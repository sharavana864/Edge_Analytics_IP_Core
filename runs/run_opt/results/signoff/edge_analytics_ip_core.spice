* NGSPICE file created from edge_analytics_ip_core.ext - technology: sky130A

* Black-box entry subcircuit for sky130_fd_sc_hd__decap_6 abstract view
.subckt sky130_fd_sc_hd__decap_6 VGND VNB VPB VPWR
.ends

* Black-box entry subcircuit for sky130_fd_sc_hd__dfrtp_1 abstract view
.subckt sky130_fd_sc_hd__dfrtp_1 CLK D RESET_B VGND VNB VPB VPWR Q
.ends

* Black-box entry subcircuit for sky130_fd_sc_hd__or3_1 abstract view
.subckt sky130_fd_sc_hd__or3_1 A B C VGND VNB VPB VPWR X
.ends

* Black-box entry subcircuit for sky130_fd_sc_hd__fill_1 abstract view
.subckt sky130_fd_sc_hd__fill_1 VGND VNB VPB VPWR
.ends

* Black-box entry subcircuit for sky130_fd_sc_hd__a221o_1 abstract view
.subckt sky130_fd_sc_hd__a221o_1 A1 A2 B1 B2 C1 VGND VNB VPB VPWR X
.ends

* Black-box entry subcircuit for sky130_fd_sc_hd__clkbuf_1 abstract view
.subckt sky130_fd_sc_hd__clkbuf_1 A VGND VNB VPB VPWR X
.ends

* Black-box entry subcircuit for sky130_fd_sc_hd__and2_2 abstract view
.subckt sky130_fd_sc_hd__and2_2 A B VGND VNB VPB VPWR X
.ends

* Black-box entry subcircuit for sky130_fd_sc_hd__dfxtp_1 abstract view
.subckt sky130_fd_sc_hd__dfxtp_1 CLK D VGND VNB VPB VPWR Q
.ends

* Black-box entry subcircuit for sky130_fd_sc_hd__fill_2 abstract view
.subckt sky130_fd_sc_hd__fill_2 VGND VNB VPB VPWR
.ends

* Black-box entry subcircuit for sky130_fd_sc_hd__mux2_1 abstract view
.subckt sky130_fd_sc_hd__mux2_1 A0 A1 S VGND VNB VPB VPWR X
.ends

* Black-box entry subcircuit for sky130_fd_sc_hd__decap_8 abstract view
.subckt sky130_fd_sc_hd__decap_8 VGND VNB VPB VPWR
.ends

* Black-box entry subcircuit for sky130_fd_sc_hd__decap_3 abstract view
.subckt sky130_fd_sc_hd__decap_3 VGND VNB VPB VPWR
.ends

* Black-box entry subcircuit for sky130_fd_sc_hd__and2_1 abstract view
.subckt sky130_fd_sc_hd__and2_1 A B VGND VNB VPB VPWR X
.ends

* Black-box entry subcircuit for sky130_fd_sc_hd__dlygate4sd3_1 abstract view
.subckt sky130_fd_sc_hd__dlygate4sd3_1 A VGND VNB VPB VPWR X
.ends

* Black-box entry subcircuit for sky130_fd_sc_hd__decap_4 abstract view
.subckt sky130_fd_sc_hd__decap_4 VGND VNB VPB VPWR
.ends

* Black-box entry subcircuit for sky130_fd_sc_hd__buf_8 abstract view
.subckt sky130_fd_sc_hd__buf_8 A VGND VNB VPB VPWR X
.ends

* Black-box entry subcircuit for sky130_ef_sc_hd__decap_12 abstract view
.subckt sky130_ef_sc_hd__decap_12 VPWR VGND VPB VNB
.ends

* Black-box entry subcircuit for sky130_fd_sc_hd__nor2_1 abstract view
.subckt sky130_fd_sc_hd__nor2_1 A B VGND VNB VPB VPWR Y
.ends

* Black-box entry subcircuit for sky130_fd_sc_hd__inv_2 abstract view
.subckt sky130_fd_sc_hd__inv_2 A VGND VNB VPB VPWR Y
.ends

* Black-box entry subcircuit for sky130_fd_sc_hd__nand2_1 abstract view
.subckt sky130_fd_sc_hd__nand2_1 A B VGND VNB VPB VPWR Y
.ends

* Black-box entry subcircuit for sky130_fd_sc_hd__tapvpwrvgnd_1 abstract view
.subckt sky130_fd_sc_hd__tapvpwrvgnd_1 VGND VPWR
.ends

* Black-box entry subcircuit for sky130_fd_sc_hd__clkbuf_4 abstract view
.subckt sky130_fd_sc_hd__clkbuf_4 A VGND VNB VPB VPWR X
.ends

* Black-box entry subcircuit for sky130_fd_sc_hd__buf_4 abstract view
.subckt sky130_fd_sc_hd__buf_4 A VGND VNB VPB VPWR X
.ends

* Black-box entry subcircuit for sky130_fd_sc_hd__a22o_1 abstract view
.subckt sky130_fd_sc_hd__a22o_1 A1 A2 B1 B2 VGND VNB VPB VPWR X
.ends

* Black-box entry subcircuit for sky130_fd_sc_hd__nor2_4 abstract view
.subckt sky130_fd_sc_hd__nor2_4 A B VGND VNB VPB VPWR Y
.ends

* Black-box entry subcircuit for sky130_fd_sc_hd__diode_2 abstract view
.subckt sky130_fd_sc_hd__diode_2 DIODE VGND VNB VPB VPWR
.ends

* Black-box entry subcircuit for sky130_fd_sc_hd__or4_1 abstract view
.subckt sky130_fd_sc_hd__or4_1 A B C D VGND VNB VPB VPWR X
.ends

* Black-box entry subcircuit for sky130_fd_sc_hd__o21a_1 abstract view
.subckt sky130_fd_sc_hd__o21a_1 A1 A2 B1 VGND VNB VPB VPWR X
.ends

* Black-box entry subcircuit for sky130_fd_sc_hd__a211o_1 abstract view
.subckt sky130_fd_sc_hd__a211o_1 A1 A2 B1 C1 VGND VNB VPB VPWR X
.ends

* Black-box entry subcircuit for sky130_fd_sc_hd__nand2_4 abstract view
.subckt sky130_fd_sc_hd__nand2_4 A B VGND VNB VPB VPWR Y
.ends

* Black-box entry subcircuit for sky130_fd_sc_hd__clkbuf_16 abstract view
.subckt sky130_fd_sc_hd__clkbuf_16 A VGND VNB VPB VPWR X
.ends

* Black-box entry subcircuit for sky130_fd_sc_hd__a2bb2o_1 abstract view
.subckt sky130_fd_sc_hd__a2bb2o_1 A1_N A2_N B1 B2 VGND VNB VPB VPWR X
.ends

* Black-box entry subcircuit for sky130_fd_sc_hd__or2_1 abstract view
.subckt sky130_fd_sc_hd__or2_1 A B VGND VNB VPB VPWR X
.ends

* Black-box entry subcircuit for sky130_fd_sc_hd__o2bb2a_1 abstract view
.subckt sky130_fd_sc_hd__o2bb2a_1 A1_N A2_N B1 B2 VGND VNB VPB VPWR X
.ends

* Black-box entry subcircuit for sky130_fd_sc_hd__a32o_1 abstract view
.subckt sky130_fd_sc_hd__a32o_1 A1 A2 A3 B1 B2 VGND VNB VPB VPWR X
.ends

* Black-box entry subcircuit for sky130_fd_sc_hd__a21oi_1 abstract view
.subckt sky130_fd_sc_hd__a21oi_1 A1 A2 B1 VGND VNB VPB VPWR Y
.ends

* Black-box entry subcircuit for sky130_fd_sc_hd__dfrtp_4 abstract view
.subckt sky130_fd_sc_hd__dfrtp_4 CLK D RESET_B VGND VNB VPB VPWR Q
.ends

* Black-box entry subcircuit for sky130_fd_sc_hd__buf_1 abstract view
.subckt sky130_fd_sc_hd__buf_1 A VGND VNB VPB VPWR X
.ends

* Black-box entry subcircuit for sky130_fd_sc_hd__and2b_2 abstract view
.subckt sky130_fd_sc_hd__and2b_2 A_N B VGND VNB VPB VPWR X
.ends

* Black-box entry subcircuit for sky130_fd_sc_hd__dlymetal6s2s_1 abstract view
.subckt sky130_fd_sc_hd__dlymetal6s2s_1 A VGND VNB VPB VPWR X
.ends

* Black-box entry subcircuit for sky130_fd_sc_hd__or2b_1 abstract view
.subckt sky130_fd_sc_hd__or2b_1 A B_N VGND VNB VPB VPWR X
.ends

* Black-box entry subcircuit for sky130_fd_sc_hd__and2b_1 abstract view
.subckt sky130_fd_sc_hd__and2b_1 A_N B VGND VNB VPB VPWR X
.ends

* Black-box entry subcircuit for sky130_fd_sc_hd__and3_1 abstract view
.subckt sky130_fd_sc_hd__and3_1 A B C VGND VNB VPB VPWR X
.ends

* Black-box entry subcircuit for sky130_fd_sc_hd__nor2_2 abstract view
.subckt sky130_fd_sc_hd__nor2_2 A B VGND VNB VPB VPWR Y
.ends

* Black-box entry subcircuit for sky130_fd_sc_hd__or3b_4 abstract view
.subckt sky130_fd_sc_hd__or3b_4 A B C_N VGND VNB VPB VPWR X
.ends

* Black-box entry subcircuit for sky130_fd_sc_hd__dfxtp_2 abstract view
.subckt sky130_fd_sc_hd__dfxtp_2 CLK D VGND VNB VPB VPWR Q
.ends

* Black-box entry subcircuit for sky130_fd_sc_hd__dfstp_1 abstract view
.subckt sky130_fd_sc_hd__dfstp_1 CLK D SET_B VGND VNB VPB VPWR Q
.ends

* Black-box entry subcircuit for sky130_fd_sc_hd__clkbuf_8 abstract view
.subckt sky130_fd_sc_hd__clkbuf_8 A VGND VNB VPB VPWR X
.ends

* Black-box entry subcircuit for sky130_fd_sc_hd__a31o_1 abstract view
.subckt sky130_fd_sc_hd__a31o_1 A1 A2 A3 B1 VGND VNB VPB VPWR X
.ends

* Black-box entry subcircuit for sky130_fd_sc_hd__and3_2 abstract view
.subckt sky130_fd_sc_hd__and3_2 A B C VGND VNB VPB VPWR X
.ends

* Black-box entry subcircuit for sky130_fd_sc_hd__buf_2 abstract view
.subckt sky130_fd_sc_hd__buf_2 A VGND VNB VPB VPWR X
.ends

* Black-box entry subcircuit for sky130_fd_sc_hd__clkbuf_2 abstract view
.subckt sky130_fd_sc_hd__clkbuf_2 A VGND VNB VPB VPWR X
.ends

* Black-box entry subcircuit for sky130_fd_sc_hd__a2111o_1 abstract view
.subckt sky130_fd_sc_hd__a2111o_1 A1 A2 B1 C1 D1 VGND VNB VPB VPWR X
.ends

* Black-box entry subcircuit for sky130_fd_sc_hd__o21ai_1 abstract view
.subckt sky130_fd_sc_hd__o21ai_1 A1 A2 B1 VGND VNB VPB VPWR Y
.ends

* Black-box entry subcircuit for sky130_fd_sc_hd__and4_2 abstract view
.subckt sky130_fd_sc_hd__and4_2 A B C D VGND VNB VPB VPWR X
.ends

* Black-box entry subcircuit for sky130_fd_sc_hd__or4_2 abstract view
.subckt sky130_fd_sc_hd__or4_2 A B C D VGND VNB VPB VPWR X
.ends

* Black-box entry subcircuit for sky130_fd_sc_hd__xor2_1 abstract view
.subckt sky130_fd_sc_hd__xor2_1 A B VGND VNB VPB VPWR X
.ends

* Black-box entry subcircuit for sky130_fd_sc_hd__o22a_1 abstract view
.subckt sky130_fd_sc_hd__o22a_1 A1 A2 B1 B2 VGND VNB VPB VPWR X
.ends

* Black-box entry subcircuit for sky130_fd_sc_hd__nor3_1 abstract view
.subckt sky130_fd_sc_hd__nor3_1 A B C VGND VNB VPB VPWR Y
.ends

* Black-box entry subcircuit for sky130_fd_sc_hd__nand2_2 abstract view
.subckt sky130_fd_sc_hd__nand2_2 A B VGND VNB VPB VPWR Y
.ends

* Black-box entry subcircuit for sky130_fd_sc_hd__buf_6 abstract view
.subckt sky130_fd_sc_hd__buf_6 A VGND VNB VPB VPWR X
.ends

* Black-box entry subcircuit for sky130_fd_sc_hd__and4b_1 abstract view
.subckt sky130_fd_sc_hd__and4b_1 A_N B C D VGND VNB VPB VPWR X
.ends

* Black-box entry subcircuit for sky130_fd_sc_hd__xnor2_1 abstract view
.subckt sky130_fd_sc_hd__xnor2_1 A B VGND VNB VPB VPWR Y
.ends

* Black-box entry subcircuit for sky130_fd_sc_hd__o221a_1 abstract view
.subckt sky130_fd_sc_hd__o221a_1 A1 A2 B1 B2 C1 VGND VNB VPB VPWR X
.ends

* Black-box entry subcircuit for sky130_fd_sc_hd__o31a_1 abstract view
.subckt sky130_fd_sc_hd__o31a_1 A1 A2 A3 B1 VGND VNB VPB VPWR X
.ends

* Black-box entry subcircuit for sky130_fd_sc_hd__dfrtp_2 abstract view
.subckt sky130_fd_sc_hd__dfrtp_2 CLK D RESET_B VGND VNB VPB VPWR Q
.ends

* Black-box entry subcircuit for sky130_fd_sc_hd__and3_4 abstract view
.subckt sky130_fd_sc_hd__and3_4 A B C VGND VNB VPB VPWR X
.ends

* Black-box entry subcircuit for sky130_fd_sc_hd__a21bo_1 abstract view
.subckt sky130_fd_sc_hd__a21bo_1 A1 A2 B1_N VGND VNB VPB VPWR X
.ends

* Black-box entry subcircuit for sky130_fd_sc_hd__o21ba_1 abstract view
.subckt sky130_fd_sc_hd__o21ba_1 A1 A2 B1_N VGND VNB VPB VPWR X
.ends

* Black-box entry subcircuit for sky130_fd_sc_hd__or4b_4 abstract view
.subckt sky130_fd_sc_hd__or4b_4 A B C D_N VGND VNB VPB VPWR X
.ends

* Black-box entry subcircuit for sky130_fd_sc_hd__nand4_4 abstract view
.subckt sky130_fd_sc_hd__nand4_4 A B C D VGND VNB VPB VPWR Y
.ends

* Black-box entry subcircuit for sky130_fd_sc_hd__and4_4 abstract view
.subckt sky130_fd_sc_hd__and4_4 A B C D VGND VNB VPB VPWR X
.ends

* Black-box entry subcircuit for sky130_fd_sc_hd__or4_4 abstract view
.subckt sky130_fd_sc_hd__or4_4 A B C D VGND VNB VPB VPWR X
.ends

* Black-box entry subcircuit for sky130_fd_sc_hd__nand2b_4 abstract view
.subckt sky130_fd_sc_hd__nand2b_4 A_N B VGND VNB VPB VPWR Y
.ends

* Black-box entry subcircuit for sky130_fd_sc_hd__or2_2 abstract view
.subckt sky130_fd_sc_hd__or2_2 A B VGND VNB VPB VPWR X
.ends

* Black-box entry subcircuit for sky130_fd_sc_hd__or3b_1 abstract view
.subckt sky130_fd_sc_hd__or3b_1 A B C_N VGND VNB VPB VPWR X
.ends

* Black-box entry subcircuit for sky130_fd_sc_hd__clkinv_4 abstract view
.subckt sky130_fd_sc_hd__clkinv_4 A VGND VNB VPB VPWR Y
.ends

* Black-box entry subcircuit for sky130_fd_sc_hd__and3b_1 abstract view
.subckt sky130_fd_sc_hd__and3b_1 A_N B C VGND VNB VPB VPWR X
.ends

* Black-box entry subcircuit for sky130_fd_sc_hd__nor4_2 abstract view
.subckt sky130_fd_sc_hd__nor4_2 A B C D VGND VNB VPB VPWR Y
.ends

* Black-box entry subcircuit for sky130_fd_sc_hd__and2_4 abstract view
.subckt sky130_fd_sc_hd__and2_4 A B VGND VNB VPB VPWR X
.ends

* Black-box entry subcircuit for sky130_fd_sc_hd__or2b_2 abstract view
.subckt sky130_fd_sc_hd__or2b_2 A B_N VGND VNB VPB VPWR X
.ends

* Black-box entry subcircuit for sky130_fd_sc_hd__a211oi_2 abstract view
.subckt sky130_fd_sc_hd__a211oi_2 A1 A2 B1 C1 VGND VNB VPB VPWR Y
.ends

* Black-box entry subcircuit for sky130_fd_sc_hd__a21o_1 abstract view
.subckt sky130_fd_sc_hd__a21o_1 A1 A2 B1 VGND VNB VPB VPWR X
.ends

* Black-box entry subcircuit for sky130_fd_sc_hd__nand3_1 abstract view
.subckt sky130_fd_sc_hd__nand3_1 A B C VGND VNB VPB VPWR Y
.ends

* Black-box entry subcircuit for sky130_fd_sc_hd__and3b_4 abstract view
.subckt sky130_fd_sc_hd__and3b_4 A_N B C VGND VNB VPB VPWR X
.ends

* Black-box entry subcircuit for sky130_fd_sc_hd__and4bb_1 abstract view
.subckt sky130_fd_sc_hd__and4bb_1 A_N B_N C D VGND VNB VPB VPWR X
.ends

* Black-box entry subcircuit for sky130_fd_sc_hd__and4_1 abstract view
.subckt sky130_fd_sc_hd__and4_1 A B C D VGND VNB VPB VPWR X
.ends

* Black-box entry subcircuit for sky130_fd_sc_hd__a31oi_1 abstract view
.subckt sky130_fd_sc_hd__a31oi_1 A1 A2 A3 B1 VGND VNB VPB VPWR Y
.ends

* Black-box entry subcircuit for sky130_fd_sc_hd__nor4_1 abstract view
.subckt sky130_fd_sc_hd__nor4_1 A B C D VGND VNB VPB VPWR Y
.ends

* Black-box entry subcircuit for sky130_fd_sc_hd__nor3b_1 abstract view
.subckt sky130_fd_sc_hd__nor3b_1 A B C_N VGND VNB VPB VPWR Y
.ends

* Black-box entry subcircuit for sky130_fd_sc_hd__dfxtp_4 abstract view
.subckt sky130_fd_sc_hd__dfxtp_4 CLK D VGND VNB VPB VPWR Q
.ends

* Black-box entry subcircuit for sky130_fd_sc_hd__nor3_4 abstract view
.subckt sky130_fd_sc_hd__nor3_4 A B C VGND VNB VPB VPWR Y
.ends

* Black-box entry subcircuit for sky130_fd_sc_hd__or3_4 abstract view
.subckt sky130_fd_sc_hd__or3_4 A B C VGND VNB VPB VPWR X
.ends

* Black-box entry subcircuit for sky130_fd_sc_hd__a41o_1 abstract view
.subckt sky130_fd_sc_hd__a41o_1 A1 A2 A3 A4 B1 VGND VNB VPB VPWR X
.ends

* Black-box entry subcircuit for sky130_fd_sc_hd__or4bb_4 abstract view
.subckt sky130_fd_sc_hd__or4bb_4 A B C_N D_N VGND VNB VPB VPWR X
.ends

* Black-box entry subcircuit for sky130_fd_sc_hd__nor3_2 abstract view
.subckt sky130_fd_sc_hd__nor3_2 A B C VGND VNB VPB VPWR Y
.ends

* Black-box entry subcircuit for sky130_fd_sc_hd__o211ai_1 abstract view
.subckt sky130_fd_sc_hd__o211ai_1 A1 A2 B1 C1 VGND VNB VPB VPWR Y
.ends

* Black-box entry subcircuit for sky130_fd_sc_hd__and4bb_4 abstract view
.subckt sky130_fd_sc_hd__and4bb_4 A_N B_N C D VGND VNB VPB VPWR X
.ends

.subckt edge_analytics_ip_core VGND VPWR cfg_addr[0] cfg_addr[1] cfg_addr[2] cfg_addr[3]
+ cfg_addr[4] cfg_addr[5] cfg_addr[6] cfg_addr[7] cfg_clk cfg_rdata[0] cfg_rdata[10]
+ cfg_rdata[11] cfg_rdata[12] cfg_rdata[13] cfg_rdata[14] cfg_rdata[15] cfg_rdata[16]
+ cfg_rdata[17] cfg_rdata[18] cfg_rdata[19] cfg_rdata[1] cfg_rdata[20] cfg_rdata[21]
+ cfg_rdata[22] cfg_rdata[23] cfg_rdata[24] cfg_rdata[25] cfg_rdata[26] cfg_rdata[27]
+ cfg_rdata[28] cfg_rdata[29] cfg_rdata[2] cfg_rdata[30] cfg_rdata[31] cfg_rdata[3]
+ cfg_rdata[4] cfg_rdata[5] cfg_rdata[6] cfg_rdata[7] cfg_rdata[8] cfg_rdata[9] cfg_read
+ cfg_rst_n cfg_wdata[0] cfg_wdata[10] cfg_wdata[11] cfg_wdata[12] cfg_wdata[13] cfg_wdata[14]
+ cfg_wdata[15] cfg_wdata[16] cfg_wdata[17] cfg_wdata[18] cfg_wdata[19] cfg_wdata[1]
+ cfg_wdata[20] cfg_wdata[21] cfg_wdata[22] cfg_wdata[23] cfg_wdata[24] cfg_wdata[25]
+ cfg_wdata[26] cfg_wdata[27] cfg_wdata[28] cfg_wdata[29] cfg_wdata[2] cfg_wdata[30]
+ cfg_wdata[31] cfg_wdata[3] cfg_wdata[4] cfg_wdata[5] cfg_wdata[6] cfg_wdata[7] cfg_wdata[8]
+ cfg_wdata[9] cfg_write clk data_valid_out irq_alert processed_data_out[0] processed_data_out[10]
+ processed_data_out[11] processed_data_out[12] processed_data_out[13] processed_data_out[14]
+ processed_data_out[15] processed_data_out[1] processed_data_out[2] processed_data_out[3]
+ processed_data_out[4] processed_data_out[5] processed_data_out[6] processed_data_out[7]
+ processed_data_out[8] processed_data_out[9] rst_n sensor_data_in[0] sensor_data_in[10]
+ sensor_data_in[11] sensor_data_in[12] sensor_data_in[13] sensor_data_in[14] sensor_data_in[15]
+ sensor_data_in[16] sensor_data_in[17] sensor_data_in[18] sensor_data_in[19] sensor_data_in[1]
+ sensor_data_in[20] sensor_data_in[21] sensor_data_in[22] sensor_data_in[23] sensor_data_in[24]
+ sensor_data_in[25] sensor_data_in[26] sensor_data_in[27] sensor_data_in[28] sensor_data_in[29]
+ sensor_data_in[2] sensor_data_in[30] sensor_data_in[31] sensor_data_in[32] sensor_data_in[33]
+ sensor_data_in[34] sensor_data_in[35] sensor_data_in[36] sensor_data_in[37] sensor_data_in[38]
+ sensor_data_in[39] sensor_data_in[3] sensor_data_in[40] sensor_data_in[41] sensor_data_in[42]
+ sensor_data_in[43] sensor_data_in[44] sensor_data_in[45] sensor_data_in[46] sensor_data_in[47]
+ sensor_data_in[48] sensor_data_in[49] sensor_data_in[4] sensor_data_in[50] sensor_data_in[51]
+ sensor_data_in[52] sensor_data_in[53] sensor_data_in[54] sensor_data_in[55] sensor_data_in[56]
+ sensor_data_in[57] sensor_data_in[58] sensor_data_in[59] sensor_data_in[5] sensor_data_in[60]
+ sensor_data_in[61] sensor_data_in[62] sensor_data_in[63] sensor_data_in[6] sensor_data_in[7]
+ sensor_data_in[8] sensor_data_in[9] sensor_valid[0] sensor_valid[1] sensor_valid[2]
+ sensor_valid[3]
XFILLER_0_94_77 VGND VGND VPWR VPWR sky130_fd_sc_hd__decap_6
X_7963_ clknet_leaf_22_clk _0053_ net193 VGND VGND VPWR VPWR u_input_buffer.data_in\[3\]
+ sky130_fd_sc_hd__dfrtp_1
X_6914_ _3145_ _3154_ _3163_ VGND VGND VPWR VPWR _3164_ sky130_fd_sc_hd__or3_1
XFILLER_0_49_303 VGND VGND VPWR VPWR sky130_fd_sc_hd__fill_1
X_7894_ clknet_leaf_82_clk net231 net188 VGND VGND VPWR VPWR u_register_bank.status_flags\[14\]
+ sky130_fd_sc_hd__dfrtp_1
X_6845_ u_input_buffer.fifo_mem\[29\]\[1\] _2939_ _2941_ u_input_buffer.fifo_mem\[13\]\[1\]
+ _3095_ VGND VGND VPWR VPWR _3096_ sky130_fd_sc_hd__a221o_1
X_3988_ _1344_ VGND VGND VPWR VPWR _0021_ sky130_fd_sc_hd__clkbuf_1
X_6776_ _2910_ _2956_ VGND VGND VPWR VPWR _3028_ sky130_fd_sc_hd__and2_2
X_5727_ _2393_ VGND VGND VPWR VPWR _0711_ sky130_fd_sc_hd__clkbuf_1
X_8515_ clknet_leaf_69_clk _0604_ VGND VGND VPWR VPWR u_input_buffer.fifo_mem\[31\]\[9\]
+ sky130_fd_sc_hd__dfxtp_1
X_8446_ clknet_leaf_28_clk _0535_ VGND VGND VPWR VPWR u_input_buffer.fifo_mem\[35\]\[4\]
+ sky130_fd_sc_hd__dfxtp_1
XFILLER_0_115_474 VGND VGND VPWR VPWR sky130_fd_sc_hd__fill_2
X_5658_ net591 _2252_ _2352_ VGND VGND VPWR VPWR _2357_ sky130_fd_sc_hd__mux2_1
X_5589_ net672 _2252_ _2315_ VGND VGND VPWR VPWR _2320_ sky130_fd_sc_hd__mux2_1
XFILLER_0_60_589 VGND VGND VPWR VPWR sky130_fd_sc_hd__decap_8
XFILLER_0_4_193 VGND VGND VPWR VPWR sky130_fd_sc_hd__decap_3
X_4609_ _1634_ _1775_ VGND VGND VPWR VPWR _1776_ sky130_fd_sc_hd__and2_1
X_8377_ clknet_leaf_93_clk _0466_ VGND VGND VPWR VPWR u_input_buffer.fifo_mem\[40\]\[15\]
+ sky130_fd_sc_hd__dfxtp_1
Xhold362 u_input_buffer.fifo_mem\[8\]\[1\] VGND VGND VPWR VPWR net574 sky130_fd_sc_hd__dlygate4sd3_1
Xhold351 u_input_buffer.fifo_mem\[44\]\[13\] VGND VGND VPWR VPWR net563 sky130_fd_sc_hd__dlygate4sd3_1
XFILLER_0_13_483 VGND VGND VPWR VPWR sky130_fd_sc_hd__decap_8
X_7328_ u_input_buffer.fifo_mem\[27\]\[13\] _3012_ _3014_ u_input_buffer.fifo_mem\[59\]\[13\]
+ _3566_ VGND VGND VPWR VPWR _3567_ sky130_fd_sc_hd__a221o_1
XFILLER_0_40_280 VGND VGND VPWR VPWR sky130_fd_sc_hd__fill_1
Xhold340 u_input_buffer.fifo_mem\[24\]\[13\] VGND VGND VPWR VPWR net552 sky130_fd_sc_hd__dlygate4sd3_1
Xhold395 u_input_buffer.fifo_mem\[8\]\[6\] VGND VGND VPWR VPWR net607 sky130_fd_sc_hd__dlygate4sd3_1
Xhold384 u_input_buffer.fifo_mem\[53\]\[14\] VGND VGND VPWR VPWR net596 sky130_fd_sc_hd__dlygate4sd3_1
Xhold373 u_input_buffer.fifo_mem\[50\]\[13\] VGND VGND VPWR VPWR net585 sky130_fd_sc_hd__dlygate4sd3_1
X_7259_ u_input_buffer.fifo_mem\[10\]\[11\] _3055_ _3057_ u_input_buffer.fifo_mem\[44\]\[11\]
+ _3499_ VGND VGND VPWR VPWR _3500_ sky130_fd_sc_hd__a221o_1
Xhold1040 u_input_buffer.fifo_mem\[61\]\[2\] VGND VGND VPWR VPWR net1252 sky130_fd_sc_hd__dlygate4sd3_1
Xhold1051 u_input_buffer.fifo_mem\[60\]\[14\] VGND VGND VPWR VPWR net1263 sky130_fd_sc_hd__dlygate4sd3_1
Xhold1062 u_sensor_interface.sensor_array\[0\]\[4\] VGND VGND VPWR VPWR net1274 sky130_fd_sc_hd__dlygate4sd3_1
Xhold1084 u_input_buffer.fifo_mem\[21\]\[13\] VGND VGND VPWR VPWR net1296 sky130_fd_sc_hd__dlygate4sd3_1
Xhold1073 u_input_buffer.fifo_mem\[25\]\[3\] VGND VGND VPWR VPWR net1285 sky130_fd_sc_hd__dlygate4sd3_1
Xhold1095 u_input_buffer.fifo_mem\[33\]\[6\] VGND VGND VPWR VPWR net1307 sky130_fd_sc_hd__dlygate4sd3_1
XFILLER_0_95_475 VGND VGND VPWR VPWR sky130_fd_sc_hd__decap_3
XFILLER_0_82_114 VGND VGND VPWR VPWR sky130_fd_sc_hd__fill_1
XFILLER_0_91_670 VGND VGND VPWR VPWR sky130_fd_sc_hd__fill_2
XFILLER_0_63_383 VGND VGND VPWR VPWR sky130_fd_sc_hd__fill_1
XFILLER_0_3_609 VGND VGND VPWR VPWR sky130_fd_sc_hd__decap_6
XFILLER_0_48_48 VGND VGND VPWR VPWR sky130_fd_sc_hd__fill_1
XFILLER_0_3_39 VGND VGND VPWR VPWR sky130_fd_sc_hd__decap_3
XFILLER_0_98_291 VGND VGND VPWR VPWR sky130_fd_sc_hd__fill_1
X_4960_ net1099 _1734_ _1951_ VGND VGND VPWR VPWR _1968_ sky130_fd_sc_hd__mux2_1
XFILLER_0_86_475 VGND VGND VPWR VPWR sky130_fd_sc_hd__fill_1
XFILLER_0_59_667 VGND VGND VPWR VPWR sky130_fd_sc_hd__decap_4
X_4891_ _1929_ VGND VGND VPWR VPWR _1930_ sky130_fd_sc_hd__buf_8
XFILLER_0_46_306 VGND VGND VPWR VPWR sky130_fd_sc_hd__fill_2
XFILLER_0_104_53 VPWR VGND VPWR VGND sky130_ef_sc_hd__decap_12
XFILLER_0_86_486 VGND VGND VPWR VPWR sky130_fd_sc_hd__fill_1
XFILLER_0_13_51 VGND VGND VPWR VPWR sky130_fd_sc_hd__decap_4
X_6630_ net261 _1595_ VGND VGND VPWR VPWR _2888_ sky130_fd_sc_hd__nor2_1
XFILLER_0_104_97 VGND VGND VPWR VPWR sky130_fd_sc_hd__fill_2
X_6561_ net262 _1390_ _2843_ VGND VGND VPWR VPWR _2846_ sky130_fd_sc_hd__mux2_1
XFILLER_0_73_169 VGND VGND VPWR VPWR sky130_fd_sc_hd__decap_4
X_8300_ clknet_leaf_50_clk _0389_ VGND VGND VPWR VPWR u_input_buffer.fifo_mem\[44\]\[2\]
+ sky130_fd_sc_hd__dfxtp_1
X_5512_ _2278_ VGND VGND VPWR VPWR _0611_ sky130_fd_sc_hd__clkbuf_1
XFILLER_0_89_55 VGND VGND VPWR VPWR sky130_fd_sc_hd__fill_1
X_6492_ _2809_ VGND VGND VPWR VPWR _1060_ sky130_fd_sc_hd__clkbuf_1
XFILLER_0_112_411 VGND VGND VPWR VPWR sky130_fd_sc_hd__fill_1
X_5443_ net755 _2008_ _2223_ VGND VGND VPWR VPWR _2233_ sky130_fd_sc_hd__mux2_1
X_8231_ clknet_leaf_1_clk _0320_ VGND VGND VPWR VPWR u_input_buffer.fifo_mem\[49\]\[13\]
+ sky130_fd_sc_hd__dfxtp_1
X_5374_ _2196_ VGND VGND VPWR VPWR _0555_ sky130_fd_sc_hd__clkbuf_1
X_8162_ clknet_leaf_8_clk _0251_ VGND VGND VPWR VPWR u_input_buffer.fifo_mem\[53\]\[8\]
+ sky130_fd_sc_hd__dfxtp_1
X_4325_ _1603_ VGND VGND VPWR VPWR _0099_ sky130_fd_sc_hd__clkbuf_1
X_7113_ u_input_buffer.fifo_mem\[33\]\[8\] _2898_ _2904_ u_input_buffer.fifo_mem\[61\]\[8\]
+ _3356_ VGND VGND VPWR VPWR _3357_ sky130_fd_sc_hd__a221o_1
XFILLER_0_10_464 VGND VGND VPWR VPWR sky130_fd_sc_hd__decap_4
X_8093_ clknet_leaf_3_clk _0182_ VGND VGND VPWR VPWR u_input_buffer.fifo_mem\[57\]\[3\]
+ sky130_fd_sc_hd__dfxtp_1
X_7044_ u_input_buffer.fifo_mem\[16\]\[6\] _2971_ _2973_ u_input_buffer.fifo_mem\[49\]\[6\]
+ _2975_ VGND VGND VPWR VPWR _3290_ sky130_fd_sc_hd__a221o_1
XFILLER_0_10_497 VPWR VGND VPWR VGND sky130_ef_sc_hd__decap_12
X_4256_ u_analytics_engine.data_in\[13\] VGND VGND VPWR VPWR _1536_ sky130_fd_sc_hd__inv_2
X_4187_ u_sample_counter.sample_count\[9\] _1487_ VGND VGND VPWR VPWR _1490_ sky130_fd_sc_hd__nand2_1
X_8995_ clknet_leaf_6_clk _1084_ VGND VGND VPWR VPWR u_input_buffer.fifo_mem\[1\]\[9\]
+ sky130_fd_sc_hd__dfxtp_1
X_7946_ clknet_leaf_27_clk _0036_ VGND VGND VPWR VPWR u_sensor_interface.sensor_array\[0\]\[2\]
+ sky130_fd_sc_hd__dfxtp_1
XTAP_1118 VGND VPWR sky130_fd_sc_hd__tapvpwrvgnd_1
XTAP_1129 VGND VPWR sky130_fd_sc_hd__tapvpwrvgnd_1
XTAP_1107 VGND VPWR sky130_fd_sc_hd__tapvpwrvgnd_1
X_7877_ _3938_ VGND VGND VPWR VPWR _1316_ sky130_fd_sc_hd__clkbuf_1
XFILLER_0_49_166 VGND VGND VPWR VPWR sky130_fd_sc_hd__fill_2
X_6828_ _3079_ VGND VGND VPWR VPWR _3080_ sky130_fd_sc_hd__clkbuf_4
XFILLER_0_107_205 VGND VGND VPWR VPWR sky130_fd_sc_hd__decap_6
XFILLER_0_18_531 VGND VGND VPWR VPWR sky130_fd_sc_hd__fill_1
X_6759_ u_input_buffer.fifo_mem\[8\]\[0\] _3004_ _3006_ u_input_buffer.fifo_mem\[19\]\[0\]
+ _3010_ VGND VGND VPWR VPWR _3011_ sky130_fd_sc_hd__a221o_1
X_8429_ clknet_leaf_29_clk _0518_ VGND VGND VPWR VPWR u_input_buffer.fifo_mem\[36\]\[3\]
+ sky130_fd_sc_hd__dfxtp_1
Xhold170 u_input_buffer.fifo_mem\[48\]\[3\] VGND VGND VPWR VPWR net382 sky130_fd_sc_hd__dlygate4sd3_1
Xhold192 u_input_buffer.fifo_mem\[14\]\[8\] VGND VGND VPWR VPWR net404 sky130_fd_sc_hd__dlygate4sd3_1
Xhold181 u_input_buffer.fifo_mem\[12\]\[4\] VGND VGND VPWR VPWR net393 sky130_fd_sc_hd__dlygate4sd3_1
XFILLER_0_18_29 VPWR VGND VPWR VGND sky130_ef_sc_hd__decap_12
XFILLER_0_87_239 VGND VGND VPWR VPWR sky130_fd_sc_hd__fill_1
XTAP_1641 VGND VPWR sky130_fd_sc_hd__tapvpwrvgnd_1
XTAP_1630 VGND VPWR sky130_fd_sc_hd__tapvpwrvgnd_1
XFILLER_0_55_169 VGND VGND VPWR VPWR sky130_fd_sc_hd__fill_1
XFILLER_0_70_139 VGND VGND VPWR VPWR sky130_fd_sc_hd__fill_1
XFILLER_0_36_394 VGND VGND VPWR VPWR sky130_fd_sc_hd__decap_4
XFILLER_0_59_47 VGND VGND VPWR VPWR sky130_fd_sc_hd__fill_1
X_4110_ _1429_ u_sensor_interface.sensor_array\[3\]\[8\] _1381_ VGND VGND VPWR VPWR
+ _1430_ sky130_fd_sc_hd__mux2_1
X_5090_ net420 _1996_ _2042_ VGND VGND VPWR VPWR _2046_ sky130_fd_sc_hd__mux2_1
X_4041_ _1372_ VGND VGND VPWR VPWR _0046_ sky130_fd_sc_hd__clkbuf_1
X_8780_ clknet_leaf_27_clk _0869_ VGND VGND VPWR VPWR u_input_buffer.fifo_mem\[14\]\[2\]
+ sky130_fd_sc_hd__dfxtp_1
X_5992_ _2541_ VGND VGND VPWR VPWR _0828_ sky130_fd_sc_hd__clkbuf_1
X_7800_ net149 u_analytics_engine.data_in\[10\] _3893_ VGND VGND VPWR VPWR _3898_
+ sky130_fd_sc_hd__mux2_1
XFILLER_0_115_41 VGND VGND VPWR VPWR sky130_fd_sc_hd__decap_4
X_4943_ _1959_ VGND VGND VPWR VPWR _0361_ sky130_fd_sc_hd__clkbuf_1
X_7731_ u_register_bank.window_cfg\[20\] _3847_ _3848_ u_register_bank.threshold_cfg\[20\]
+ _3850_ VGND VGND VPWR VPWR _3851_ sky130_fd_sc_hd__a221o_1
X_7662_ u_register_bank.window_cfg\[5\] _3772_ _3773_ u_analytics_engine.threshold\[5\]
+ _3796_ VGND VGND VPWR VPWR _3797_ sky130_fd_sc_hd__a221o_1
XFILLER_0_74_445 VPWR VGND VPWR VGND sky130_ef_sc_hd__decap_12
X_4874_ net445 _1720_ _1912_ VGND VGND VPWR VPWR _1921_ sky130_fd_sc_hd__mux2_1
X_6613_ _2874_ _2875_ VGND VGND VPWR VPWR _1115_ sky130_fd_sc_hd__nor2_1
XFILLER_0_62_629 VGND VGND VPWR VPWR sky130_fd_sc_hd__fill_1
X_7593_ net16 u_analytics_engine.threshold\[13\] _3748_ VGND VGND VPWR VPWR _3752_
+ sky130_fd_sc_hd__mux2_1
XFILLER_0_34_309 VGND VGND VPWR VPWR sky130_fd_sc_hd__decap_3
X_6544_ _2836_ VGND VGND VPWR VPWR _1085_ sky130_fd_sc_hd__clkbuf_1
X_6475_ net1144 _1438_ _2788_ VGND VGND VPWR VPWR _2800_ sky130_fd_sc_hd__mux2_1
X_5426_ _2224_ VGND VGND VPWR VPWR _0579_ sky130_fd_sc_hd__clkbuf_1
XFILLER_0_71_3 VGND VGND VPWR VPWR sky130_fd_sc_hd__fill_1
X_8214_ clknet_leaf_9_clk _0303_ VGND VGND VPWR VPWR u_input_buffer.fifo_mem\[50\]\[12\]
+ sky130_fd_sc_hd__dfxtp_1
X_9194_ clknet_leaf_82_clk _1282_ net187 VGND VGND VPWR VPWR net151 sky130_fd_sc_hd__dfrtp_1
X_8145_ clknet_leaf_35_clk _0234_ VGND VGND VPWR VPWR u_input_buffer.fifo_mem\[54\]\[7\]
+ sky130_fd_sc_hd__dfxtp_1
X_5357_ net886 _1988_ _2187_ VGND VGND VPWR VPWR _2188_ sky130_fd_sc_hd__mux2_1
XFILLER_0_100_469 VGND VGND VPWR VPWR sky130_fd_sc_hd__decap_4
X_5288_ _2150_ VGND VGND VPWR VPWR _2151_ sky130_fd_sc_hd__buf_4
X_8076_ clknet_leaf_59_clk _0165_ VGND VGND VPWR VPWR u_input_buffer.fifo_mem\[58\]\[2\]
+ sky130_fd_sc_hd__dfxtp_1
X_4308_ _1587_ VGND VGND VPWR VPWR _0098_ sky130_fd_sc_hd__clkbuf_1
X_7027_ u_input_buffer.fifo_mem\[26\]\[5\] _3066_ _3068_ u_input_buffer.fifo_mem\[62\]\[5\]
+ _3273_ VGND VGND VPWR VPWR _3274_ sky130_fd_sc_hd__a221o_1
X_4239_ net228 _1522_ VGND VGND VPWR VPWR _1525_ sky130_fd_sc_hd__nor2_1
XFILLER_0_97_559 VGND VGND VPWR VPWR sky130_fd_sc_hd__fill_1
X_8978_ clknet_leaf_16_clk _1067_ VGND VGND VPWR VPWR u_input_buffer.fifo_mem\[2\]\[8\]
+ sky130_fd_sc_hd__dfxtp_1
X_7929_ clknet_leaf_33_clk _0019_ VGND VGND VPWR VPWR u_sensor_interface.sensor_array\[1\]\[1\]
+ sky130_fd_sc_hd__dfxtp_1
XFILLER_0_92_253 VGND VGND VPWR VPWR sky130_fd_sc_hd__fill_1
XFILLER_0_53_629 VGND VGND VPWR VPWR sky130_fd_sc_hd__decap_4
XFILLER_0_45_180 VGND VGND VPWR VPWR sky130_fd_sc_hd__fill_1
XFILLER_0_103_252 VGND VGND VPWR VPWR sky130_fd_sc_hd__fill_2
XFILLER_0_60_194 VGND VGND VPWR VPWR sky130_fd_sc_hd__fill_2
XFILLER_0_61_15 VGND VGND VPWR VPWR sky130_fd_sc_hd__decap_4
XFILLER_0_0_29 VGND VGND VPWR VPWR sky130_fd_sc_hd__decap_6
XTAP_1460 VGND VPWR sky130_fd_sc_hd__tapvpwrvgnd_1
XFILLER_0_96_570 VGND VGND VPWR VPWR sky130_fd_sc_hd__decap_4
XFILLER_0_8_509 VPWR VGND VPWR VGND sky130_ef_sc_hd__decap_12
XTAP_1493 VGND VPWR sky130_fd_sc_hd__tapvpwrvgnd_1
XTAP_1482 VGND VPWR sky130_fd_sc_hd__tapvpwrvgnd_1
XTAP_1471 VGND VPWR sky130_fd_sc_hd__tapvpwrvgnd_1
XFILLER_0_16_309 VGND VGND VPWR VPWR sky130_fd_sc_hd__decap_4
X_4590_ _1765_ VGND VGND VPWR VPWR _0202_ sky130_fd_sc_hd__clkbuf_1
XFILLER_0_9_27 VPWR VGND VPWR VGND sky130_ef_sc_hd__decap_12
XFILLER_0_37_681 VGND VGND VPWR VPWR sky130_fd_sc_hd__fill_2
XFILLER_0_3_225 VGND VGND VPWR VPWR sky130_fd_sc_hd__fill_2
Xhold917 u_input_buffer.fifo_mem\[46\]\[6\] VGND VGND VPWR VPWR net1129 sky130_fd_sc_hd__dlygate4sd3_1
Xhold928 u_input_buffer.fifo_mem\[48\]\[7\] VGND VGND VPWR VPWR net1140 sky130_fd_sc_hd__dlygate4sd3_1
XFILLER_0_10_41 VPWR VGND VPWR VGND sky130_ef_sc_hd__decap_12
Xhold906 u_input_buffer.fifo_mem\[32\]\[15\] VGND VGND VPWR VPWR net1118 sky130_fd_sc_hd__dlygate4sd3_1
Xhold939 u_input_buffer.fifo_mem\[18\]\[3\] VGND VGND VPWR VPWR net1151 sky130_fd_sc_hd__dlygate4sd3_1
X_6260_ _1612_ net1244 _2680_ VGND VGND VPWR VPWR _2686_ sky130_fd_sc_hd__mux2_1
XFILLER_0_10_85 VGND VGND VPWR VPWR sky130_fd_sc_hd__fill_1
X_6191_ _2649_ VGND VGND VPWR VPWR _0919_ sky130_fd_sc_hd__clkbuf_1
X_5211_ net391 _2014_ _2096_ VGND VGND VPWR VPWR _2110_ sky130_fd_sc_hd__mux2_1
XFILLER_0_86_89 VGND VGND VPWR VPWR sky130_fd_sc_hd__fill_1
X_5142_ _1451_ net1009 _2059_ VGND VGND VPWR VPWR _2073_ sky130_fd_sc_hd__mux2_1
X_5073_ _2036_ VGND VGND VPWR VPWR _0414_ sky130_fd_sc_hd__clkbuf_1
X_4024_ _1363_ VGND VGND VPWR VPWR _0038_ sky130_fd_sc_hd__clkbuf_1
X_8901_ clknet_leaf_81_clk _0990_ VGND VGND VPWR VPWR u_input_buffer.fifo_mem\[7\]\[11\]
+ sky130_fd_sc_hd__dfxtp_1
X_8832_ clknet_leaf_37_clk _0921_ VGND VGND VPWR VPWR u_input_buffer.fifo_mem\[11\]\[6\]
+ sky130_fd_sc_hd__dfxtp_1
X_8763_ clknet_leaf_33_clk _0852_ VGND VGND VPWR VPWR u_input_buffer.fifo_mem\[15\]\[1\]
+ sky130_fd_sc_hd__dfxtp_1
XFILLER_0_59_261 VGND VGND VPWR VPWR sky130_fd_sc_hd__fill_1
X_5975_ _1604_ net1007 _2531_ VGND VGND VPWR VPWR _2533_ sky130_fd_sc_hd__mux2_1
X_8694_ clknet_leaf_90_clk _0783_ VGND VGND VPWR VPWR u_input_buffer.fifo_mem\[20\]\[12\]
+ sky130_fd_sc_hd__dfxtp_1
X_7714_ u_register_bank.status_flags\[17\] _3814_ _3808_ u_register_bank.sensor_enable\[17\]
+ VGND VGND VPWR VPWR _3837_ sky130_fd_sc_hd__a22o_1
X_4926_ net425 _1734_ _1933_ VGND VGND VPWR VPWR _1950_ sky130_fd_sc_hd__mux2_1
XFILLER_0_47_434 VGND VGND VPWR VPWR sky130_fd_sc_hd__fill_2
X_7645_ u_register_bank.status_flags\[1\] _3775_ _3778_ u_register_bank.sensor_enable\[1\]
+ VGND VGND VPWR VPWR _3784_ sky130_fd_sc_hd__a22o_1
X_4857_ _1911_ VGND VGND VPWR VPWR _1912_ sky130_fd_sc_hd__buf_4
X_7576_ net39 u_analytics_engine.threshold\[5\] _3737_ VGND VGND VPWR VPWR _3743_
+ sky130_fd_sc_hd__mux2_1
XFILLER_0_62_437 VGND VGND VPWR VPWR sky130_fd_sc_hd__fill_2
XFILLER_0_7_553 VGND VGND VPWR VPWR sky130_fd_sc_hd__decap_6
X_4788_ net764 _1700_ _1874_ VGND VGND VPWR VPWR _1875_ sky130_fd_sc_hd__mux2_1
X_6527_ _1606_ net1242 _2825_ VGND VGND VPWR VPWR _2828_ sky130_fd_sc_hd__mux2_1
XFILLER_0_43_651 VGND VGND VPWR VPWR sky130_fd_sc_hd__decap_3
XFILLER_0_113_561 VPWR VGND VPWR VGND sky130_ef_sc_hd__decap_12
X_6458_ _2791_ VGND VGND VPWR VPWR _1044_ sky130_fd_sc_hd__clkbuf_1
XFILLER_0_30_334 VGND VGND VPWR VPWR sky130_fd_sc_hd__decap_3
X_5409_ _1433_ net733 _2205_ VGND VGND VPWR VPWR _2215_ sky130_fd_sc_hd__mux2_1
X_6389_ _1604_ net1154 _2753_ VGND VGND VPWR VPWR _2755_ sky130_fd_sc_hd__mux2_1
X_9177_ net173 _1265_ VGND VGND VPWR VPWR net133 sky130_fd_sc_hd__dfxtp_1
X_8128_ clknet_leaf_36_clk _0217_ VGND VGND VPWR VPWR u_input_buffer.fifo_mem\[55\]\[6\]
+ sky130_fd_sc_hd__dfxtp_1
X_8059_ clknet_leaf_45_clk _0148_ VGND VGND VPWR VPWR u_input_buffer.fifo_mem\[59\]\[1\]
+ sky130_fd_sc_hd__dfxtp_1
XFILLER_0_65_275 VGND VGND VPWR VPWR sky130_fd_sc_hd__decap_4
XTAP_507 VGND VPWR sky130_fd_sc_hd__tapvpwrvgnd_1
XTAP_518 VGND VPWR sky130_fd_sc_hd__tapvpwrvgnd_1
XTAP_529 VGND VPWR sky130_fd_sc_hd__tapvpwrvgnd_1
XFILLER_0_56_37 VGND VGND VPWR VPWR sky130_fd_sc_hd__fill_1
X_5760_ _2411_ VGND VGND VPWR VPWR _0726_ sky130_fd_sc_hd__clkbuf_1
XTAP_1290 VGND VPWR sky130_fd_sc_hd__tapvpwrvgnd_1
XFILLER_0_56_242 VGND VGND VPWR VPWR sky130_fd_sc_hd__fill_1
X_4711_ _1463_ net596 _1816_ VGND VGND VPWR VPWR _1832_ sky130_fd_sc_hd__mux2_1
X_5691_ _2374_ VGND VGND VPWR VPWR _0694_ sky130_fd_sc_hd__clkbuf_1
XFILLER_0_112_53 VPWR VGND VPWR VGND sky130_ef_sc_hd__decap_12
X_7430_ _3663_ VGND VGND VPWR VPWR _1144_ sky130_fd_sc_hd__clkbuf_1
X_4642_ net620 _1734_ _1777_ VGND VGND VPWR VPWR _1794_ sky130_fd_sc_hd__mux2_1
XFILLER_0_71_245 VGND VGND VPWR VPWR sky130_fd_sc_hd__fill_2
XFILLER_0_44_459 VGND VGND VPWR VPWR sky130_fd_sc_hd__fill_1
XFILLER_0_112_97 VPWR VGND VPWR VGND sky130_ef_sc_hd__decap_12
XFILLER_0_4_545 VPWR VGND VPWR VGND sky130_ef_sc_hd__decap_12
Xhold703 u_input_buffer.fifo_mem\[22\]\[12\] VGND VGND VPWR VPWR net915 sky130_fd_sc_hd__dlygate4sd3_1
XFILLER_0_24_150 VGND VGND VPWR VPWR sky130_fd_sc_hd__fill_1
X_7361_ u_input_buffer.fifo_mem\[51\]\[14\] _2989_ _2992_ u_input_buffer.fifo_mem\[11\]\[14\]
+ _3598_ VGND VGND VPWR VPWR _3599_ sky130_fd_sc_hd__a221o_1
X_4573_ _1592_ _1755_ VGND VGND VPWR VPWR _1756_ sky130_fd_sc_hd__nor2_4
Xhold714 u_input_buffer.fifo_mem\[42\]\[1\] VGND VGND VPWR VPWR net926 sky130_fd_sc_hd__dlygate4sd3_1
XFILLER_0_97_33 VPWR VGND VPWR VGND sky130_ef_sc_hd__decap_12
Xhold736 u_input_buffer.fifo_mem\[57\]\[11\] VGND VGND VPWR VPWR net948 sky130_fd_sc_hd__dlygate4sd3_1
XFILLER_0_4_589 VPWR VGND VPWR VGND sky130_ef_sc_hd__decap_12
Xhold725 u_input_buffer.fifo_mem\[13\]\[10\] VGND VGND VPWR VPWR net937 sky130_fd_sc_hd__dlygate4sd3_1
X_9100_ net170 _1188_ net202 VGND VGND VPWR VPWR u_register_bank.window_cfg\[14\]
+ sky130_fd_sc_hd__dfrtp_1
X_6312_ net890 _2526_ _2697_ VGND VGND VPWR VPWR _2713_ sky130_fd_sc_hd__mux2_1
X_7292_ u_input_buffer.fifo_mem\[52\]\[12\] _3038_ _3040_ u_input_buffer.fifo_mem\[56\]\[12\]
+ VGND VGND VPWR VPWR _3532_ sky130_fd_sc_hd__a22o_1
Xhold769 u_input_buffer.fifo_mem\[56\]\[0\] VGND VGND VPWR VPWR net981 sky130_fd_sc_hd__dlygate4sd3_1
Xhold747 u_input_buffer.fifo_mem\[45\]\[13\] VGND VGND VPWR VPWR net959 sky130_fd_sc_hd__dlygate4sd3_1
X_9031_ clknet_leaf_101_clk _1120_ net184 VGND VGND VPWR VPWR u_input_buffer.wr_ptr\[0\]
+ sky130_fd_sc_hd__dfrtp_1
Xhold758 u_input_buffer.fifo_mem\[7\]\[13\] VGND VGND VPWR VPWR net970 sky130_fd_sc_hd__dlygate4sd3_1
XFILLER_0_40_665 VGND VGND VPWR VPWR sky130_fd_sc_hd__fill_1
X_6243_ _2676_ VGND VGND VPWR VPWR _0944_ sky130_fd_sc_hd__clkbuf_1
X_6174_ _2639_ VGND VGND VPWR VPWR _0912_ sky130_fd_sc_hd__clkbuf_1
X_5125_ _2064_ VGND VGND VPWR VPWR _0438_ sky130_fd_sc_hd__clkbuf_1
X_5056_ net770 _1996_ _2024_ VGND VGND VPWR VPWR _2028_ sky130_fd_sc_hd__mux2_1
X_4007_ _1354_ VGND VGND VPWR VPWR _0030_ sky130_fd_sc_hd__clkbuf_1
X_8815_ clknet_leaf_30_clk _0904_ VGND VGND VPWR VPWR u_input_buffer.fifo_mem\[12\]\[5\]
+ sky130_fd_sc_hd__dfxtp_1
X_8746_ clknet_leaf_24_clk _0835_ VGND VGND VPWR VPWR u_input_buffer.fifo_mem\[16\]\[0\]
+ sky130_fd_sc_hd__dfxtp_1
X_5958_ _2521_ VGND VGND VPWR VPWR _0814_ sky130_fd_sc_hd__clkbuf_1
X_4909_ _1941_ VGND VGND VPWR VPWR _0345_ sky130_fd_sc_hd__clkbuf_1
X_5889_ net312 _2240_ _2479_ VGND VGND VPWR VPWR _2480_ sky130_fd_sc_hd__mux2_1
X_8677_ clknet_leaf_110_clk _0766_ VGND VGND VPWR VPWR u_input_buffer.fifo_mem\[21\]\[11\]
+ sky130_fd_sc_hd__dfxtp_1
X_7628_ net35 u_register_bank.threshold_cfg\[30\] _3736_ VGND VGND VPWR VPWR _3770_
+ sky130_fd_sc_hd__mux2_1
X_7559_ net35 u_register_bank.window_cfg\[30\] _3699_ VGND VGND VPWR VPWR _3733_ sky130_fd_sc_hd__mux2_1
X_9229_ net173 _1316_ net204 VGND VGND VPWR VPWR u_register_bank.sensor_enable\[30\]
+ sky130_fd_sc_hd__dfrtp_1
XFILLER_0_30_197 VGND VGND VPWR VPWR sky130_fd_sc_hd__decap_4
Xhold41 u_input_buffer.fifo_mem\[0\]\[1\] VGND VGND VPWR VPWR net253 sky130_fd_sc_hd__dlygate4sd3_1
Xhold30 u_sample_counter.sample_count\[19\] VGND VGND VPWR VPWR net242 sky130_fd_sc_hd__dlygate4sd3_1
Xhold74 u_input_buffer.fifo_mem\[63\]\[1\] VGND VGND VPWR VPWR net286 sky130_fd_sc_hd__dlygate4sd3_1
Xhold52 u_input_buffer.fifo_mem\[24\]\[15\] VGND VGND VPWR VPWR net264 sky130_fd_sc_hd__dlygate4sd3_1
Xhold63 u_input_buffer.fifo_mem\[28\]\[11\] VGND VGND VPWR VPWR net275 sky130_fd_sc_hd__dlygate4sd3_1
Xhold85 u_input_buffer.fifo_mem\[51\]\[10\] VGND VGND VPWR VPWR net297 sky130_fd_sc_hd__dlygate4sd3_1
Xhold96 u_input_buffer.fifo_mem\[35\]\[15\] VGND VGND VPWR VPWR net308 sky130_fd_sc_hd__dlygate4sd3_1
XFILLER_0_85_359 VGND VGND VPWR VPWR sky130_fd_sc_hd__fill_1
XFILLER_0_38_231 VGND VGND VPWR VPWR sky130_fd_sc_hd__decap_4
XFILLER_0_66_595 VGND VGND VPWR VPWR sky130_fd_sc_hd__decap_4
XFILLER_0_81_543 VGND VGND VPWR VPWR sky130_fd_sc_hd__fill_1
XFILLER_0_53_278 VGND VGND VPWR VPWR sky130_fd_sc_hd__fill_2
XANTENNA_5 _3221_ VGND VGND VPWR VPWR sky130_fd_sc_hd__diode_2
XFILLER_0_67_25 VGND VGND VPWR VPWR sky130_fd_sc_hd__decap_3
XTAP_315 VGND VPWR sky130_fd_sc_hd__tapvpwrvgnd_1
XTAP_304 VGND VPWR sky130_fd_sc_hd__tapvpwrvgnd_1
XTAP_348 VGND VPWR sky130_fd_sc_hd__tapvpwrvgnd_1
XTAP_326 VGND VPWR sky130_fd_sc_hd__tapvpwrvgnd_1
XTAP_337 VGND VPWR sky130_fd_sc_hd__tapvpwrvgnd_1
XTAP_359 VGND VPWR sky130_fd_sc_hd__tapvpwrvgnd_1
XFILLER_0_20_9 VGND VGND VPWR VPWR sky130_fd_sc_hd__decap_8
XFILLER_0_107_75 VPWR VGND VPWR VGND sky130_ef_sc_hd__decap_12
XFILLER_0_89_665 VGND VGND VPWR VPWR sky130_fd_sc_hd__decap_6
X_6930_ u_input_buffer.fifo_mem\[12\]\[3\] _2980_ _2982_ u_input_buffer.fifo_mem\[18\]\[3\]
+ _3178_ VGND VGND VPWR VPWR _3179_ sky130_fd_sc_hd__a221o_1
X_6861_ u_input_buffer.fifo_mem\[30\]\[1\] _3029_ _3031_ u_input_buffer.fifo_mem\[58\]\[1\]
+ VGND VGND VPWR VPWR _3112_ sky130_fd_sc_hd__a22o_1
X_6792_ _3011_ _3022_ _3033_ _3043_ VGND VGND VPWR VPWR _3044_ sky130_fd_sc_hd__or4_1
X_8600_ clknet_leaf_88_clk _0689_ VGND VGND VPWR VPWR u_input_buffer.fifo_mem\[26\]\[14\]
+ sky130_fd_sc_hd__dfxtp_1
XFILLER_0_9_615 VGND VGND VPWR VPWR sky130_fd_sc_hd__fill_1
X_5812_ _2438_ VGND VGND VPWR VPWR _0751_ sky130_fd_sc_hd__clkbuf_1
X_8531_ clknet_leaf_64_clk _0620_ VGND VGND VPWR VPWR u_input_buffer.fifo_mem\[30\]\[9\]
+ sky130_fd_sc_hd__dfxtp_1
X_5743_ _2401_ VGND VGND VPWR VPWR _0719_ sky130_fd_sc_hd__clkbuf_1
X_8462_ clknet_leaf_17_clk _0551_ VGND VGND VPWR VPWR u_input_buffer.fifo_mem\[34\]\[4\]
+ sky130_fd_sc_hd__dfxtp_1
X_5674_ net1166 _2268_ _2351_ VGND VGND VPWR VPWR _2365_ sky130_fd_sc_hd__mux2_1
XFILLER_0_115_645 VGND VGND VPWR VPWR sky130_fd_sc_hd__fill_2
X_4625_ _1785_ VGND VGND VPWR VPWR _0217_ sky130_fd_sc_hd__clkbuf_1
XFILLER_0_72_587 VGND VGND VPWR VPWR sky130_fd_sc_hd__fill_1
X_7413_ u_input_buffer.fifo_mem\[23\]\[15\] _3045_ _3047_ u_input_buffer.fifo_mem\[20\]\[15\]
+ _3649_ VGND VGND VPWR VPWR _3650_ sky130_fd_sc_hd__a221o_1
X_8393_ clknet_leaf_94_clk _0482_ VGND VGND VPWR VPWR u_input_buffer.fifo_mem\[39\]\[15\]
+ sky130_fd_sc_hd__dfxtp_1
XFILLER_0_114_177 VPWR VGND VPWR VGND sky130_ef_sc_hd__decap_12
Xhold511 u_input_buffer.fifo_mem\[57\]\[15\] VGND VGND VPWR VPWR net723 sky130_fd_sc_hd__dlygate4sd3_1
Xhold500 u_input_buffer.fifo_mem\[6\]\[12\] VGND VGND VPWR VPWR net712 sky130_fd_sc_hd__dlygate4sd3_1
X_4556_ _1427_ net994 _1738_ VGND VGND VPWR VPWR _1747_ sky130_fd_sc_hd__mux2_1
X_7344_ net523 _3085_ _3087_ VGND VGND VPWR VPWR _3583_ sky130_fd_sc_hd__o21a_1
Xhold533 u_input_buffer.fifo_mem\[4\]\[7\] VGND VGND VPWR VPWR net745 sky130_fd_sc_hd__dlygate4sd3_1
Xhold522 u_input_buffer.fifo_mem\[51\]\[14\] VGND VGND VPWR VPWR net734 sky130_fd_sc_hd__dlygate4sd3_1
Xhold544 u_input_buffer.fifo_mem\[42\]\[15\] VGND VGND VPWR VPWR net756 sky130_fd_sc_hd__dlygate4sd3_1
Xhold577 u_input_buffer.fifo_mem\[55\]\[6\] VGND VGND VPWR VPWR net789 sky130_fd_sc_hd__dlygate4sd3_1
Xhold588 u_input_buffer.fifo_mem\[27\]\[8\] VGND VGND VPWR VPWR net800 sky130_fd_sc_hd__dlygate4sd3_1
X_7275_ u_input_buffer.fifo_mem\[1\]\[12\] _2931_ _3512_ _3514_ VGND VGND VPWR VPWR
+ _3515_ sky130_fd_sc_hd__a211o_1
Xhold555 u_input_buffer.fifo_mem\[28\]\[14\] VGND VGND VPWR VPWR net767 sky130_fd_sc_hd__dlygate4sd3_1
Xhold566 u_input_buffer.fifo_mem\[4\]\[11\] VGND VGND VPWR VPWR net778 sky130_fd_sc_hd__dlygate4sd3_1
X_4487_ _1596_ _1701_ VGND VGND VPWR VPWR _1702_ sky130_fd_sc_hd__nand2_4
X_6226_ net974 _2508_ _2662_ VGND VGND VPWR VPWR _2668_ sky130_fd_sc_hd__mux2_1
Xhold599 u_input_buffer.fifo_mem\[38\]\[2\] VGND VGND VPWR VPWR net811 sky130_fd_sc_hd__dlygate4sd3_1
X_9014_ clknet_leaf_93_clk _1103_ VGND VGND VPWR VPWR u_input_buffer.fifo_mem\[0\]\[12\]
+ sky130_fd_sc_hd__dfxtp_1
X_6157_ net737 _2508_ _2625_ VGND VGND VPWR VPWR _2631_ sky130_fd_sc_hd__mux2_1
XTAP_860 VGND VPWR sky130_fd_sc_hd__tapvpwrvgnd_1
XTAP_871 VGND VPWR sky130_fd_sc_hd__tapvpwrvgnd_1
X_5108_ net763 _2014_ _2041_ VGND VGND VPWR VPWR _2055_ sky130_fd_sc_hd__mux2_1
XTAP_882 VGND VPWR sky130_fd_sc_hd__tapvpwrvgnd_1
XTAP_893 VGND VPWR sky130_fd_sc_hd__tapvpwrvgnd_1
X_6088_ _2593_ VGND VGND VPWR VPWR _0872_ sky130_fd_sc_hd__clkbuf_1
XFILLER_0_99_429 VGND VGND VPWR VPWR sky130_fd_sc_hd__decap_4
X_5039_ net563 _2016_ _1989_ VGND VGND VPWR VPWR _2017_ sky130_fd_sc_hd__mux2_1
XFILLER_0_67_337 VGND VGND VPWR VPWR sky130_fd_sc_hd__fill_1
X_8729_ clknet_leaf_12_clk _0818_ VGND VGND VPWR VPWR u_input_buffer.fifo_mem\[18\]\[15\]
+ sky130_fd_sc_hd__dfxtp_1
XFILLER_0_63_543 VGND VGND VPWR VPWR sky130_fd_sc_hd__fill_1
XFILLER_0_8_681 VGND VGND VPWR VPWR sky130_fd_sc_hd__decap_4
XFILLER_0_106_656 VGND VGND VPWR VPWR sky130_fd_sc_hd__fill_2
XFILLER_0_106_634 VGND VGND VPWR VPWR sky130_fd_sc_hd__fill_1
XFILLER_0_105_111 VGND VGND VPWR VPWR sky130_fd_sc_hd__fill_1
XFILLER_0_35_278 VGND VGND VPWR VPWR sky130_fd_sc_hd__fill_2
XFILLER_0_16_492 VGND VGND VPWR VPWR sky130_fd_sc_hd__fill_1
XFILLER_0_50_226 VGND VGND VPWR VPWR sky130_fd_sc_hd__fill_1
XFILLER_0_105_188 VGND VGND VPWR VPWR sky130_fd_sc_hd__decap_4
XFILLER_0_86_602 VGND VGND VPWR VPWR sky130_fd_sc_hd__fill_2
XFILLER_0_85_178 VGND VGND VPWR VPWR sky130_fd_sc_hd__decap_3
XFILLER_0_73_318 VGND VGND VPWR VPWR sky130_fd_sc_hd__fill_2
XFILLER_0_39_540 VGND VGND VPWR VPWR sky130_fd_sc_hd__fill_1
XPHY_170 VGND VGND VPWR VPWR sky130_fd_sc_hd__decap_3
XPHY_192 VGND VGND VPWR VPWR sky130_fd_sc_hd__decap_3
XPHY_181 VGND VGND VPWR VPWR sky130_fd_sc_hd__decap_3
Xclkbuf_leaf_105_clk clknet_3_0__leaf_clk VGND VGND VPWR VPWR clknet_leaf_105_clk
+ sky130_fd_sc_hd__clkbuf_16
XFILLER_0_81_351 VGND VGND VPWR VPWR sky130_fd_sc_hd__fill_2
XFILLER_0_54_576 VGND VGND VPWR VPWR sky130_fd_sc_hd__fill_1
X_4410_ _1657_ VGND VGND VPWR VPWR _0130_ sky130_fd_sc_hd__clkbuf_1
X_5390_ _2204_ VGND VGND VPWR VPWR _2205_ sky130_fd_sc_hd__buf_4
X_4341_ u_input_buffer.data_in\[6\] VGND VGND VPWR VPWR _1614_ sky130_fd_sc_hd__clkbuf_4
XFILLER_0_68_9 VGND VGND VPWR VPWR sky130_fd_sc_hd__decap_3
XFILLER_0_10_613 VPWR VGND VPWR VGND sky130_ef_sc_hd__decap_12
X_7060_ _3299_ _3301_ _3303_ _3305_ VGND VGND VPWR VPWR _3306_ sky130_fd_sc_hd__or4_1
XFILLER_0_10_657 VPWR VGND VPWR VGND sky130_ef_sc_hd__decap_12
X_4272_ u_analytics_engine.threshold\[13\] _1536_ u_analytics_engine.data_in\[12\]
+ _1540_ VGND VGND VPWR VPWR _1552_ sky130_fd_sc_hd__a2bb2o_1
X_6011_ net777 _2502_ _2549_ VGND VGND VPWR VPWR _2552_ sky130_fd_sc_hd__mux2_1
X_7962_ clknet_leaf_23_clk _0052_ net193 VGND VGND VPWR VPWR u_input_buffer.data_in\[2\]
+ sky130_fd_sc_hd__dfrtp_1
X_6913_ _3156_ _3158_ _3160_ _3162_ VGND VGND VPWR VPWR _3163_ sky130_fd_sc_hd__or4_1
X_7893_ clknet_leaf_82_clk net240 net187 VGND VGND VPWR VPWR u_register_bank.status_flags\[13\]
+ sky130_fd_sc_hd__dfrtp_1
XFILLER_0_64_307 VGND VGND VPWR VPWR sky130_fd_sc_hd__fill_1
X_6844_ u_input_buffer.fifo_mem\[17\]\[1\] _2943_ _2945_ u_input_buffer.fifo_mem\[5\]\[1\]
+ VGND VGND VPWR VPWR _3095_ sky130_fd_sc_hd__a22o_1
X_3987_ u_sensor_interface.sensor_array\[1\]\[3\] net56 _1334_ VGND VGND VPWR VPWR
+ _1344_ sky130_fd_sc_hd__mux2_1
X_6775_ _3026_ VGND VGND VPWR VPWR _3027_ sky130_fd_sc_hd__clkbuf_4
X_5726_ net604 _2252_ _2388_ VGND VGND VPWR VPWR _2393_ sky130_fd_sc_hd__mux2_1
X_8514_ clknet_leaf_69_clk _0603_ VGND VGND VPWR VPWR u_input_buffer.fifo_mem\[31\]\[8\]
+ sky130_fd_sc_hd__dfxtp_1
XFILLER_0_17_223 VGND VGND VPWR VPWR sky130_fd_sc_hd__fill_1
XFILLER_0_17_234 VGND VGND VPWR VPWR sky130_fd_sc_hd__decap_6
X_8445_ clknet_leaf_29_clk _0534_ VGND VGND VPWR VPWR u_input_buffer.fifo_mem\[35\]\[3\]
+ sky130_fd_sc_hd__dfxtp_1
X_5657_ _2356_ VGND VGND VPWR VPWR _0678_ sky130_fd_sc_hd__clkbuf_1
XFILLER_0_5_673 VPWR VGND VPWR VGND sky130_ef_sc_hd__decap_12
XFILLER_0_4_150 VGND VGND VPWR VPWR sky130_fd_sc_hd__decap_4
XFILLER_0_32_226 VGND VGND VPWR VPWR sky130_fd_sc_hd__decap_3
X_5588_ _2319_ VGND VGND VPWR VPWR _0646_ sky130_fd_sc_hd__clkbuf_1
X_8376_ clknet_leaf_90_clk _0465_ VGND VGND VPWR VPWR u_input_buffer.fifo_mem\[40\]\[14\]
+ sky130_fd_sc_hd__dfxtp_1
X_4608_ _1678_ _1774_ VGND VGND VPWR VPWR _1775_ sky130_fd_sc_hd__nor2_1
XFILLER_0_102_147 VGND VGND VPWR VPWR sky130_fd_sc_hd__fill_1
Xhold341 u_input_buffer.fifo_mem\[48\]\[6\] VGND VGND VPWR VPWR net553 sky130_fd_sc_hd__dlygate4sd3_1
Xhold330 u_input_buffer.fifo_mem\[24\]\[9\] VGND VGND VPWR VPWR net542 sky130_fd_sc_hd__dlygate4sd3_1
X_7327_ u_input_buffer.fifo_mem\[31\]\[13\] _3016_ _3019_ u_input_buffer.fifo_mem\[38\]\[13\]
+ VGND VGND VPWR VPWR _3566_ sky130_fd_sc_hd__a22o_1
X_4539_ _1737_ VGND VGND VPWR VPWR _1738_ sky130_fd_sc_hd__clkbuf_4
Xhold352 u_input_buffer.fifo_mem\[47\]\[11\] VGND VGND VPWR VPWR net564 sky130_fd_sc_hd__dlygate4sd3_1
Xhold385 u_input_buffer.fifo_mem\[35\]\[9\] VGND VGND VPWR VPWR net597 sky130_fd_sc_hd__dlygate4sd3_1
Xhold374 u_input_buffer.fifo_mem\[35\]\[1\] VGND VGND VPWR VPWR net586 sky130_fd_sc_hd__dlygate4sd3_1
Xhold396 u_input_buffer.fifo_mem\[26\]\[10\] VGND VGND VPWR VPWR net608 sky130_fd_sc_hd__dlygate4sd3_1
XFILLER_0_7_82 VGND VGND VPWR VPWR sky130_fd_sc_hd__fill_1
X_7258_ u_input_buffer.fifo_mem\[15\]\[11\] _3059_ _3061_ u_input_buffer.fifo_mem\[43\]\[11\]
+ VGND VGND VPWR VPWR _3499_ sky130_fd_sc_hd__a22o_1
Xhold363 u_input_buffer.fifo_mem\[14\]\[12\] VGND VGND VPWR VPWR net575 sky130_fd_sc_hd__dlygate4sd3_1
X_6209_ _2658_ VGND VGND VPWR VPWR _0928_ sky130_fd_sc_hd__clkbuf_1
X_7189_ u_analytics_engine.data_in\[9\] _2893_ _3430_ _3431_ VGND VGND VPWR VPWR _1135_
+ sky130_fd_sc_hd__a22o_1
Xhold1041 u_input_buffer.fifo_mem\[63\]\[14\] VGND VGND VPWR VPWR net1253 sky130_fd_sc_hd__dlygate4sd3_1
XTAP_690 VGND VPWR sky130_fd_sc_hd__tapvpwrvgnd_1
Xhold1030 u_input_buffer.fifo_mem\[1\]\[2\] VGND VGND VPWR VPWR net1242 sky130_fd_sc_hd__dlygate4sd3_1
Xhold1085 u_input_buffer.fifo_mem\[45\]\[5\] VGND VGND VPWR VPWR net1297 sky130_fd_sc_hd__dlygate4sd3_1
Xhold1063 u_input_buffer.fifo_mem\[29\]\[9\] VGND VGND VPWR VPWR net1275 sky130_fd_sc_hd__dlygate4sd3_1
Xhold1074 net163 VGND VGND VPWR VPWR net1286 sky130_fd_sc_hd__dlygate4sd3_1
Xhold1052 u_input_buffer.fifo_mem\[21\]\[3\] VGND VGND VPWR VPWR net1264 sky130_fd_sc_hd__dlygate4sd3_1
XFILLER_0_68_602 VGND VGND VPWR VPWR sky130_fd_sc_hd__decap_8
Xhold1096 net151 VGND VGND VPWR VPWR net1308 sky130_fd_sc_hd__dlygate4sd3_1
Xclkbuf_3_6__f_clk clknet_0_clk VGND VGND VPWR VPWR clknet_3_6__leaf_clk sky130_fd_sc_hd__clkbuf_16
XFILLER_0_68_635 VGND VGND VPWR VPWR sky130_fd_sc_hd__fill_1
XFILLER_0_67_167 VGND VGND VPWR VPWR sky130_fd_sc_hd__fill_1
XFILLER_0_67_178 VGND VGND VPWR VPWR sky130_fd_sc_hd__fill_1
XFILLER_0_31_281 VGND VGND VPWR VPWR sky130_fd_sc_hd__decap_4
XFILLER_0_48_27 VGND VGND VPWR VPWR sky130_fd_sc_hd__fill_1
XFILLER_0_104_21 VGND VGND VPWR VPWR sky130_fd_sc_hd__decap_6
X_4890_ u_input_buffer.wr_ptr\[4\] _1590_ VGND VGND VPWR VPWR _1929_ sky130_fd_sc_hd__or2_1
XFILLER_0_73_104 VGND VGND VPWR VPWR sky130_fd_sc_hd__fill_1
XFILLER_0_39_381 VGND VGND VPWR VPWR sky130_fd_sc_hd__fill_2
XFILLER_0_104_65 VPWR VGND VPWR VGND sky130_ef_sc_hd__decap_12
X_6560_ _2845_ VGND VGND VPWR VPWR _1092_ sky130_fd_sc_hd__clkbuf_1
X_5511_ net617 _2240_ _2277_ VGND VGND VPWR VPWR _2278_ sky130_fd_sc_hd__mux2_1
X_6491_ net797 _1384_ _2807_ VGND VGND VPWR VPWR _2809_ sky130_fd_sc_hd__mux2_1
X_5442_ _2232_ VGND VGND VPWR VPWR _0587_ sky130_fd_sc_hd__clkbuf_1
X_8230_ clknet_leaf_99_clk _0319_ VGND VGND VPWR VPWR u_input_buffer.fifo_mem\[49\]\[12\]
+ sky130_fd_sc_hd__dfxtp_1
X_5373_ net514 _2006_ _2187_ VGND VGND VPWR VPWR _2196_ sky130_fd_sc_hd__mux2_1
XFILLER_0_2_643 VGND VGND VPWR VPWR sky130_fd_sc_hd__fill_1
X_8161_ clknet_leaf_8_clk _0250_ VGND VGND VPWR VPWR u_input_buffer.fifo_mem\[53\]\[7\]
+ sky130_fd_sc_hd__dfxtp_1
X_4324_ net547 _1588_ _1602_ VGND VGND VPWR VPWR _1603_ sky130_fd_sc_hd__mux2_1
X_7112_ u_input_buffer.fifo_mem\[21\]\[8\] _2909_ _2913_ u_input_buffer.fifo_mem\[25\]\[8\]
+ VGND VGND VPWR VPWR _3356_ sky130_fd_sc_hd__a22o_1
X_8092_ clknet_leaf_3_clk _0181_ VGND VGND VPWR VPWR u_input_buffer.fifo_mem\[57\]\[2\]
+ sky130_fd_sc_hd__dfxtp_1
X_7043_ u_input_buffer.fifo_mem\[36\]\[6\] _2951_ _2955_ u_input_buffer.fifo_mem\[35\]\[6\]
+ _3288_ VGND VGND VPWR VPWR _3289_ sky130_fd_sc_hd__a221o_1
X_4255_ _1533_ u_analytics_engine.data_in\[14\] u_analytics_engine.threshold\[15\]
+ _1534_ VGND VGND VPWR VPWR _1535_ sky130_fd_sc_hd__o2bb2a_1
X_4186_ _1489_ VGND VGND VPWR VPWR _0074_ sky130_fd_sc_hd__clkbuf_1
X_8994_ clknet_leaf_8_clk _1083_ VGND VGND VPWR VPWR u_input_buffer.fifo_mem\[1\]\[8\]
+ sky130_fd_sc_hd__dfxtp_1
XTAP_1119 VGND VPWR sky130_fd_sc_hd__tapvpwrvgnd_1
XTAP_1108 VGND VPWR sky130_fd_sc_hd__tapvpwrvgnd_1
X_7945_ clknet_leaf_64_clk _0035_ VGND VGND VPWR VPWR u_sensor_interface.sensor_array\[0\]\[1\]
+ sky130_fd_sc_hd__dfxtp_1
X_7876_ net35 u_register_bank.sensor_enable\[30\] _3904_ VGND VGND VPWR VPWR _3938_
+ sky130_fd_sc_hd__mux2_1
XFILLER_0_49_145 VGND VGND VPWR VPWR sky130_fd_sc_hd__fill_1
X_6827_ _2917_ _2956_ VGND VGND VPWR VPWR _3079_ sky130_fd_sc_hd__and2_2
XFILLER_0_9_275 VGND VGND VPWR VPWR sky130_fd_sc_hd__fill_1
X_6758_ u_input_buffer.fifo_mem\[47\]\[0\] _2880_ _3007_ _3009_ u_input_buffer.fifo_mem\[24\]\[0\]
+ VGND VGND VPWR VPWR _3010_ sky130_fd_sc_hd__a32o_1
XFILLER_0_73_682 VGND VGND VPWR VPWR sky130_fd_sc_hd__decap_4
XFILLER_0_33_502 VGND VGND VPWR VPWR sky130_fd_sc_hd__fill_2
X_5709_ _2383_ VGND VGND VPWR VPWR _0703_ sky130_fd_sc_hd__clkbuf_1
X_6689_ _2940_ VGND VGND VPWR VPWR _2941_ sky130_fd_sc_hd__clkbuf_4
X_8428_ clknet_leaf_27_clk _0517_ VGND VGND VPWR VPWR u_input_buffer.fifo_mem\[36\]\[2\]
+ sky130_fd_sc_hd__dfxtp_1
XFILLER_0_60_365 VGND VGND VPWR VPWR sky130_fd_sc_hd__decap_3
XFILLER_0_5_481 VPWR VGND VPWR VGND sky130_ef_sc_hd__decap_12
X_8359_ clknet_leaf_107_clk _0448_ VGND VGND VPWR VPWR u_input_buffer.fifo_mem\[41\]\[13\]
+ sky130_fd_sc_hd__dfxtp_1
Xhold171 u_input_buffer.fifo_mem\[3\]\[9\] VGND VGND VPWR VPWR net383 sky130_fd_sc_hd__dlygate4sd3_1
Xhold160 u_input_buffer.fifo_mem\[31\]\[13\] VGND VGND VPWR VPWR net372 sky130_fd_sc_hd__dlygate4sd3_1
Xhold182 u_input_buffer.fifo_mem\[24\]\[0\] VGND VGND VPWR VPWR net394 sky130_fd_sc_hd__dlygate4sd3_1
Xhold193 u_input_buffer.fifo_mem\[58\]\[11\] VGND VGND VPWR VPWR net405 sky130_fd_sc_hd__dlygate4sd3_1
XTAP_1642 VGND VPWR sky130_fd_sc_hd__tapvpwrvgnd_1
XTAP_1631 VGND VPWR sky130_fd_sc_hd__tapvpwrvgnd_1
XTAP_1620 VGND VPWR sky130_fd_sc_hd__tapvpwrvgnd_1
XFILLER_0_83_402 VGND VGND VPWR VPWR sky130_fd_sc_hd__decap_3
XFILLER_0_36_362 VGND VGND VPWR VPWR sky130_fd_sc_hd__fill_2
XFILLER_0_63_181 VGND VGND VPWR VPWR sky130_fd_sc_hd__decap_4
XFILLER_0_24_546 VGND VGND VPWR VPWR sky130_fd_sc_hd__fill_1
X_4040_ net274 net49 _1367_ VGND VGND VPWR VPWR _1372_ sky130_fd_sc_hd__mux2_1
XFILLER_0_91_57 VPWR VGND VPWR VGND sky130_ef_sc_hd__decap_12
X_5991_ _1620_ net1190 _2531_ VGND VGND VPWR VPWR _2541_ sky130_fd_sc_hd__mux2_1
X_4942_ net1129 _1716_ _1952_ VGND VGND VPWR VPWR _1959_ sky130_fd_sc_hd__mux2_1
X_7730_ u_register_bank.status_flags\[20\] _3849_ _3843_ u_register_bank.sensor_enable\[20\]
+ VGND VGND VPWR VPWR _3850_ sky130_fd_sc_hd__a22o_1
XFILLER_0_115_97 VPWR VGND VPWR VGND sky130_ef_sc_hd__decap_12
X_7661_ u_register_bank.status_flags\[5\] _3775_ _3778_ u_register_bank.sensor_enable\[5\]
+ VGND VGND VPWR VPWR _3796_ sky130_fd_sc_hd__a22o_1
XFILLER_0_47_638 VGND VGND VPWR VPWR sky130_fd_sc_hd__decap_3
X_4873_ _1920_ VGND VGND VPWR VPWR _0330_ sky130_fd_sc_hd__clkbuf_1
XFILLER_0_74_457 VGND VGND VPWR VPWR sky130_fd_sc_hd__decap_6
XFILLER_0_24_95 VGND VGND VPWR VPWR sky130_fd_sc_hd__fill_1
X_6612_ _2872_ _2861_ _2873_ VGND VGND VPWR VPWR _2875_ sky130_fd_sc_hd__a21oi_1
XFILLER_0_46_137 VGND VGND VPWR VPWR sky130_fd_sc_hd__decap_3
XFILLER_0_55_671 VGND VGND VPWR VPWR sky130_fd_sc_hd__fill_1
X_7592_ _3751_ VGND VGND VPWR VPWR _1218_ sky130_fd_sc_hd__clkbuf_1
X_6543_ _1622_ net1148 _2824_ VGND VGND VPWR VPWR _2836_ sky130_fd_sc_hd__mux2_1
X_6474_ _2799_ VGND VGND VPWR VPWR _1052_ sky130_fd_sc_hd__clkbuf_1
XFILLER_0_40_94 VGND VGND VPWR VPWR sky130_fd_sc_hd__fill_2
X_5425_ net636 _1988_ _2223_ VGND VGND VPWR VPWR _2224_ sky130_fd_sc_hd__mux2_1
X_8213_ clknet_leaf_9_clk _0302_ VGND VGND VPWR VPWR u_input_buffer.fifo_mem\[50\]\[11\]
+ sky130_fd_sc_hd__dfxtp_1
XFILLER_0_42_387 VGND VGND VPWR VPWR sky130_fd_sc_hd__fill_2
X_9193_ clknet_leaf_47_clk _1281_ net199 VGND VGND VPWR VPWR net150 sky130_fd_sc_hd__dfrtp_4
XFILLER_0_100_459 VGND VGND VPWR VPWR sky130_fd_sc_hd__fill_1
X_8144_ clknet_leaf_36_clk _0233_ VGND VGND VPWR VPWR u_input_buffer.fifo_mem\[54\]\[6\]
+ sky130_fd_sc_hd__dfxtp_1
X_5356_ _2186_ VGND VGND VPWR VPWR _2187_ sky130_fd_sc_hd__buf_4
XFILLER_0_49_70 VGND VGND VPWR VPWR sky130_fd_sc_hd__fill_1
X_8075_ clknet_leaf_59_clk _0164_ VGND VGND VPWR VPWR u_input_buffer.fifo_mem\[58\]\[1\]
+ sky130_fd_sc_hd__dfxtp_1
XFILLER_0_10_295 VGND VGND VPWR VPWR sky130_fd_sc_hd__fill_1
X_5287_ _1834_ _1930_ VGND VGND VPWR VPWR _2150_ sky130_fd_sc_hd__nor2_4
X_4307_ u_analytics_engine.threshold_cross _1586_ _1474_ VGND VGND VPWR VPWR _1587_
+ sky130_fd_sc_hd__mux2_1
X_7026_ u_input_buffer.fifo_mem\[3\]\[5\] _3070_ _3072_ u_input_buffer.fifo_mem\[60\]\[5\]
+ VGND VGND VPWR VPWR _3273_ sky130_fd_sc_hd__a22o_1
X_4238_ _1524_ VGND VGND VPWR VPWR _0091_ sky130_fd_sc_hd__clkbuf_1
X_4169_ _1477_ _1478_ VGND VGND VPWR VPWR _0068_ sky130_fd_sc_hd__nor2_1
Xclkbuf_leaf_94_clk clknet_3_3__leaf_clk VGND VGND VPWR VPWR clknet_leaf_94_clk sky130_fd_sc_hd__clkbuf_16
X_8977_ clknet_leaf_30_clk _1066_ VGND VGND VPWR VPWR u_input_buffer.fifo_mem\[2\]\[7\]
+ sky130_fd_sc_hd__dfxtp_1
X_7928_ clknet_leaf_33_clk _0018_ VGND VGND VPWR VPWR u_sensor_interface.sensor_array\[1\]\[0\]
+ sky130_fd_sc_hd__dfxtp_1
X_7859_ _3929_ VGND VGND VPWR VPWR _1307_ sky130_fd_sc_hd__clkbuf_1
XFILLER_0_80_416 VGND VGND VPWR VPWR sky130_fd_sc_hd__fill_1
XFILLER_0_18_373 VGND VGND VPWR VPWR sky130_fd_sc_hd__fill_1
XFILLER_0_61_685 VGND VGND VPWR VPWR sky130_fd_sc_hd__fill_1
XFILLER_0_21_527 VGND VGND VPWR VPWR sky130_fd_sc_hd__decap_6
XFILLER_0_103_297 VGND VGND VPWR VPWR sky130_fd_sc_hd__fill_2
Xclkbuf_leaf_85_clk clknet_3_2__leaf_clk VGND VGND VPWR VPWR clknet_leaf_85_clk sky130_fd_sc_hd__clkbuf_16
XTAP_1450 VGND VPWR sky130_fd_sc_hd__tapvpwrvgnd_1
XFILLER_0_68_262 VGND VGND VPWR VPWR sky130_fd_sc_hd__decap_4
XTAP_1483 VGND VPWR sky130_fd_sc_hd__tapvpwrvgnd_1
XTAP_1472 VGND VPWR sky130_fd_sc_hd__tapvpwrvgnd_1
XTAP_1461 VGND VPWR sky130_fd_sc_hd__tapvpwrvgnd_1
XFILLER_0_96_593 VGND VGND VPWR VPWR sky130_fd_sc_hd__fill_1
XFILLER_0_68_284 VGND VGND VPWR VPWR sky130_fd_sc_hd__fill_1
XTAP_1494 VGND VPWR sky130_fd_sc_hd__tapvpwrvgnd_1
XFILLER_0_44_608 VGND VGND VPWR VPWR sky130_fd_sc_hd__decap_4
XFILLER_0_71_449 VGND VGND VPWR VPWR sky130_fd_sc_hd__fill_2
XFILLER_0_9_39 VPWR VGND VPWR VGND sky130_ef_sc_hd__decap_12
XFILLER_0_101_55 VGND VGND VPWR VPWR sky130_fd_sc_hd__fill_1
Xhold918 u_input_buffer.fifo_mem\[19\]\[1\] VGND VGND VPWR VPWR net1130 sky130_fd_sc_hd__dlygate4sd3_1
Xhold907 u_input_buffer.fifo_mem\[37\]\[4\] VGND VGND VPWR VPWR net1119 sky130_fd_sc_hd__dlygate4sd3_1
XFILLER_0_10_53 VGND VGND VPWR VPWR sky130_fd_sc_hd__decap_6
Xhold929 u_input_buffer.fifo_mem\[38\]\[14\] VGND VGND VPWR VPWR net1141 sky130_fd_sc_hd__dlygate4sd3_1
X_5210_ _2109_ VGND VGND VPWR VPWR _0478_ sky130_fd_sc_hd__clkbuf_1
X_6190_ net660 _2506_ _2644_ VGND VGND VPWR VPWR _2649_ sky130_fd_sc_hd__mux2_1
XFILLER_0_20_560 VGND VGND VPWR VPWR sky130_fd_sc_hd__fill_2
XFILLER_0_20_582 VGND VGND VPWR VPWR sky130_fd_sc_hd__decap_6
X_5141_ _2072_ VGND VGND VPWR VPWR _0446_ sky130_fd_sc_hd__clkbuf_1
XFILLER_0_50_9 VGND VGND VPWR VPWR sky130_fd_sc_hd__fill_1
XFILLER_0_19_51 VGND VGND VPWR VPWR sky130_fd_sc_hd__decap_4
X_5072_ net355 _2012_ _2023_ VGND VGND VPWR VPWR _2036_ sky130_fd_sc_hd__mux2_1
X_4023_ net1274 net90 _1356_ VGND VGND VPWR VPWR _1363_ sky130_fd_sc_hd__mux2_1
XFILLER_0_19_84 VPWR VGND VPWR VGND sky130_ef_sc_hd__decap_12
X_8900_ clknet_leaf_85_clk _0989_ VGND VGND VPWR VPWR u_input_buffer.fifo_mem\[7\]\[10\]
+ sky130_fd_sc_hd__dfxtp_1
Xclkbuf_leaf_76_clk clknet_3_3__leaf_clk VGND VGND VPWR VPWR clknet_leaf_76_clk sky130_fd_sc_hd__clkbuf_16
X_8831_ clknet_leaf_37_clk _0920_ VGND VGND VPWR VPWR u_input_buffer.fifo_mem\[11\]\[5\]
+ sky130_fd_sc_hd__dfxtp_1
X_8762_ clknet_leaf_33_clk _0851_ VGND VGND VPWR VPWR u_input_buffer.fifo_mem\[15\]\[0\]
+ sky130_fd_sc_hd__dfxtp_1
X_7713_ _3836_ VGND VGND VPWR VPWR _1254_ sky130_fd_sc_hd__clkbuf_1
X_5974_ _2532_ VGND VGND VPWR VPWR _0819_ sky130_fd_sc_hd__clkbuf_1
X_8693_ clknet_leaf_90_clk _0782_ VGND VGND VPWR VPWR u_input_buffer.fifo_mem\[20\]\[11\]
+ sky130_fd_sc_hd__dfxtp_1
X_4925_ _1949_ VGND VGND VPWR VPWR _0353_ sky130_fd_sc_hd__clkbuf_1
X_7644_ _3783_ VGND VGND VPWR VPWR _1238_ sky130_fd_sc_hd__clkbuf_1
XFILLER_0_35_608 VGND VGND VPWR VPWR sky130_fd_sc_hd__decap_8
X_4856_ _1592_ _1910_ VGND VGND VPWR VPWR _1911_ sky130_fd_sc_hd__nor2_4
X_7575_ _3742_ VGND VGND VPWR VPWR _1210_ sky130_fd_sc_hd__clkbuf_1
X_4787_ _1873_ VGND VGND VPWR VPWR _1874_ sky130_fd_sc_hd__clkbuf_4
X_6526_ _2827_ VGND VGND VPWR VPWR _1076_ sky130_fd_sc_hd__clkbuf_1
XFILLER_0_43_685 VGND VGND VPWR VPWR sky130_fd_sc_hd__fill_1
XFILLER_0_113_573 VPWR VGND VPWR VGND sky130_ef_sc_hd__decap_12
X_6457_ net709 _1384_ _2789_ VGND VGND VPWR VPWR _2791_ sky130_fd_sc_hd__mux2_1
XFILLER_0_30_324 VGND VGND VPWR VPWR sky130_fd_sc_hd__fill_2
X_6388_ _2754_ VGND VGND VPWR VPWR _1011_ sky130_fd_sc_hd__clkbuf_1
X_9176_ net173 _1264_ VGND VGND VPWR VPWR net132 sky130_fd_sc_hd__dfxtp_1
X_5408_ _2214_ VGND VGND VPWR VPWR _0571_ sky130_fd_sc_hd__clkbuf_1
X_8127_ clknet_leaf_49_clk _0216_ VGND VGND VPWR VPWR u_input_buffer.fifo_mem\[55\]\[5\]
+ sky130_fd_sc_hd__dfxtp_1
X_5339_ net687 _2006_ _2169_ VGND VGND VPWR VPWR _2178_ sky130_fd_sc_hd__mux2_1
X_8058_ clknet_leaf_45_clk _0147_ VGND VGND VPWR VPWR u_input_buffer.fifo_mem\[59\]\[0\]
+ sky130_fd_sc_hd__dfxtp_1
X_7009_ u_input_buffer.fifo_mem\[50\]\[5\] _2995_ _2997_ u_input_buffer.fifo_mem\[4\]\[5\]
+ VGND VGND VPWR VPWR _3256_ sky130_fd_sc_hd__a22o_1
Xclkbuf_leaf_67_clk clknet_3_6__leaf_clk VGND VGND VPWR VPWR clknet_leaf_67_clk sky130_fd_sc_hd__clkbuf_16
XFILLER_0_26_608 VGND VGND VPWR VPWR sky130_fd_sc_hd__fill_2
XFILLER_0_25_129 VGND VGND VPWR VPWR sky130_fd_sc_hd__fill_1
XFILLER_0_21_335 VGND VGND VPWR VPWR sky130_fd_sc_hd__fill_1
XTAP_508 VGND VPWR sky130_fd_sc_hd__tapvpwrvgnd_1
XTAP_519 VGND VPWR sky130_fd_sc_hd__tapvpwrvgnd_1
Xclkbuf_leaf_58_clk clknet_3_7__leaf_clk VGND VGND VPWR VPWR clknet_leaf_58_clk sky130_fd_sc_hd__clkbuf_16
XTAP_1291 VGND VPWR sky130_fd_sc_hd__tapvpwrvgnd_1
XTAP_1280 VGND VPWR sky130_fd_sc_hd__tapvpwrvgnd_1
X_4710_ _1831_ VGND VGND VPWR VPWR _0256_ sky130_fd_sc_hd__clkbuf_1
XFILLER_0_29_468 VGND VGND VPWR VPWR sky130_fd_sc_hd__fill_1
X_5690_ _1608_ net1285 _2370_ VGND VGND VPWR VPWR _2374_ sky130_fd_sc_hd__mux2_1
XFILLER_0_112_21 VGND VGND VPWR VPWR sky130_fd_sc_hd__decap_6
X_4641_ _1793_ VGND VGND VPWR VPWR _0225_ sky130_fd_sc_hd__clkbuf_1
XFILLER_0_114_315 VGND VGND VPWR VPWR sky130_fd_sc_hd__fill_1
XFILLER_0_112_65 VPWR VGND VPWR VGND sky130_ef_sc_hd__decap_12
XFILLER_0_4_557 VPWR VGND VPWR VGND sky130_ef_sc_hd__decap_12
X_7360_ u_input_buffer.fifo_mem\[50\]\[14\] _2994_ _2996_ u_input_buffer.fifo_mem\[4\]\[14\]
+ VGND VGND VPWR VPWR _3598_ sky130_fd_sc_hd__a22o_1
X_4572_ _1658_ _1701_ VGND VGND VPWR VPWR _1755_ sky130_fd_sc_hd__nand2_4
Xhold715 u_input_buffer.fifo_mem\[10\]\[2\] VGND VGND VPWR VPWR net927 sky130_fd_sc_hd__dlygate4sd3_1
XFILLER_0_97_45 VGND VGND VPWR VPWR sky130_fd_sc_hd__decap_8
Xhold737 u_input_buffer.fifo_mem\[22\]\[0\] VGND VGND VPWR VPWR net949 sky130_fd_sc_hd__dlygate4sd3_1
Xhold704 u_input_buffer.fifo_mem\[27\]\[7\] VGND VGND VPWR VPWR net916 sky130_fd_sc_hd__dlygate4sd3_1
X_7291_ u_input_buffer.fifo_mem\[7\]\[12\] _3024_ _3026_ u_input_buffer.fifo_mem\[22\]\[12\]
+ _3530_ VGND VGND VPWR VPWR _3531_ sky130_fd_sc_hd__a221o_1
Xhold726 u_input_buffer.fifo_mem\[23\]\[15\] VGND VGND VPWR VPWR net938 sky130_fd_sc_hd__dlygate4sd3_1
XFILLER_0_24_195 VGND VGND VPWR VPWR sky130_fd_sc_hd__fill_1
X_6311_ _2712_ VGND VGND VPWR VPWR _0976_ sky130_fd_sc_hd__clkbuf_1
Xhold748 u_input_buffer.fifo_mem\[20\]\[0\] VGND VGND VPWR VPWR net960 sky130_fd_sc_hd__dlygate4sd3_1
X_6242_ net613 _2524_ _2661_ VGND VGND VPWR VPWR _2676_ sky130_fd_sc_hd__mux2_1
Xhold759 u_input_buffer.fifo_mem\[57\]\[14\] VGND VGND VPWR VPWR net971 sky130_fd_sc_hd__dlygate4sd3_1
X_9030_ clknet_leaf_97_clk _1119_ net186 VGND VGND VPWR VPWR u_input_buffer.rd_ptr\[5\]
+ sky130_fd_sc_hd__dfrtp_1
XFILLER_0_110_587 VGND VGND VPWR VPWR sky130_fd_sc_hd__fill_1
X_6173_ net500 _2524_ _2624_ VGND VGND VPWR VPWR _2639_ sky130_fd_sc_hd__mux2_1
X_5124_ _1397_ net1188 _2060_ VGND VGND VPWR VPWR _2064_ sky130_fd_sc_hd__mux2_1
X_5055_ _2027_ VGND VGND VPWR VPWR _0405_ sky130_fd_sc_hd__clkbuf_1
Xclkbuf_leaf_49_clk clknet_3_7__leaf_clk VGND VGND VPWR VPWR clknet_leaf_49_clk sky130_fd_sc_hd__clkbuf_16
X_4006_ u_sensor_interface.sensor_array\[1\]\[12\] net66 _1345_ VGND VGND VPWR VPWR
+ _1354_ sky130_fd_sc_hd__mux2_1
X_8814_ clknet_leaf_24_clk _0903_ VGND VGND VPWR VPWR u_input_buffer.fifo_mem\[12\]\[4\]
+ sky130_fd_sc_hd__dfxtp_1
XFILLER_0_75_530 VGND VGND VPWR VPWR sky130_fd_sc_hd__fill_1
X_8745_ clknet_leaf_103_clk _0834_ VGND VGND VPWR VPWR u_input_buffer.fifo_mem\[17\]\[15\]
+ sky130_fd_sc_hd__dfxtp_1
X_5957_ net914 _2520_ _2497_ VGND VGND VPWR VPWR _2521_ sky130_fd_sc_hd__mux2_1
X_4908_ net1220 _1716_ _1934_ VGND VGND VPWR VPWR _1941_ sky130_fd_sc_hd__mux2_1
X_8676_ clknet_leaf_105_clk _0765_ VGND VGND VPWR VPWR u_input_buffer.fifo_mem\[21\]\[10\]
+ sky130_fd_sc_hd__dfxtp_1
X_7627_ _3769_ VGND VGND VPWR VPWR _1235_ sky130_fd_sc_hd__clkbuf_1
X_5888_ _2478_ VGND VGND VPWR VPWR _2479_ sky130_fd_sc_hd__buf_4
X_4839_ _1427_ net1109 _1893_ VGND VGND VPWR VPWR _1902_ sky130_fd_sc_hd__mux2_1
XFILLER_0_16_641 VGND VGND VPWR VPWR sky130_fd_sc_hd__decap_3
XFILLER_0_105_348 VGND VGND VPWR VPWR sky130_fd_sc_hd__fill_2
X_7558_ _3732_ VGND VGND VPWR VPWR _1203_ sky130_fd_sc_hd__clkbuf_1
XFILLER_0_43_471 VGND VGND VPWR VPWR sky130_fd_sc_hd__fill_2
X_6509_ net953 _1438_ _2806_ VGND VGND VPWR VPWR _2818_ sky130_fd_sc_hd__mux2_1
X_7489_ net754 _1468_ _3677_ VGND VGND VPWR VPWR _3694_ sky130_fd_sc_hd__mux2_1
X_9228_ net178 _1315_ net212 VGND VGND VPWR VPWR u_register_bank.sensor_enable\[29\]
+ sky130_fd_sc_hd__dfrtp_1
X_9159_ net177 _1247_ VGND VGND VPWR VPWR net145 sky130_fd_sc_hd__dfxtp_1
Xhold31 u_sample_counter.sample_count\[0\] VGND VGND VPWR VPWR net243 sky130_fd_sc_hd__buf_1
Xhold20 u_sample_counter.sample_count\[17\] VGND VGND VPWR VPWR net232 sky130_fd_sc_hd__dlygate4sd3_1
Xhold64 u_input_buffer.fifo_mem\[63\]\[4\] VGND VGND VPWR VPWR net276 sky130_fd_sc_hd__dlygate4sd3_1
Xhold42 _1127_ VGND VGND VPWR VPWR net254 sky130_fd_sc_hd__dlygate4sd3_1
Xhold53 u_sensor_interface.sensor_array\[3\]\[3\] VGND VGND VPWR VPWR net265 sky130_fd_sc_hd__dlygate4sd3_1
XFILLER_0_98_633 VGND VGND VPWR VPWR sky130_fd_sc_hd__fill_2
Xhold86 u_input_buffer.fifo_mem\[62\]\[3\] VGND VGND VPWR VPWR net298 sky130_fd_sc_hd__dlygate4sd3_1
Xhold97 u_input_buffer.fifo_mem\[7\]\[14\] VGND VGND VPWR VPWR net309 sky130_fd_sc_hd__dlygate4sd3_1
Xhold75 u_input_buffer.fifo_mem\[52\]\[15\] VGND VGND VPWR VPWR net287 sky130_fd_sc_hd__dlygate4sd3_1
XFILLER_0_97_198 VGND VGND VPWR VPWR sky130_fd_sc_hd__decap_3
XFILLER_0_66_541 VGND VGND VPWR VPWR sky130_fd_sc_hd__decap_4
XFILLER_0_109_665 VGND VGND VPWR VPWR sky130_fd_sc_hd__decap_6
XFILLER_0_93_382 VGND VGND VPWR VPWR sky130_fd_sc_hd__fill_1
XFILLER_0_26_427 VGND VGND VPWR VPWR sky130_fd_sc_hd__decap_4
XFILLER_0_81_577 VGND VGND VPWR VPWR sky130_fd_sc_hd__fill_2
XFILLER_0_22_600 VGND VGND VPWR VPWR sky130_fd_sc_hd__fill_1
XANTENNA_6 _3259_ VGND VGND VPWR VPWR sky130_fd_sc_hd__diode_2
XFILLER_0_61_290 VGND VGND VPWR VPWR sky130_fd_sc_hd__decap_6
XFILLER_0_1_505 VPWR VGND VPWR VGND sky130_ef_sc_hd__decap_12
XFILLER_0_104_392 VGND VGND VPWR VPWR sky130_fd_sc_hd__fill_1
XFILLER_0_6_29 VGND VGND VPWR VPWR sky130_fd_sc_hd__decap_8
XTAP_305 VGND VPWR sky130_fd_sc_hd__tapvpwrvgnd_1
XTAP_349 VGND VPWR sky130_fd_sc_hd__tapvpwrvgnd_1
XTAP_327 VGND VPWR sky130_fd_sc_hd__tapvpwrvgnd_1
XTAP_338 VGND VPWR sky130_fd_sc_hd__tapvpwrvgnd_1
XTAP_316 VGND VPWR sky130_fd_sc_hd__tapvpwrvgnd_1
XFILLER_0_16_41 VPWR VGND VPWR VGND sky130_ef_sc_hd__decap_12
XFILLER_0_107_87 VGND VGND VPWR VPWR sky130_fd_sc_hd__decap_3
X_6860_ u_input_buffer.fifo_mem\[27\]\[1\] _3013_ _3015_ u_input_buffer.fifo_mem\[59\]\[1\]
+ _3110_ VGND VGND VPWR VPWR _3111_ sky130_fd_sc_hd__a221o_1
XFILLER_0_16_85 VGND VGND VPWR VPWR sky130_fd_sc_hd__fill_2
X_6791_ u_input_buffer.fifo_mem\[6\]\[0\] _3035_ _3037_ u_input_buffer.fifo_mem\[28\]\[0\]
+ _3042_ VGND VGND VPWR VPWR _3043_ sky130_fd_sc_hd__a221o_1
X_5811_ net915 _2268_ _2424_ VGND VGND VPWR VPWR _2438_ sky130_fd_sc_hd__mux2_1
X_8530_ clknet_leaf_64_clk _0619_ VGND VGND VPWR VPWR u_input_buffer.fifo_mem\[30\]\[8\]
+ sky130_fd_sc_hd__dfxtp_1
X_5742_ net702 _2268_ _2387_ VGND VGND VPWR VPWR _2401_ sky130_fd_sc_hd__mux2_1
XFILLER_0_115_602 VGND VGND VPWR VPWR sky130_fd_sc_hd__decap_8
XFILLER_0_72_533 VGND VGND VPWR VPWR sky130_fd_sc_hd__decap_3
X_8461_ clknet_leaf_17_clk _0550_ VGND VGND VPWR VPWR u_input_buffer.fifo_mem\[34\]\[3\]
+ sky130_fd_sc_hd__dfxtp_1
X_5673_ _2364_ VGND VGND VPWR VPWR _0686_ sky130_fd_sc_hd__clkbuf_1
X_4624_ net789 _1716_ _1778_ VGND VGND VPWR VPWR _1785_ sky130_fd_sc_hd__mux2_1
X_8392_ clknet_leaf_90_clk _0481_ VGND VGND VPWR VPWR u_input_buffer.fifo_mem\[39\]\[14\]
+ sky130_fd_sc_hd__dfxtp_1
X_7412_ u_input_buffer.fifo_mem\[39\]\[15\] _3049_ _3051_ u_input_buffer.fifo_mem\[40\]\[15\]
+ VGND VGND VPWR VPWR _3649_ sky130_fd_sc_hd__a22o_1
XFILLER_0_32_419 VGND VGND VPWR VPWR sky130_fd_sc_hd__fill_1
XFILLER_0_115_679 VGND VGND VPWR VPWR sky130_fd_sc_hd__fill_1
XFILLER_0_4_365 VGND VGND VPWR VPWR sky130_fd_sc_hd__decap_6
X_7343_ _3563_ _3572_ _3581_ VGND VGND VPWR VPWR _3582_ sky130_fd_sc_hd__or3_1
X_4555_ _1746_ VGND VGND VPWR VPWR _0186_ sky130_fd_sc_hd__clkbuf_1
Xhold501 u_analytics_engine.data_in\[11\] VGND VGND VPWR VPWR net713 sky130_fd_sc_hd__dlygate4sd3_1
XFILLER_0_114_189 VGND VGND VPWR VPWR sky130_fd_sc_hd__decap_6
Xhold523 u_input_buffer.fifo_mem\[36\]\[7\] VGND VGND VPWR VPWR net735 sky130_fd_sc_hd__dlygate4sd3_1
XFILLER_0_102_329 VGND VGND VPWR VPWR sky130_fd_sc_hd__fill_1
Xhold545 u_input_buffer.fifo_mem\[54\]\[9\] VGND VGND VPWR VPWR net757 sky130_fd_sc_hd__dlygate4sd3_1
Xhold534 u_input_buffer.fifo_mem\[51\]\[12\] VGND VGND VPWR VPWR net746 sky130_fd_sc_hd__dlygate4sd3_1
Xhold512 u_input_buffer.fifo_mem\[12\]\[11\] VGND VGND VPWR VPWR net724 sky130_fd_sc_hd__dlygate4sd3_1
Xhold578 u_input_buffer.fifo_mem\[4\]\[0\] VGND VGND VPWR VPWR net790 sky130_fd_sc_hd__dlygate4sd3_1
Xhold567 u_input_buffer.fifo_mem\[3\]\[7\] VGND VGND VPWR VPWR net779 sky130_fd_sc_hd__dlygate4sd3_1
X_7274_ u_input_buffer.fifo_mem\[29\]\[12\] _2938_ _2940_ u_input_buffer.fifo_mem\[13\]\[12\]
+ _3513_ VGND VGND VPWR VPWR _3514_ sky130_fd_sc_hd__a221o_1
Xhold556 u_input_buffer.fifo_mem\[19\]\[12\] VGND VGND VPWR VPWR net768 sky130_fd_sc_hd__dlygate4sd3_1
X_9013_ clknet_leaf_95_clk _1102_ VGND VGND VPWR VPWR u_input_buffer.fifo_mem\[0\]\[11\]
+ sky130_fd_sc_hd__dfxtp_1
X_4486_ _1598_ _1597_ VGND VGND VPWR VPWR _1701_ sky130_fd_sc_hd__and2b_2
X_6225_ _2667_ VGND VGND VPWR VPWR _0935_ sky130_fd_sc_hd__clkbuf_1
Xhold589 u_input_buffer.fifo_mem\[11\]\[13\] VGND VGND VPWR VPWR net801 sky130_fd_sc_hd__dlygate4sd3_1
X_6156_ _2630_ VGND VGND VPWR VPWR _0903_ sky130_fd_sc_hd__clkbuf_1
XTAP_850 VGND VPWR sky130_fd_sc_hd__tapvpwrvgnd_1
XTAP_861 VGND VPWR sky130_fd_sc_hd__tapvpwrvgnd_1
X_5107_ _2054_ VGND VGND VPWR VPWR _0430_ sky130_fd_sc_hd__clkbuf_1
XTAP_883 VGND VPWR sky130_fd_sc_hd__tapvpwrvgnd_1
XTAP_872 VGND VPWR sky130_fd_sc_hd__tapvpwrvgnd_1
XTAP_894 VGND VPWR sky130_fd_sc_hd__tapvpwrvgnd_1
X_6087_ net732 _2508_ _2587_ VGND VGND VPWR VPWR _2593_ sky130_fd_sc_hd__mux2_1
X_5038_ _1456_ VGND VGND VPWR VPWR _2016_ sky130_fd_sc_hd__clkbuf_4
XFILLER_0_95_614 VGND VGND VPWR VPWR sky130_fd_sc_hd__fill_2
XFILLER_0_94_157 VGND VGND VPWR VPWR sky130_fd_sc_hd__decap_4
X_6989_ u_input_buffer.fifo_mem\[54\]\[4\] _3078_ _3080_ u_input_buffer.fifo_mem\[46\]\[4\]
+ VGND VGND VPWR VPWR _3237_ sky130_fd_sc_hd__a22o_1
X_8728_ clknet_leaf_12_clk _0817_ VGND VGND VPWR VPWR u_input_buffer.fifo_mem\[18\]\[14\]
+ sky130_fd_sc_hd__dfxtp_1
XFILLER_0_35_213 VGND VGND VPWR VPWR sky130_fd_sc_hd__fill_2
XFILLER_0_106_602 VGND VGND VPWR VPWR sky130_fd_sc_hd__decap_3
XFILLER_0_75_393 VGND VGND VPWR VPWR sky130_fd_sc_hd__fill_2
X_8659_ clknet_leaf_68_clk _0748_ VGND VGND VPWR VPWR u_input_buffer.fifo_mem\[22\]\[9\]
+ sky130_fd_sc_hd__dfxtp_1
XFILLER_0_63_566 VGND VGND VPWR VPWR sky130_fd_sc_hd__fill_2
XFILLER_0_90_363 VGND VGND VPWR VPWR sky130_fd_sc_hd__fill_1
XFILLER_0_90_352 VGND VGND VPWR VPWR sky130_fd_sc_hd__decap_4
XFILLER_0_63_588 VGND VGND VPWR VPWR sky130_fd_sc_hd__decap_4
XFILLER_0_105_178 VGND VGND VPWR VPWR sky130_fd_sc_hd__fill_1
Xinput110 sensor_valid[0] VGND VGND VPWR VPWR net110 sky130_fd_sc_hd__dlymetal6s2s_1
XFILLER_0_86_669 VGND VGND VPWR VPWR sky130_fd_sc_hd__fill_1
XFILLER_0_85_146 VGND VGND VPWR VPWR sky130_fd_sc_hd__decap_3
XPHY_160 VGND VGND VPWR VPWR sky130_fd_sc_hd__decap_3
XPHY_193 VGND VGND VPWR VPWR sky130_fd_sc_hd__decap_3
XPHY_182 VGND VGND VPWR VPWR sky130_fd_sc_hd__decap_3
XPHY_171 VGND VGND VPWR VPWR sky130_fd_sc_hd__decap_3
XFILLER_0_81_374 VGND VGND VPWR VPWR sky130_fd_sc_hd__fill_1
XFILLER_0_14_408 VGND VGND VPWR VPWR sky130_fd_sc_hd__fill_1
X_4340_ _1613_ VGND VGND VPWR VPWR _0104_ sky130_fd_sc_hd__clkbuf_1
XFILLER_0_10_625 VPWR VGND VPWR VGND sky130_ef_sc_hd__decap_12
XFILLER_0_10_669 VPWR VGND VPWR VGND sky130_ef_sc_hd__decap_12
X_4271_ _1544_ _1545_ _1548_ _1550_ VGND VGND VPWR VPWR _1551_ sky130_fd_sc_hd__a22o_1
XFILLER_0_94_13 VGND VGND VPWR VPWR sky130_fd_sc_hd__fill_2
X_6010_ _2551_ VGND VGND VPWR VPWR _0836_ sky130_fd_sc_hd__clkbuf_1
X_7961_ clknet_leaf_23_clk _0051_ net193 VGND VGND VPWR VPWR u_input_buffer.data_in\[1\]
+ sky130_fd_sc_hd__dfrtp_1
X_6912_ u_input_buffer.fifo_mem\[63\]\[2\] _2887_ _3076_ u_input_buffer.fifo_mem\[55\]\[2\]
+ _3161_ VGND VGND VPWR VPWR _3162_ sky130_fd_sc_hd__a221o_1
X_7892_ clknet_leaf_80_clk net241 net191 VGND VGND VPWR VPWR u_register_bank.status_flags\[12\]
+ sky130_fd_sc_hd__dfrtp_1
X_6843_ u_input_buffer.fifo_mem\[53\]\[1\] _2934_ _2936_ u_input_buffer.fifo_mem\[57\]\[1\]
+ VGND VGND VPWR VPWR _3094_ sky130_fd_sc_hd__a22o_1
XFILLER_0_9_413 VGND VGND VPWR VPWR sky130_fd_sc_hd__decap_4
X_3986_ _1343_ VGND VGND VPWR VPWR _0020_ sky130_fd_sc_hd__clkbuf_1
X_6774_ _2910_ _3018_ VGND VGND VPWR VPWR _3026_ sky130_fd_sc_hd__and2_2
X_8513_ clknet_leaf_45_clk _0602_ VGND VGND VPWR VPWR u_input_buffer.fifo_mem\[31\]\[7\]
+ sky130_fd_sc_hd__dfxtp_1
X_5725_ _2392_ VGND VGND VPWR VPWR _0710_ sky130_fd_sc_hd__clkbuf_1
X_8444_ clknet_leaf_27_clk _0533_ VGND VGND VPWR VPWR u_input_buffer.fifo_mem\[35\]\[2\]
+ sky130_fd_sc_hd__dfxtp_1
XFILLER_0_72_374 VGND VGND VPWR VPWR sky130_fd_sc_hd__decap_4
X_5656_ net978 _2250_ _2352_ VGND VGND VPWR VPWR _2356_ sky130_fd_sc_hd__mux2_1
XFILLER_0_5_641 VPWR VGND VPWR VGND sky130_ef_sc_hd__decap_12
XFILLER_0_17_268 VGND VGND VPWR VPWR sky130_fd_sc_hd__decap_3
XFILLER_0_45_577 VGND VGND VPWR VPWR sky130_fd_sc_hd__decap_4
XFILLER_0_115_443 VGND VGND VPWR VPWR sky130_fd_sc_hd__fill_1
XFILLER_0_72_396 VGND VGND VPWR VPWR sky130_fd_sc_hd__decap_4
X_4607_ u_input_buffer.wr_ptr\[3\] _1598_ VGND VGND VPWR VPWR _1774_ sky130_fd_sc_hd__or2b_1
XFILLER_0_115_487 VGND VGND VPWR VPWR sky130_fd_sc_hd__fill_1
X_5587_ net842 _2250_ _2315_ VGND VGND VPWR VPWR _2319_ sky130_fd_sc_hd__mux2_1
XFILLER_0_5_685 VGND VGND VPWR VPWR sky130_fd_sc_hd__fill_1
X_8375_ clknet_leaf_93_clk _0464_ VGND VGND VPWR VPWR u_input_buffer.fifo_mem\[40\]\[13\]
+ sky130_fd_sc_hd__dfxtp_1
Xhold320 u_input_buffer.fifo_mem\[0\]\[11\] VGND VGND VPWR VPWR net532 sky130_fd_sc_hd__dlygate4sd3_1
Xhold342 u_input_buffer.fifo_mem\[23\]\[6\] VGND VGND VPWR VPWR net554 sky130_fd_sc_hd__dlygate4sd3_1
X_4538_ _1634_ _1736_ VGND VGND VPWR VPWR _1737_ sky130_fd_sc_hd__nand2_4
X_7326_ u_input_buffer.fifo_mem\[8\]\[13\] _3003_ _3005_ u_input_buffer.fifo_mem\[19\]\[13\]
+ _3564_ VGND VGND VPWR VPWR _3565_ sky130_fd_sc_hd__a221o_1
Xhold353 u_input_buffer.fifo_mem\[14\]\[15\] VGND VGND VPWR VPWR net565 sky130_fd_sc_hd__dlygate4sd3_1
Xhold331 u_input_buffer.fifo_mem\[42\]\[13\] VGND VGND VPWR VPWR net543 sky130_fd_sc_hd__dlygate4sd3_1
XFILLER_0_111_671 VGND VGND VPWR VPWR sky130_fd_sc_hd__fill_1
Xhold364 u_input_buffer.fifo_mem\[32\]\[7\] VGND VGND VPWR VPWR net576 sky130_fd_sc_hd__dlygate4sd3_1
Xhold375 u_input_buffer.fifo_mem\[58\]\[3\] VGND VGND VPWR VPWR net587 sky130_fd_sc_hd__dlygate4sd3_1
X_4469_ net943 _1618_ _1683_ VGND VGND VPWR VPWR _1692_ sky130_fd_sc_hd__mux2_1
X_7257_ u_input_buffer.fifo_mem\[23\]\[11\] _3045_ _3047_ u_input_buffer.fifo_mem\[20\]\[11\]
+ _3497_ VGND VGND VPWR VPWR _3498_ sky130_fd_sc_hd__a221o_1
Xhold386 u_input_buffer.fifo_mem\[50\]\[14\] VGND VGND VPWR VPWR net598 sky130_fd_sc_hd__dlygate4sd3_1
Xhold397 u_input_buffer.fifo_mem\[4\]\[3\] VGND VGND VPWR VPWR net609 sky130_fd_sc_hd__dlygate4sd3_1
X_6208_ net801 _2524_ _2643_ VGND VGND VPWR VPWR _2658_ sky130_fd_sc_hd__mux2_1
X_7188_ net257 _3086_ _3088_ VGND VGND VPWR VPWR _3431_ sky130_fd_sc_hd__o21a_1
Xhold1042 u_input_buffer.fifo_mem\[38\]\[3\] VGND VGND VPWR VPWR net1254 sky130_fd_sc_hd__dlygate4sd3_1
Xhold1031 u_input_buffer.fifo_mem\[9\]\[8\] VGND VGND VPWR VPWR net1243 sky130_fd_sc_hd__dlygate4sd3_1
X_6139_ _1628_ net1035 _2606_ VGND VGND VPWR VPWR _2621_ sky130_fd_sc_hd__mux2_1
Xhold1020 u_input_buffer.fifo_mem\[61\]\[10\] VGND VGND VPWR VPWR net1232 sky130_fd_sc_hd__dlygate4sd3_1
XTAP_680 VGND VPWR sky130_fd_sc_hd__tapvpwrvgnd_1
XTAP_691 VGND VPWR sky130_fd_sc_hd__tapvpwrvgnd_1
Xhold1053 u_input_buffer.fifo_mem\[9\]\[1\] VGND VGND VPWR VPWR net1265 sky130_fd_sc_hd__dlygate4sd3_1
Xhold1075 u_input_buffer.fifo_mem\[59\]\[11\] VGND VGND VPWR VPWR net1287 sky130_fd_sc_hd__dlygate4sd3_1
Xhold1064 u_input_buffer.fifo_mem\[61\]\[1\] VGND VGND VPWR VPWR net1276 sky130_fd_sc_hd__dlygate4sd3_1
Xhold1097 u_input_buffer.fifo_mem\[49\]\[3\] VGND VGND VPWR VPWR net1309 sky130_fd_sc_hd__dlygate4sd3_1
Xhold1086 u_input_buffer.fifo_mem\[62\]\[14\] VGND VGND VPWR VPWR net1298 sky130_fd_sc_hd__dlygate4sd3_1
XFILLER_0_67_113 VGND VGND VPWR VPWR sky130_fd_sc_hd__decap_6
XFILLER_0_67_102 VGND VGND VPWR VPWR sky130_fd_sc_hd__decap_4
XFILLER_0_83_617 VGND VGND VPWR VPWR sky130_fd_sc_hd__decap_6
XFILLER_0_67_135 VGND VGND VPWR VPWR sky130_fd_sc_hd__fill_2
XFILLER_0_106_421 VGND VGND VPWR VPWR sky130_fd_sc_hd__fill_2
XFILLER_0_51_503 VGND VGND VPWR VPWR sky130_fd_sc_hd__fill_1
XFILLER_0_23_249 VGND VGND VPWR VPWR sky130_fd_sc_hd__decap_4
XFILLER_0_104_77 VGND VGND VPWR VPWR sky130_fd_sc_hd__decap_6
XFILLER_0_82_672 VPWR VGND VPWR VGND sky130_ef_sc_hd__decap_12
XFILLER_0_13_86 VGND VGND VPWR VPWR sky130_fd_sc_hd__fill_1
X_5510_ _2276_ VGND VGND VPWR VPWR _2277_ sky130_fd_sc_hd__buf_4
XFILLER_0_54_363 VGND VGND VPWR VPWR sky130_fd_sc_hd__fill_1
X_6490_ _2808_ VGND VGND VPWR VPWR _1059_ sky130_fd_sc_hd__clkbuf_1
X_5441_ net664 _2006_ _2223_ VGND VGND VPWR VPWR _2232_ sky130_fd_sc_hd__mux2_1
X_5372_ _2195_ VGND VGND VPWR VPWR _0554_ sky130_fd_sc_hd__clkbuf_1
X_8160_ clknet_leaf_7_clk _0249_ VGND VGND VPWR VPWR u_input_buffer.fifo_mem\[53\]\[6\]
+ sky130_fd_sc_hd__dfxtp_1
X_7111_ u_analytics_engine.data_in\[7\] _2893_ _3354_ _3355_ VGND VGND VPWR VPWR _1133_
+ sky130_fd_sc_hd__a22o_1
X_4323_ _1601_ VGND VGND VPWR VPWR _1602_ sky130_fd_sc_hd__clkbuf_4
X_8091_ clknet_leaf_3_clk _0180_ VGND VGND VPWR VPWR u_input_buffer.fifo_mem\[57\]\[1\]
+ sky130_fd_sc_hd__dfxtp_1
X_7042_ u_input_buffer.fifo_mem\[14\]\[6\] _2958_ _2961_ u_input_buffer.fifo_mem\[42\]\[6\]
+ VGND VGND VPWR VPWR _3288_ sky130_fd_sc_hd__a22o_1
X_4254_ u_analytics_engine.data_in\[15\] VGND VGND VPWR VPWR _1534_ sky130_fd_sc_hd__inv_2
X_4185_ _1487_ _1488_ VGND VGND VPWR VPWR _1489_ sky130_fd_sc_hd__and2b_1
X_8993_ clknet_leaf_8_clk _1082_ VGND VGND VPWR VPWR u_input_buffer.fifo_mem\[1\]\[7\]
+ sky130_fd_sc_hd__dfxtp_1
X_7944_ clknet_leaf_33_clk _0034_ VGND VGND VPWR VPWR u_sensor_interface.sensor_array\[0\]\[0\]
+ sky130_fd_sc_hd__dfxtp_1
XTAP_1109 VGND VPWR sky130_fd_sc_hd__tapvpwrvgnd_1
X_7875_ _3937_ VGND VGND VPWR VPWR _1315_ sky130_fd_sc_hd__clkbuf_1
X_6826_ _3077_ VGND VGND VPWR VPWR _3078_ sky130_fd_sc_hd__clkbuf_4
XFILLER_0_70_70 VGND VGND VPWR VPWR sky130_fd_sc_hd__fill_2
XFILLER_0_9_265 VGND VGND VPWR VPWR sky130_fd_sc_hd__fill_1
XFILLER_0_18_533 VGND VGND VPWR VPWR sky130_fd_sc_hd__fill_2
X_6757_ _3008_ VGND VGND VPWR VPWR _3009_ sky130_fd_sc_hd__clkbuf_4
X_3969_ u_sensor_interface.sensor_array\[2\]\[10\] net82 _1334_ VGND VGND VPWR VPWR
+ _1335_ sky130_fd_sc_hd__mux2_1
XFILLER_0_9_298 VGND VGND VPWR VPWR sky130_fd_sc_hd__fill_1
X_5708_ _1626_ net989 _2369_ VGND VGND VPWR VPWR _2383_ sky130_fd_sc_hd__mux2_1
XFILLER_0_115_251 VGND VGND VPWR VPWR sky130_fd_sc_hd__fill_1
X_6688_ _2902_ _2930_ VGND VGND VPWR VPWR _2940_ sky130_fd_sc_hd__nor2_4
XFILLER_0_33_514 VGND VGND VPWR VPWR sky130_fd_sc_hd__decap_4
XFILLER_0_45_385 VGND VGND VPWR VPWR sky130_fd_sc_hd__fill_1
X_8427_ clknet_leaf_28_clk _0516_ VGND VGND VPWR VPWR u_input_buffer.fifo_mem\[36\]\[1\]
+ sky130_fd_sc_hd__dfxtp_1
X_5639_ _2346_ VGND VGND VPWR VPWR _0670_ sky130_fd_sc_hd__clkbuf_1
XFILLER_0_33_569 VGND VGND VPWR VPWR sky130_fd_sc_hd__decap_4
XFILLER_0_5_493 VGND VGND VPWR VPWR sky130_fd_sc_hd__decap_8
X_8358_ clknet_leaf_106_clk _0447_ VGND VGND VPWR VPWR u_input_buffer.fifo_mem\[41\]\[12\]
+ sky130_fd_sc_hd__dfxtp_1
Xhold161 u_input_buffer.fifo_mem\[23\]\[3\] VGND VGND VPWR VPWR net373 sky130_fd_sc_hd__dlygate4sd3_1
Xhold150 u_input_buffer.fifo_mem\[54\]\[6\] VGND VGND VPWR VPWR net362 sky130_fd_sc_hd__dlygate4sd3_1
X_7309_ u_input_buffer.fifo_mem\[37\]\[13\] _2922_ _2925_ u_input_buffer.fifo_mem\[9\]\[13\]
+ VGND VGND VPWR VPWR _3548_ sky130_fd_sc_hd__a22o_1
Xhold172 u_input_buffer.fifo_mem\[43\]\[9\] VGND VGND VPWR VPWR net384 sky130_fd_sc_hd__dlygate4sd3_1
Xhold194 u_input_buffer.fifo_mem\[11\]\[8\] VGND VGND VPWR VPWR net406 sky130_fd_sc_hd__dlygate4sd3_1
X_8289_ clknet_leaf_18_clk _0378_ VGND VGND VPWR VPWR u_input_buffer.fifo_mem\[45\]\[7\]
+ sky130_fd_sc_hd__dfxtp_1
Xhold183 u_input_buffer.fifo_mem\[14\]\[11\] VGND VGND VPWR VPWR net395 sky130_fd_sc_hd__dlygate4sd3_1
XTAP_1632 VGND VPWR sky130_fd_sc_hd__tapvpwrvgnd_1
XTAP_1621 VGND VPWR sky130_fd_sc_hd__tapvpwrvgnd_1
XTAP_1610 VGND VPWR sky130_fd_sc_hd__tapvpwrvgnd_1
XTAP_1643 VGND VPWR sky130_fd_sc_hd__tapvpwrvgnd_1
XFILLER_0_50_29 VGND VGND VPWR VPWR sky130_fd_sc_hd__decap_3
XFILLER_0_36_341 VGND VGND VPWR VPWR sky130_fd_sc_hd__fill_1
XFILLER_0_75_15 VPWR VGND VPWR VGND sky130_ef_sc_hd__decap_12
XFILLER_0_115_21 VGND VGND VPWR VPWR sky130_fd_sc_hd__decap_3
X_5990_ _2540_ VGND VGND VPWR VPWR _0827_ sky130_fd_sc_hd__clkbuf_1
X_4941_ _1958_ VGND VGND VPWR VPWR _0360_ sky130_fd_sc_hd__clkbuf_1
XFILLER_0_91_69 VGND VGND VPWR VPWR sky130_fd_sc_hd__decap_4
XFILLER_0_115_65 VPWR VGND VPWR VGND sky130_ef_sc_hd__decap_12
X_7660_ _3795_ VGND VGND VPWR VPWR _1242_ sky130_fd_sc_hd__clkbuf_1
X_4872_ net1140 _1718_ _1912_ VGND VGND VPWR VPWR _1920_ sky130_fd_sc_hd__mux2_1
XFILLER_0_24_85 VGND VGND VPWR VPWR sky130_fd_sc_hd__fill_2
XFILLER_0_47_617 VGND VGND VPWR VPWR sky130_fd_sc_hd__decap_3
X_6611_ _2872_ _2873_ _2860_ VGND VGND VPWR VPWR _2874_ sky130_fd_sc_hd__and3_1
XFILLER_0_46_149 VGND VGND VPWR VPWR sky130_fd_sc_hd__decap_4
X_7591_ net15 u_analytics_engine.threshold\[12\] _3748_ VGND VGND VPWR VPWR _3751_
+ sky130_fd_sc_hd__mux2_1
XFILLER_0_40_51 VGND VGND VPWR VPWR sky130_fd_sc_hd__fill_2
X_6542_ _2835_ VGND VGND VPWR VPWR _1084_ sky130_fd_sc_hd__clkbuf_1
X_6473_ net383 _1432_ _2789_ VGND VGND VPWR VPWR _2799_ sky130_fd_sc_hd__mux2_1
X_5424_ _2222_ VGND VGND VPWR VPWR _2223_ sky130_fd_sc_hd__buf_4
X_8212_ clknet_leaf_14_clk _0301_ VGND VGND VPWR VPWR u_input_buffer.fifo_mem\[50\]\[10\]
+ sky130_fd_sc_hd__dfxtp_1
X_9192_ clknet_leaf_78_clk _1280_ net192 VGND VGND VPWR VPWR net149 sky130_fd_sc_hd__dfrtp_1
X_8143_ clknet_leaf_34_clk _0232_ VGND VGND VPWR VPWR u_input_buffer.fifo_mem\[54\]\[5\]
+ sky130_fd_sc_hd__dfxtp_1
X_5355_ _1872_ _1930_ VGND VGND VPWR VPWR _2186_ sky130_fd_sc_hd__nor2_4
X_8074_ clknet_leaf_54_clk _0163_ VGND VGND VPWR VPWR u_input_buffer.fifo_mem\[58\]\[0\]
+ sky130_fd_sc_hd__dfxtp_1
X_5286_ _2149_ VGND VGND VPWR VPWR _0514_ sky130_fd_sc_hd__clkbuf_1
X_4306_ _1554_ _1584_ _1585_ _1575_ VGND VGND VPWR VPWR _1586_ sky130_fd_sc_hd__o2bb2a_1
X_7025_ u_input_buffer.fifo_mem\[10\]\[5\] _3056_ _3058_ u_input_buffer.fifo_mem\[44\]\[5\]
+ _3271_ VGND VGND VPWR VPWR _3272_ sky130_fd_sc_hd__a221o_1
X_4237_ _1522_ _1523_ VGND VGND VPWR VPWR _1524_ sky130_fd_sc_hd__and2b_1
X_4168_ net220 _1476_ VGND VGND VPWR VPWR _1478_ sky130_fd_sc_hd__nor2_1
X_8976_ clknet_leaf_30_clk _1065_ VGND VGND VPWR VPWR u_input_buffer.fifo_mem\[2\]\[6\]
+ sky130_fd_sc_hd__dfxtp_1
X_4099_ u_input_buffer.data_in\[7\] VGND VGND VPWR VPWR _1420_ sky130_fd_sc_hd__clkbuf_4
X_7927_ clknet_leaf_110_clk _0017_ VGND VGND VPWR VPWR u_sensor_interface.sensor_array\[2\]\[15\]
+ sky130_fd_sc_hd__dfxtp_1
X_7858_ net25 u_register_bank.sensor_enable\[21\] _3927_ VGND VGND VPWR VPWR _3929_
+ sky130_fd_sc_hd__mux2_1
XFILLER_0_38_639 VGND VGND VPWR VPWR sky130_fd_sc_hd__decap_4
XFILLER_0_65_447 VGND VGND VPWR VPWR sky130_fd_sc_hd__fill_1
XFILLER_0_65_436 VGND VGND VPWR VPWR sky130_fd_sc_hd__decap_8
X_6809_ _2896_ _2991_ VGND VGND VPWR VPWR _3061_ sky130_fd_sc_hd__nor2_2
X_7789_ net1318 u_analytics_engine.data_in\[5\] _1474_ VGND VGND VPWR VPWR _3892_
+ sky130_fd_sc_hd__mux2_1
XFILLER_0_61_642 VGND VGND VPWR VPWR sky130_fd_sc_hd__decap_6
XFILLER_0_33_344 VGND VGND VPWR VPWR sky130_fd_sc_hd__decap_4
XTAP_1440 VGND VPWR sky130_fd_sc_hd__tapvpwrvgnd_1
XTAP_1451 VGND VPWR sky130_fd_sc_hd__tapvpwrvgnd_1
XFILLER_0_96_583 VGND VGND VPWR VPWR sky130_fd_sc_hd__decap_4
XTAP_1484 VGND VPWR sky130_fd_sc_hd__tapvpwrvgnd_1
XTAP_1473 VGND VPWR sky130_fd_sc_hd__tapvpwrvgnd_1
XTAP_1462 VGND VPWR sky130_fd_sc_hd__tapvpwrvgnd_1
XTAP_1495 VGND VPWR sky130_fd_sc_hd__tapvpwrvgnd_1
XFILLER_0_71_406 VGND VGND VPWR VPWR sky130_fd_sc_hd__decap_4
XFILLER_0_37_650 VGND VGND VPWR VPWR sky130_fd_sc_hd__decap_3
Xhold919 u_input_buffer.fifo_mem\[46\]\[1\] VGND VGND VPWR VPWR net1131 sky130_fd_sc_hd__dlygate4sd3_1
Xhold908 u_input_buffer.fifo_mem\[45\]\[7\] VGND VGND VPWR VPWR net1120 sky130_fd_sc_hd__dlygate4sd3_1
X_5140_ _1445_ net780 _2059_ VGND VGND VPWR VPWR _2072_ sky130_fd_sc_hd__mux2_1
X_5071_ _2035_ VGND VGND VPWR VPWR _0413_ sky130_fd_sc_hd__clkbuf_1
XFILLER_0_19_63 VGND VGND VPWR VPWR sky130_fd_sc_hd__fill_1
X_4022_ _1362_ VGND VGND VPWR VPWR _0037_ sky130_fd_sc_hd__clkbuf_1
XFILLER_0_19_96 VGND VGND VPWR VPWR sky130_fd_sc_hd__decap_8
X_8830_ clknet_leaf_16_clk _0919_ VGND VGND VPWR VPWR u_input_buffer.fifo_mem\[11\]\[4\]
+ sky130_fd_sc_hd__dfxtp_1
X_5973_ _1588_ net1280 _2531_ VGND VGND VPWR VPWR _2532_ sky130_fd_sc_hd__mux2_1
X_8761_ clknet_leaf_99_clk _0850_ VGND VGND VPWR VPWR u_input_buffer.fifo_mem\[16\]\[15\]
+ sky130_fd_sc_hd__dfxtp_1
XFILLER_0_59_241 VGND VGND VPWR VPWR sky130_fd_sc_hd__fill_1
X_7712_ _3835_ net121 _3817_ VGND VGND VPWR VPWR _3836_ sky130_fd_sc_hd__mux2_1
X_4924_ net1000 _1732_ _1933_ VGND VGND VPWR VPWR _1949_ sky130_fd_sc_hd__mux2_1
X_8692_ clknet_leaf_71_clk _0781_ VGND VGND VPWR VPWR u_input_buffer.fifo_mem\[20\]\[10\]
+ sky130_fd_sc_hd__dfxtp_1
X_7643_ _3780_ net114 _3782_ VGND VGND VPWR VPWR _3783_ sky130_fd_sc_hd__mux2_1
X_4855_ _1597_ _1598_ _1658_ VGND VGND VPWR VPWR _1910_ sky130_fd_sc_hd__or3b_4
X_7574_ net38 u_analytics_engine.threshold\[4\] _3737_ VGND VGND VPWR VPWR _3742_
+ sky130_fd_sc_hd__mux2_1
X_4786_ _1592_ _1872_ VGND VGND VPWR VPWR _1873_ sky130_fd_sc_hd__nor2_4
XFILLER_0_7_588 VPWR VGND VPWR VGND sky130_ef_sc_hd__decap_12
X_6525_ _1604_ net1012 _2825_ VGND VGND VPWR VPWR _2827_ sky130_fd_sc_hd__mux2_1
XFILLER_0_70_472 VGND VGND VPWR VPWR sky130_fd_sc_hd__decap_4
XFILLER_0_42_141 VGND VGND VPWR VPWR sky130_fd_sc_hd__fill_2
X_6456_ _2790_ VGND VGND VPWR VPWR _1043_ sky130_fd_sc_hd__clkbuf_1
XFILLER_0_113_585 VPWR VGND VPWR VGND sky130_ef_sc_hd__decap_12
X_9175_ net177 _1263_ VGND VGND VPWR VPWR net131 sky130_fd_sc_hd__dfxtp_2
XFILLER_0_11_561 VPWR VGND VPWR VGND sky130_ef_sc_hd__decap_12
X_6387_ _1588_ net1031 _2753_ VGND VGND VPWR VPWR _2754_ sky130_fd_sc_hd__mux2_1
X_5407_ _1427_ net1136 _2205_ VGND VGND VPWR VPWR _2214_ sky130_fd_sc_hd__mux2_1
X_5338_ _2177_ VGND VGND VPWR VPWR _0538_ sky130_fd_sc_hd__clkbuf_1
X_8126_ clknet_leaf_36_clk _0215_ VGND VGND VPWR VPWR u_input_buffer.fifo_mem\[55\]\[4\]
+ sky130_fd_sc_hd__dfxtp_1
X_8057_ clknet_leaf_88_clk _0146_ VGND VGND VPWR VPWR u_input_buffer.fifo_mem\[60\]\[15\]
+ sky130_fd_sc_hd__dfxtp_1
X_7008_ u_input_buffer.fifo_mem\[12\]\[5\] _2980_ _2982_ u_input_buffer.fifo_mem\[18\]\[5\]
+ _3254_ VGND VGND VPWR VPWR _3255_ sky130_fd_sc_hd__a221o_1
X_5269_ _1421_ net887 _2133_ VGND VGND VPWR VPWR _2141_ sky130_fd_sc_hd__mux2_1
X_8959_ clknet_leaf_44_clk _1048_ VGND VGND VPWR VPWR u_input_buffer.fifo_mem\[3\]\[5\]
+ sky130_fd_sc_hd__dfxtp_1
XFILLER_0_65_222 VGND VGND VPWR VPWR sky130_fd_sc_hd__fill_2
XFILLER_0_25_108 VGND VGND VPWR VPWR sky130_fd_sc_hd__fill_1
XFILLER_0_34_642 VGND VGND VPWR VPWR sky130_fd_sc_hd__fill_2
XFILLER_0_33_163 VGND VGND VPWR VPWR sky130_fd_sc_hd__decap_4
XTAP_509 VGND VPWR sky130_fd_sc_hd__tapvpwrvgnd_1
XFILLER_0_88_325 VGND VGND VPWR VPWR sky130_fd_sc_hd__decap_4
XFILLER_0_72_27 VGND VGND VPWR VPWR sky130_fd_sc_hd__fill_1
XTAP_1292 VGND VPWR sky130_fd_sc_hd__tapvpwrvgnd_1
XTAP_1270 VGND VPWR sky130_fd_sc_hd__tapvpwrvgnd_1
XTAP_1281 VGND VPWR sky130_fd_sc_hd__tapvpwrvgnd_1
XFILLER_0_84_597 VGND VGND VPWR VPWR sky130_fd_sc_hd__fill_1
XFILLER_0_71_225 VGND VGND VPWR VPWR sky130_fd_sc_hd__fill_1
X_4640_ net368 _1732_ _1777_ VGND VGND VPWR VPWR _1793_ sky130_fd_sc_hd__mux2_1
XFILLER_0_112_77 VGND VGND VPWR VPWR sky130_fd_sc_hd__decap_6
X_4571_ _1754_ VGND VGND VPWR VPWR _0194_ sky130_fd_sc_hd__clkbuf_1
X_6310_ net678 _2524_ _2697_ VGND VGND VPWR VPWR _2712_ sky130_fd_sc_hd__mux2_1
Xhold727 u_input_buffer.fifo_mem\[55\]\[7\] VGND VGND VPWR VPWR net939 sky130_fd_sc_hd__dlygate4sd3_1
Xhold705 u_input_buffer.fifo_mem\[26\]\[15\] VGND VGND VPWR VPWR net917 sky130_fd_sc_hd__dlygate4sd3_1
XFILLER_0_4_569 VPWR VGND VPWR VGND sky130_ef_sc_hd__decap_12
X_7290_ u_input_buffer.fifo_mem\[30\]\[12\] _3028_ _3030_ u_input_buffer.fifo_mem\[58\]\[12\]
+ VGND VGND VPWR VPWR _3530_ sky130_fd_sc_hd__a22o_1
Xhold716 u_input_buffer.fifo_mem\[8\]\[11\] VGND VGND VPWR VPWR net928 sky130_fd_sc_hd__dlygate4sd3_1
XFILLER_0_97_57 VPWR VGND VPWR VGND sky130_ef_sc_hd__decap_12
Xhold749 u_input_buffer.fifo_mem\[18\]\[10\] VGND VGND VPWR VPWR net961 sky130_fd_sc_hd__dlygate4sd3_1
Xhold738 u_input_buffer.fifo_mem\[53\]\[7\] VGND VGND VPWR VPWR net950 sky130_fd_sc_hd__dlygate4sd3_1
X_6241_ _2675_ VGND VGND VPWR VPWR _0943_ sky130_fd_sc_hd__clkbuf_1
X_6172_ _2638_ VGND VGND VPWR VPWR _0911_ sky130_fd_sc_hd__clkbuf_1
X_5123_ _2063_ VGND VGND VPWR VPWR _0437_ sky130_fd_sc_hd__clkbuf_1
X_5054_ net1005 _1994_ _2024_ VGND VGND VPWR VPWR _2027_ sky130_fd_sc_hd__mux2_1
XFILLER_0_46_61 VGND VGND VPWR VPWR sky130_fd_sc_hd__fill_1
X_4005_ _1353_ VGND VGND VPWR VPWR _0029_ sky130_fd_sc_hd__clkbuf_1
X_8813_ clknet_leaf_18_clk _0902_ VGND VGND VPWR VPWR u_input_buffer.fifo_mem\[12\]\[3\]
+ sky130_fd_sc_hd__dfxtp_1
XFILLER_0_1_30 VPWR VGND VPWR VGND sky130_ef_sc_hd__decap_12
XFILLER_0_94_306 VGND VGND VPWR VPWR sky130_fd_sc_hd__fill_2
XFILLER_0_62_60 VGND VGND VPWR VPWR sky130_fd_sc_hd__fill_1
X_8744_ clknet_leaf_103_clk _0833_ VGND VGND VPWR VPWR u_input_buffer.fifo_mem\[17\]\[14\]
+ sky130_fd_sc_hd__dfxtp_1
X_5956_ _1444_ VGND VGND VPWR VPWR _2520_ sky130_fd_sc_hd__clkbuf_4
XFILLER_0_47_211 VGND VGND VPWR VPWR sky130_fd_sc_hd__decap_4
X_4907_ _1940_ VGND VGND VPWR VPWR _0344_ sky130_fd_sc_hd__clkbuf_1
X_5887_ _1853_ _2242_ VGND VGND VPWR VPWR _2478_ sky130_fd_sc_hd__nor2_4
X_8675_ clknet_leaf_5_clk _0764_ VGND VGND VPWR VPWR u_input_buffer.fifo_mem\[21\]\[9\]
+ sky130_fd_sc_hd__dfxtp_1
X_4838_ _1901_ VGND VGND VPWR VPWR _0314_ sky130_fd_sc_hd__clkbuf_1
X_7626_ net33 u_register_bank.threshold_cfg\[29\] _3759_ VGND VGND VPWR VPWR _3769_
+ sky130_fd_sc_hd__mux2_1
X_7557_ net33 u_register_bank.window_cfg\[29\] _3722_ VGND VGND VPWR VPWR _3732_ sky130_fd_sc_hd__mux2_1
X_4769_ net544 _1720_ _1855_ VGND VGND VPWR VPWR _1864_ sky130_fd_sc_hd__mux2_1
XFILLER_0_50_409 VGND VGND VPWR VPWR sky130_fd_sc_hd__fill_2
XFILLER_0_70_291 VGND VGND VPWR VPWR sky130_fd_sc_hd__fill_1
X_6508_ _2817_ VGND VGND VPWR VPWR _1068_ sky130_fd_sc_hd__clkbuf_1
X_7488_ _3693_ VGND VGND VPWR VPWR _1172_ sky130_fd_sc_hd__clkbuf_1
X_9227_ net178 _1314_ net212 VGND VGND VPWR VPWR u_register_bank.sensor_enable\[28\]
+ sky130_fd_sc_hd__dfrtp_1
X_6439_ net762 _1432_ _2771_ VGND VGND VPWR VPWR _2781_ sky130_fd_sc_hd__mux2_1
XFILLER_0_113_393 VGND VGND VPWR VPWR sky130_fd_sc_hd__decap_6
X_9158_ net179 _1246_ VGND VGND VPWR VPWR net144 sky130_fd_sc_hd__dfxtp_1
XFILLER_0_87_90 VGND VGND VPWR VPWR sky130_fd_sc_hd__decap_3
X_8109_ clknet_leaf_68_clk _0198_ VGND VGND VPWR VPWR u_input_buffer.fifo_mem\[56\]\[3\]
+ sky130_fd_sc_hd__dfxtp_1
Xhold21 u_sample_counter.sample_count\[3\] VGND VGND VPWR VPWR net233 sky130_fd_sc_hd__dlygate4sd3_1
X_9089_ net174 _1177_ net206 VGND VGND VPWR VPWR u_register_bank.window_cfg\[3\] sky130_fd_sc_hd__dfstp_1
Xhold32 u_sample_counter.sample_count\[16\] VGND VGND VPWR VPWR net244 sky130_fd_sc_hd__dlygate4sd3_1
Xhold10 u_sample_counter.sample_count\[11\] VGND VGND VPWR VPWR net222 sky130_fd_sc_hd__dlygate4sd3_1
Xhold65 u_sensor_interface.sensor_array\[3\]\[2\] VGND VGND VPWR VPWR net277 sky130_fd_sc_hd__dlygate4sd3_1
Xhold54 u_input_buffer.fifo_mem\[22\]\[14\] VGND VGND VPWR VPWR net266 sky130_fd_sc_hd__dlygate4sd3_1
Xhold43 u_input_buffer.wr_ptr\[1\] VGND VGND VPWR VPWR net255 sky130_fd_sc_hd__dlygate4sd3_1
XFILLER_0_98_623 VGND VGND VPWR VPWR sky130_fd_sc_hd__fill_2
Xhold76 u_input_buffer.fifo_mem\[32\]\[5\] VGND VGND VPWR VPWR net288 sky130_fd_sc_hd__dlygate4sd3_1
Xhold87 u_input_buffer.fifo_mem\[10\]\[8\] VGND VGND VPWR VPWR net299 sky130_fd_sc_hd__dlygate4sd3_1
Xhold98 u_input_buffer.fifo_mem\[16\]\[9\] VGND VGND VPWR VPWR net310 sky130_fd_sc_hd__dlygate4sd3_1
XFILLER_0_97_166 VGND VGND VPWR VPWR sky130_fd_sc_hd__fill_2
XFILLER_0_85_328 VGND VGND VPWR VPWR sky130_fd_sc_hd__fill_1
XFILLER_0_66_531 VGND VGND VPWR VPWR sky130_fd_sc_hd__fill_1
XFILLER_0_109_655 VGND VGND VPWR VPWR sky130_fd_sc_hd__fill_1
XFILLER_0_108_121 VGND VGND VPWR VPWR sky130_fd_sc_hd__decap_3
XFILLER_0_53_203 VGND VGND VPWR VPWR sky130_fd_sc_hd__fill_2
XANTENNA_7 _3297_ VGND VGND VPWR VPWR sky130_fd_sc_hd__diode_2
XFILLER_0_1_517 VGND VGND VPWR VPWR sky130_fd_sc_hd__fill_2
XFILLER_0_22_645 VGND VGND VPWR VPWR sky130_fd_sc_hd__fill_2
XFILLER_0_22_667 VGND VGND VPWR VPWR sky130_fd_sc_hd__fill_2
XTAP_306 VGND VPWR sky130_fd_sc_hd__tapvpwrvgnd_1
XTAP_339 VGND VPWR sky130_fd_sc_hd__tapvpwrvgnd_1
XTAP_317 VGND VPWR sky130_fd_sc_hd__tapvpwrvgnd_1
XTAP_328 VGND VPWR sky130_fd_sc_hd__tapvpwrvgnd_1
XFILLER_0_83_15 VPWR VGND VPWR VGND sky130_ef_sc_hd__decap_12
XFILLER_0_107_55 VGND VGND VPWR VPWR sky130_fd_sc_hd__fill_1
XFILLER_0_16_53 VPWR VGND VPWR VGND sky130_ef_sc_hd__decap_12
X_6790_ u_input_buffer.fifo_mem\[52\]\[0\] _3039_ _3041_ u_input_buffer.fifo_mem\[56\]\[0\]
+ VGND VGND VPWR VPWR _3042_ sky130_fd_sc_hd__a22o_1
XFILLER_0_76_339 VGND VGND VPWR VPWR sky130_fd_sc_hd__decap_3
XFILLER_0_9_617 VPWR VGND VPWR VGND sky130_ef_sc_hd__decap_12
X_5810_ _2437_ VGND VGND VPWR VPWR _0750_ sky130_fd_sc_hd__clkbuf_1
X_5741_ _2400_ VGND VGND VPWR VPWR _0718_ sky130_fd_sc_hd__clkbuf_1
X_8460_ clknet_leaf_25_clk _0549_ VGND VGND VPWR VPWR u_input_buffer.fifo_mem\[34\]\[2\]
+ sky130_fd_sc_hd__dfxtp_1
XFILLER_0_32_41 VGND VGND VPWR VPWR sky130_fd_sc_hd__fill_1
X_5672_ net559 _2266_ _2351_ VGND VGND VPWR VPWR _2364_ sky130_fd_sc_hd__mux2_1
X_7411_ _3641_ _3643_ _3645_ _3647_ VGND VGND VPWR VPWR _3648_ sky130_fd_sc_hd__or4_1
XFILLER_0_114_124 VPWR VGND VPWR VGND sky130_ef_sc_hd__decap_12
X_4623_ _1784_ VGND VGND VPWR VPWR _0216_ sky130_fd_sc_hd__clkbuf_1
XFILLER_0_4_322 VGND VGND VPWR VPWR sky130_fd_sc_hd__fill_1
X_8391_ clknet_leaf_92_clk _0480_ VGND VGND VPWR VPWR u_input_buffer.fifo_mem\[39\]\[13\]
+ sky130_fd_sc_hd__dfxtp_1
Xhold502 u_input_buffer.fifo_mem\[40\]\[7\] VGND VGND VPWR VPWR net714 sky130_fd_sc_hd__dlygate4sd3_1
X_7342_ _3574_ _3576_ _3578_ _3580_ VGND VGND VPWR VPWR _3581_ sky130_fd_sc_hd__or4_1
X_4554_ _1421_ net760 _1738_ VGND VGND VPWR VPWR _1746_ sky130_fd_sc_hd__mux2_1
Xhold513 u_input_buffer.fifo_mem\[63\]\[7\] VGND VGND VPWR VPWR net725 sky130_fd_sc_hd__dlygate4sd3_1
Xhold524 u_input_buffer.fifo_mem\[18\]\[6\] VGND VGND VPWR VPWR net736 sky130_fd_sc_hd__dlygate4sd3_1
Xhold535 u_input_buffer.fifo_mem\[12\]\[8\] VGND VGND VPWR VPWR net747 sky130_fd_sc_hd__dlygate4sd3_1
X_7273_ u_input_buffer.fifo_mem\[17\]\[12\] _2942_ _2944_ u_input_buffer.fifo_mem\[5\]\[12\]
+ VGND VGND VPWR VPWR _3513_ sky130_fd_sc_hd__a22o_1
Xhold546 u_input_buffer.fifo_mem\[39\]\[9\] VGND VGND VPWR VPWR net758 sky130_fd_sc_hd__dlygate4sd3_1
Xhold557 u_input_buffer.fifo_mem\[50\]\[5\] VGND VGND VPWR VPWR net769 sky130_fd_sc_hd__dlygate4sd3_1
X_6224_ net525 _2506_ _2662_ VGND VGND VPWR VPWR _2667_ sky130_fd_sc_hd__mux2_1
X_4485_ _1376_ VGND VGND VPWR VPWR _1700_ sky130_fd_sc_hd__clkbuf_4
Xhold579 u_input_buffer.fifo_mem\[3\]\[15\] VGND VGND VPWR VPWR net791 sky130_fd_sc_hd__dlygate4sd3_1
Xhold568 u_input_buffer.fifo_mem\[41\]\[11\] VGND VGND VPWR VPWR net780 sky130_fd_sc_hd__dlygate4sd3_1
XFILLER_0_40_475 VGND VGND VPWR VPWR sky130_fd_sc_hd__fill_1
X_9012_ clknet_leaf_71_clk _1101_ VGND VGND VPWR VPWR u_input_buffer.fifo_mem\[0\]\[10\]
+ sky130_fd_sc_hd__dfxtp_1
XFILLER_0_110_374 VGND VGND VPWR VPWR sky130_fd_sc_hd__fill_2
XFILLER_0_0_561 VGND VGND VPWR VPWR sky130_fd_sc_hd__decap_4
X_6155_ net393 _2506_ _2625_ VGND VGND VPWR VPWR _2630_ sky130_fd_sc_hd__mux2_1
XFILLER_0_0_594 VGND VGND VPWR VPWR sky130_fd_sc_hd__decap_8
XTAP_840 VGND VPWR sky130_fd_sc_hd__tapvpwrvgnd_1
XTAP_851 VGND VPWR sky130_fd_sc_hd__tapvpwrvgnd_1
XTAP_862 VGND VPWR sky130_fd_sc_hd__tapvpwrvgnd_1
X_6086_ _2592_ VGND VGND VPWR VPWR _0871_ sky130_fd_sc_hd__clkbuf_1
X_5106_ net904 _2012_ _2041_ VGND VGND VPWR VPWR _2054_ sky130_fd_sc_hd__mux2_1
XTAP_884 VGND VPWR sky130_fd_sc_hd__tapvpwrvgnd_1
XTAP_873 VGND VPWR sky130_fd_sc_hd__tapvpwrvgnd_1
XTAP_895 VGND VPWR sky130_fd_sc_hd__tapvpwrvgnd_1
X_5037_ _2015_ VGND VGND VPWR VPWR _0399_ sky130_fd_sc_hd__clkbuf_1
XFILLER_0_79_133 VGND VGND VPWR VPWR sky130_fd_sc_hd__decap_3
X_6988_ u_input_buffer.fifo_mem\[26\]\[4\] _3066_ _3068_ u_input_buffer.fifo_mem\[62\]\[4\]
+ _3235_ VGND VGND VPWR VPWR _3236_ sky130_fd_sc_hd__a221o_1
XFILLER_0_48_553 VGND VGND VPWR VPWR sky130_fd_sc_hd__decap_3
X_8727_ clknet_leaf_11_clk _0816_ VGND VGND VPWR VPWR u_input_buffer.fifo_mem\[18\]\[13\]
+ sky130_fd_sc_hd__dfxtp_1
X_5939_ net321 _2508_ _2498_ VGND VGND VPWR VPWR _2509_ sky130_fd_sc_hd__mux2_1
X_8658_ clknet_leaf_65_clk _0747_ VGND VGND VPWR VPWR u_input_buffer.fifo_mem\[22\]\[8\]
+ sky130_fd_sc_hd__dfxtp_1
XFILLER_0_35_225 VGND VGND VPWR VPWR sky130_fd_sc_hd__fill_2
X_7609_ _3760_ VGND VGND VPWR VPWR _1226_ sky130_fd_sc_hd__clkbuf_1
X_8589_ clknet_leaf_43_clk _0678_ VGND VGND VPWR VPWR u_input_buffer.fifo_mem\[26\]\[3\]
+ sky130_fd_sc_hd__dfxtp_1
XFILLER_0_31_420 VGND VGND VPWR VPWR sky130_fd_sc_hd__decap_3
XFILLER_0_9_3 VPWR VGND VPWR VGND sky130_ef_sc_hd__decap_12
Xinput100 sensor_data_in[59] VGND VGND VPWR VPWR net100 sky130_fd_sc_hd__clkbuf_1
Xinput111 sensor_valid[1] VGND VGND VPWR VPWR net111 sky130_fd_sc_hd__clkbuf_8
XFILLER_0_98_475 VGND VGND VPWR VPWR sky130_fd_sc_hd__fill_1
XPHY_161 VGND VGND VPWR VPWR sky130_fd_sc_hd__decap_3
XPHY_150 VGND VGND VPWR VPWR sky130_fd_sc_hd__decap_3
XPHY_194 VGND VGND VPWR VPWR sky130_fd_sc_hd__decap_3
XPHY_183 VGND VGND VPWR VPWR sky130_fd_sc_hd__decap_3
XPHY_172 VGND VGND VPWR VPWR sky130_fd_sc_hd__decap_3
XFILLER_0_5_108 VGND VGND VPWR VPWR sky130_fd_sc_hd__decap_4
XFILLER_0_111_105 VGND VGND VPWR VPWR sky130_fd_sc_hd__decap_6
XFILLER_0_22_475 VGND VGND VPWR VPWR sky130_fd_sc_hd__fill_1
XFILLER_0_10_637 VGND VGND VPWR VPWR sky130_fd_sc_hd__decap_6
X_4270_ u_analytics_engine.threshold\[9\] _1546_ u_analytics_engine.data_in\[8\] _1549_
+ VGND VGND VPWR VPWR _1550_ sky130_fd_sc_hd__a2bb2o_1
XFILLER_0_94_25 VGND VGND VPWR VPWR sky130_fd_sc_hd__decap_3
X_7960_ clknet_leaf_23_clk _0050_ net193 VGND VGND VPWR VPWR u_input_buffer.data_in\[0\]
+ sky130_fd_sc_hd__dfrtp_1
X_6911_ u_input_buffer.fifo_mem\[54\]\[2\] _3078_ _3080_ u_input_buffer.fifo_mem\[46\]\[2\]
+ VGND VGND VPWR VPWR _3161_ sky130_fd_sc_hd__a22o_1
X_7891_ clknet_leaf_80_clk net222 net187 VGND VGND VPWR VPWR u_register_bank.status_flags\[11\]
+ sky130_fd_sc_hd__dfrtp_1
XFILLER_0_77_626 VGND VGND VPWR VPWR sky130_fd_sc_hd__fill_1
XFILLER_0_76_125 VGND VGND VPWR VPWR sky130_fd_sc_hd__fill_1
X_6842_ u_input_buffer.fifo_mem\[41\]\[1\] _2919_ _2921_ u_input_buffer.fifo_mem\[45\]\[1\]
+ _3092_ VGND VGND VPWR VPWR _3093_ sky130_fd_sc_hd__a221o_1
XFILLER_0_92_618 VPWR VGND VPWR VGND sky130_ef_sc_hd__decap_12
X_3985_ u_sensor_interface.sensor_array\[1\]\[2\] net55 _1334_ VGND VGND VPWR VPWR
+ _1343_ sky130_fd_sc_hd__mux2_1
X_6773_ _3024_ VGND VGND VPWR VPWR _3025_ sky130_fd_sc_hd__clkbuf_4
X_8512_ clknet_leaf_67_clk _0601_ VGND VGND VPWR VPWR u_input_buffer.fifo_mem\[31\]\[6\]
+ sky130_fd_sc_hd__dfxtp_1
X_5724_ net593 _2250_ _2388_ VGND VGND VPWR VPWR _2392_ sky130_fd_sc_hd__mux2_1
XFILLER_0_115_411 VGND VGND VPWR VPWR sky130_fd_sc_hd__fill_1
X_8443_ clknet_leaf_28_clk _0532_ VGND VGND VPWR VPWR u_input_buffer.fifo_mem\[35\]\[1\]
+ sky130_fd_sc_hd__dfxtp_1
X_5655_ _2355_ VGND VGND VPWR VPWR _0677_ sky130_fd_sc_hd__clkbuf_1
XFILLER_0_5_653 VPWR VGND VPWR VGND sky130_ef_sc_hd__decap_12
X_8374_ clknet_leaf_93_clk _0463_ VGND VGND VPWR VPWR u_input_buffer.fifo_mem\[40\]\[12\]
+ sky130_fd_sc_hd__dfxtp_1
X_4606_ _1773_ VGND VGND VPWR VPWR _0210_ sky130_fd_sc_hd__clkbuf_1
X_5586_ _2318_ VGND VGND VPWR VPWR _0645_ sky130_fd_sc_hd__clkbuf_1
Xhold310 u_input_buffer.fifo_mem\[40\]\[13\] VGND VGND VPWR VPWR net522 sky130_fd_sc_hd__dlygate4sd3_1
X_7325_ u_input_buffer.fifo_mem\[47\]\[13\] _2879_ _2917_ _3008_ u_input_buffer.fifo_mem\[24\]\[13\]
+ VGND VGND VPWR VPWR _3564_ sky130_fd_sc_hd__a32o_1
Xhold321 u_input_buffer.fifo_mem\[12\]\[0\] VGND VGND VPWR VPWR net533 sky130_fd_sc_hd__dlygate4sd3_1
Xhold343 u_input_buffer.fifo_mem\[34\]\[5\] VGND VGND VPWR VPWR net555 sky130_fd_sc_hd__dlygate4sd3_1
Xhold332 u_input_buffer.fifo_mem\[51\]\[8\] VGND VGND VPWR VPWR net544 sky130_fd_sc_hd__dlygate4sd3_1
X_4537_ _1638_ _1679_ VGND VGND VPWR VPWR _1736_ sky130_fd_sc_hd__nor2_4
Xhold354 u_input_buffer.fifo_mem\[16\]\[6\] VGND VGND VPWR VPWR net566 sky130_fd_sc_hd__dlygate4sd3_1
X_4468_ _1691_ VGND VGND VPWR VPWR _0154_ sky130_fd_sc_hd__clkbuf_1
Xhold387 u_input_buffer.fifo_mem\[34\]\[4\] VGND VGND VPWR VPWR net599 sky130_fd_sc_hd__dlygate4sd3_1
Xhold365 u_input_buffer.fifo_mem\[11\]\[9\] VGND VGND VPWR VPWR net577 sky130_fd_sc_hd__dlygate4sd3_1
X_7256_ u_input_buffer.fifo_mem\[39\]\[11\] _3049_ _3051_ u_input_buffer.fifo_mem\[40\]\[11\]
+ VGND VGND VPWR VPWR _3497_ sky130_fd_sc_hd__a22o_1
Xhold376 u_input_buffer.fifo_mem\[10\]\[12\] VGND VGND VPWR VPWR net588 sky130_fd_sc_hd__dlygate4sd3_1
Xhold398 u_input_buffer.fifo_mem\[40\]\[8\] VGND VGND VPWR VPWR net610 sky130_fd_sc_hd__dlygate4sd3_1
X_7187_ _3411_ _3420_ _3429_ VGND VGND VPWR VPWR _3430_ sky130_fd_sc_hd__or3_1
X_6207_ _2657_ VGND VGND VPWR VPWR _0927_ sky130_fd_sc_hd__clkbuf_1
X_6138_ _2620_ VGND VGND VPWR VPWR _0895_ sky130_fd_sc_hd__clkbuf_1
X_4399_ _1439_ net1232 _1640_ VGND VGND VPWR VPWR _1652_ sky130_fd_sc_hd__mux2_1
XTAP_670 VGND VPWR sky130_fd_sc_hd__tapvpwrvgnd_1
Xhold1032 u_input_buffer.fifo_mem\[9\]\[5\] VGND VGND VPWR VPWR net1244 sky130_fd_sc_hd__dlygate4sd3_1
Xhold1010 u_input_buffer.fifo_mem\[13\]\[11\] VGND VGND VPWR VPWR net1222 sky130_fd_sc_hd__dlygate4sd3_1
XTAP_681 VGND VPWR sky130_fd_sc_hd__tapvpwrvgnd_1
XTAP_692 VGND VPWR sky130_fd_sc_hd__tapvpwrvgnd_1
Xhold1021 u_input_buffer.fifo_mem\[61\]\[3\] VGND VGND VPWR VPWR net1233 sky130_fd_sc_hd__dlygate4sd3_1
Xhold1054 u_input_buffer.fifo_mem\[49\]\[0\] VGND VGND VPWR VPWR net1266 sky130_fd_sc_hd__dlygate4sd3_1
X_6069_ net444 _2524_ _2568_ VGND VGND VPWR VPWR _2583_ sky130_fd_sc_hd__mux2_1
Xhold1065 u_input_buffer.fifo_mem\[59\]\[12\] VGND VGND VPWR VPWR net1277 sky130_fd_sc_hd__dlygate4sd3_1
Xhold1043 u_input_buffer.fifo_mem\[27\]\[12\] VGND VGND VPWR VPWR net1255 sky130_fd_sc_hd__dlygate4sd3_1
Xhold1076 u_input_buffer.fifo_mem\[21\]\[7\] VGND VGND VPWR VPWR net1288 sky130_fd_sc_hd__dlygate4sd3_1
Xhold1098 u_analytics_engine.data_in\[0\] VGND VGND VPWR VPWR net1310 sky130_fd_sc_hd__dlygate4sd3_1
Xhold1087 u_input_buffer.fifo_mem\[59\]\[1\] VGND VGND VPWR VPWR net1299 sky130_fd_sc_hd__dlygate4sd3_1
XFILLER_0_36_567 VGND VGND VPWR VPWR sky130_fd_sc_hd__fill_1
XFILLER_0_91_684 VGND VGND VPWR VPWR sky130_fd_sc_hd__fill_2
XFILLER_0_90_161 VGND VGND VPWR VPWR sky130_fd_sc_hd__fill_2
XFILLER_0_106_477 VGND VGND VPWR VPWR sky130_fd_sc_hd__decap_4
XFILLER_0_16_291 VGND VGND VPWR VPWR sky130_fd_sc_hd__decap_3
XFILLER_0_101_193 VGND VGND VPWR VPWR sky130_fd_sc_hd__fill_2
XFILLER_0_98_250 VGND VGND VPWR VPWR sky130_fd_sc_hd__fill_2
XFILLER_0_59_615 VGND VGND VPWR VPWR sky130_fd_sc_hd__fill_1
XFILLER_0_58_103 VGND VGND VPWR VPWR sky130_fd_sc_hd__fill_2
XFILLER_0_46_309 VGND VGND VPWR VPWR sky130_fd_sc_hd__decap_3
XFILLER_0_13_65 VGND VGND VPWR VPWR sky130_fd_sc_hd__decap_3
XFILLER_0_81_150 VGND VGND VPWR VPWR sky130_fd_sc_hd__fill_1
XFILLER_0_54_342 VGND VGND VPWR VPWR sky130_fd_sc_hd__fill_2
X_5440_ _2231_ VGND VGND VPWR VPWR _0586_ sky130_fd_sc_hd__clkbuf_1
XFILLER_0_82_684 VGND VGND VPWR VPWR sky130_fd_sc_hd__fill_2
XFILLER_0_2_601 VPWR VGND VPWR VGND sky130_ef_sc_hd__decap_12
XFILLER_0_42_559 VGND VGND VPWR VPWR sky130_fd_sc_hd__fill_2
X_5371_ net526 _2004_ _2187_ VGND VGND VPWR VPWR _2195_ sky130_fd_sc_hd__mux2_1
XFILLER_0_2_645 VPWR VGND VPWR VGND sky130_ef_sc_hd__decap_12
XFILLER_0_100_609 VGND VGND VPWR VPWR sky130_fd_sc_hd__decap_4
X_7110_ net249 _3086_ _3088_ VGND VGND VPWR VPWR _3355_ sky130_fd_sc_hd__o21a_1
X_8090_ clknet_leaf_2_clk _0179_ VGND VGND VPWR VPWR u_input_buffer.fifo_mem\[57\]\[0\]
+ sky130_fd_sc_hd__dfxtp_1
X_4322_ _1592_ _1600_ VGND VGND VPWR VPWR _1601_ sky130_fd_sc_hd__nor2_4
X_4253_ u_analytics_engine.threshold\[14\] VGND VGND VPWR VPWR _1533_ sky130_fd_sc_hd__inv_2
X_7041_ u_input_buffer.fifo_mem\[1\]\[6\] _2932_ _3284_ _3286_ VGND VGND VPWR VPWR
+ _3287_ sky130_fd_sc_hd__a211o_1
X_4184_ u_sample_counter.sample_count\[6\] u_sample_counter.sample_count\[7\] _1483_
+ u_sample_counter.sample_count\[8\] VGND VGND VPWR VPWR _1488_ sky130_fd_sc_hd__a31o_1
X_8992_ clknet_leaf_7_clk _1081_ VGND VGND VPWR VPWR u_input_buffer.fifo_mem\[1\]\[6\]
+ sky130_fd_sc_hd__dfxtp_1
X_7943_ clknet_leaf_110_clk _0033_ VGND VGND VPWR VPWR u_sensor_interface.sensor_array\[1\]\[15\]
+ sky130_fd_sc_hd__dfxtp_1
XFILLER_0_77_412 VGND VGND VPWR VPWR sky130_fd_sc_hd__fill_1
XFILLER_0_54_83 VGND VGND VPWR VPWR sky130_fd_sc_hd__fill_1
X_7874_ net33 u_register_bank.sensor_enable\[29\] _3927_ VGND VGND VPWR VPWR _3937_
+ sky130_fd_sc_hd__mux2_1
XFILLER_0_54_94 VGND VGND VPWR VPWR sky130_fd_sc_hd__fill_2
X_6825_ _2885_ _2882_ _3018_ VGND VGND VPWR VPWR _3077_ sky130_fd_sc_hd__and3_2
X_3968_ _1322_ VGND VGND VPWR VPWR _1334_ sky130_fd_sc_hd__clkbuf_8
X_6756_ _2906_ _3002_ VGND VGND VPWR VPWR _3008_ sky130_fd_sc_hd__nor2_2
X_5707_ _2382_ VGND VGND VPWR VPWR _0702_ sky130_fd_sc_hd__clkbuf_1
XFILLER_0_18_589 VGND VGND VPWR VPWR sky130_fd_sc_hd__decap_4
X_6687_ _2938_ VGND VGND VPWR VPWR _2939_ sky130_fd_sc_hd__buf_2
X_8426_ clknet_leaf_28_clk _0515_ VGND VGND VPWR VPWR u_input_buffer.fifo_mem\[36\]\[0\]
+ sky130_fd_sc_hd__dfxtp_1
X_5638_ net423 _2266_ _2333_ VGND VGND VPWR VPWR _2346_ sky130_fd_sc_hd__mux2_1
XFILLER_0_13_261 VGND VGND VPWR VPWR sky130_fd_sc_hd__fill_1
X_5569_ _1445_ net1078 _2296_ VGND VGND VPWR VPWR _2309_ sky130_fd_sc_hd__mux2_1
X_8357_ clknet_leaf_1_clk _0446_ VGND VGND VPWR VPWR u_input_buffer.fifo_mem\[41\]\[11\]
+ sky130_fd_sc_hd__dfxtp_1
Xhold151 u_input_buffer.fifo_mem\[8\]\[2\] VGND VGND VPWR VPWR net363 sky130_fd_sc_hd__dlygate4sd3_1
X_7308_ u_input_buffer.fifo_mem\[33\]\[13\] _2897_ _2903_ u_input_buffer.fifo_mem\[61\]\[13\]
+ _3546_ VGND VGND VPWR VPWR _3547_ sky130_fd_sc_hd__a221o_1
Xhold140 u_input_buffer.fifo_mem\[63\]\[11\] VGND VGND VPWR VPWR net352 sky130_fd_sc_hd__dlygate4sd3_1
Xhold162 u_input_buffer.fifo_mem\[40\]\[12\] VGND VGND VPWR VPWR net374 sky130_fd_sc_hd__dlygate4sd3_1
Xhold195 u_input_buffer.fifo_mem\[40\]\[2\] VGND VGND VPWR VPWR net407 sky130_fd_sc_hd__dlygate4sd3_1
X_8288_ clknet_leaf_18_clk _0377_ VGND VGND VPWR VPWR u_input_buffer.fifo_mem\[45\]\[6\]
+ sky130_fd_sc_hd__dfxtp_1
Xhold184 u_input_buffer.fifo_mem\[22\]\[8\] VGND VGND VPWR VPWR net396 sky130_fd_sc_hd__dlygate4sd3_1
Xhold173 u_input_buffer.fifo_mem\[19\]\[8\] VGND VGND VPWR VPWR net385 sky130_fd_sc_hd__dlygate4sd3_1
X_7239_ u_input_buffer.fifo_mem\[16\]\[11\] _2970_ _2972_ u_input_buffer.fifo_mem\[49\]\[11\]
+ _2974_ VGND VGND VPWR VPWR _3480_ sky130_fd_sc_hd__a221o_1
XTAP_1600 VGND VPWR sky130_fd_sc_hd__tapvpwrvgnd_1
XTAP_1633 VGND VPWR sky130_fd_sc_hd__tapvpwrvgnd_1
XTAP_1622 VGND VPWR sky130_fd_sc_hd__tapvpwrvgnd_1
XTAP_1611 VGND VPWR sky130_fd_sc_hd__tapvpwrvgnd_1
XTAP_1644 VGND VPWR sky130_fd_sc_hd__tapvpwrvgnd_1
XFILLER_0_95_297 VGND VGND VPWR VPWR sky130_fd_sc_hd__fill_2
XFILLER_0_24_504 VGND VGND VPWR VPWR sky130_fd_sc_hd__decap_4
XFILLER_0_63_194 VGND VGND VPWR VPWR sky130_fd_sc_hd__decap_4
XFILLER_0_51_356 VGND VGND VPWR VPWR sky130_fd_sc_hd__decap_3
XFILLER_0_75_27 VGND VGND VPWR VPWR sky130_fd_sc_hd__decap_6
XFILLER_0_78_209 VGND VGND VPWR VPWR sky130_fd_sc_hd__fill_2
XFILLER_0_115_55 VGND VGND VPWR VPWR sky130_fd_sc_hd__fill_1
X_4940_ net1113 _1714_ _1952_ VGND VGND VPWR VPWR _1958_ sky130_fd_sc_hd__mux2_1
XFILLER_0_115_77 VGND VGND VPWR VPWR sky130_fd_sc_hd__decap_6
XFILLER_0_86_253 VGND VGND VPWR VPWR sky130_fd_sc_hd__fill_2
X_4871_ _1919_ VGND VGND VPWR VPWR _0329_ sky130_fd_sc_hd__clkbuf_1
X_6610_ u_input_buffer.rd_ptr\[1\] VGND VGND VPWR VPWR _2873_ sky130_fd_sc_hd__clkbuf_2
X_7590_ _3750_ VGND VGND VPWR VPWR _1217_ sky130_fd_sc_hd__clkbuf_1
X_6541_ _1620_ net813 _2825_ VGND VGND VPWR VPWR _2835_ sky130_fd_sc_hd__mux2_1
XFILLER_0_70_610 VGND VGND VPWR VPWR sky130_fd_sc_hd__fill_2
XFILLER_0_55_673 VGND VGND VPWR VPWR sky130_fd_sc_hd__decap_4
XFILLER_0_6_247 VGND VGND VPWR VPWR sky130_fd_sc_hd__fill_2
XFILLER_0_27_386 VGND VGND VPWR VPWR sky130_fd_sc_hd__decap_6
XFILLER_0_70_643 VGND VGND VPWR VPWR sky130_fd_sc_hd__fill_1
XFILLER_0_70_632 VGND VGND VPWR VPWR sky130_fd_sc_hd__decap_6
X_6472_ _2798_ VGND VGND VPWR VPWR _1051_ sky130_fd_sc_hd__clkbuf_1
XFILLER_0_54_194 VGND VGND VPWR VPWR sky130_fd_sc_hd__fill_2
X_8211_ clknet_leaf_13_clk _0300_ VGND VGND VPWR VPWR u_input_buffer.fifo_mem\[50\]\[9\]
+ sky130_fd_sc_hd__dfxtp_1
XFILLER_0_2_431 VPWR VGND VPWR VGND sky130_ef_sc_hd__decap_12
X_9191_ clknet_leaf_79_clk _1279_ net191 VGND VGND VPWR VPWR net163 sky130_fd_sc_hd__dfrtp_1
X_5423_ _1910_ _1930_ VGND VGND VPWR VPWR _2222_ sky130_fd_sc_hd__nor2_4
X_8142_ clknet_leaf_40_clk _0231_ VGND VGND VPWR VPWR u_input_buffer.fifo_mem\[54\]\[4\]
+ sky130_fd_sc_hd__dfxtp_1
XFILLER_0_2_475 VGND VGND VPWR VPWR sky130_fd_sc_hd__fill_1
X_5354_ _2185_ VGND VGND VPWR VPWR _0546_ sky130_fd_sc_hd__clkbuf_1
X_4305_ _1577_ u_analytics_engine.data_in\[0\] _1558_ _1569_ _1579_ VGND VGND VPWR
+ VPWR _1585_ sky130_fd_sc_hd__a2111o_1
XFILLER_0_10_253 VGND VGND VPWR VPWR sky130_fd_sc_hd__fill_1
XFILLER_0_49_50 VGND VGND VPWR VPWR sky130_fd_sc_hd__fill_2
X_8073_ clknet_leaf_91_clk _0162_ VGND VGND VPWR VPWR u_input_buffer.fifo_mem\[59\]\[15\]
+ sky130_fd_sc_hd__dfxtp_1
X_5285_ _1469_ net1026 _2132_ VGND VGND VPWR VPWR _2149_ sky130_fd_sc_hd__mux2_1
X_7024_ u_input_buffer.fifo_mem\[15\]\[5\] _3060_ _3062_ u_input_buffer.fifo_mem\[43\]\[5\]
+ VGND VGND VPWR VPWR _3271_ sky130_fd_sc_hd__a22o_1
X_4236_ _1520_ _1519_ _1521_ VGND VGND VPWR VPWR _1523_ sky130_fd_sc_hd__o21ai_1
X_4167_ u_analytics_engine.data_valid u_sample_counter.sample_count\[1\] u_sample_counter.sample_count\[0\]
+ u_sample_counter.sample_count\[2\] VGND VGND VPWR VPWR _1477_ sky130_fd_sc_hd__and4_2
XFILLER_0_4_85 VGND VGND VPWR VPWR sky130_fd_sc_hd__decap_8
XFILLER_0_4_74 VGND VGND VPWR VPWR sky130_fd_sc_hd__fill_1
XFILLER_0_4_63 VGND VGND VPWR VPWR sky130_fd_sc_hd__decap_3
XFILLER_0_65_93 VGND VGND VPWR VPWR sky130_fd_sc_hd__fill_1
X_8975_ clknet_leaf_29_clk _1064_ VGND VGND VPWR VPWR u_input_buffer.fifo_mem\[2\]\[5\]
+ sky130_fd_sc_hd__dfxtp_1
X_4098_ _1419_ VGND VGND VPWR VPWR _0056_ sky130_fd_sc_hd__clkbuf_1
X_7926_ clknet_leaf_110_clk _0016_ VGND VGND VPWR VPWR u_sensor_interface.sensor_array\[2\]\[14\]
+ sky130_fd_sc_hd__dfxtp_1
X_7857_ _3928_ VGND VGND VPWR VPWR _1306_ sky130_fd_sc_hd__clkbuf_1
XFILLER_0_108_517 VGND VGND VPWR VPWR sky130_fd_sc_hd__fill_2
XFILLER_0_92_223 VGND VGND VPWR VPWR sky130_fd_sc_hd__decap_4
X_6808_ _3059_ VGND VGND VPWR VPWR _3060_ sky130_fd_sc_hd__clkbuf_4
XFILLER_0_108_528 VGND VGND VPWR VPWR sky130_fd_sc_hd__decap_4
X_7788_ _3891_ VGND VGND VPWR VPWR _1274_ sky130_fd_sc_hd__clkbuf_1
XFILLER_0_73_481 VGND VGND VPWR VPWR sky130_fd_sc_hd__fill_1
XFILLER_0_61_621 VGND VGND VPWR VPWR sky130_fd_sc_hd__fill_1
X_6739_ _2876_ _2952_ _2877_ VGND VGND VPWR VPWR _2991_ sky130_fd_sc_hd__or3b_4
XFILLER_0_52_109 VGND VGND VPWR VPWR sky130_fd_sc_hd__fill_1
X_8409_ clknet_leaf_92_clk _0498_ VGND VGND VPWR VPWR u_input_buffer.fifo_mem\[38\]\[15\]
+ sky130_fd_sc_hd__dfxtp_1
XFILLER_0_60_197 VGND VGND VPWR VPWR sky130_fd_sc_hd__fill_1
XTAP_1441 VGND VPWR sky130_fd_sc_hd__tapvpwrvgnd_1
XTAP_1430 VGND VPWR sky130_fd_sc_hd__tapvpwrvgnd_1
XTAP_1474 VGND VPWR sky130_fd_sc_hd__tapvpwrvgnd_1
XTAP_1463 VGND VPWR sky130_fd_sc_hd__tapvpwrvgnd_1
XTAP_1452 VGND VPWR sky130_fd_sc_hd__tapvpwrvgnd_1
XFILLER_0_68_297 VGND VGND VPWR VPWR sky130_fd_sc_hd__decap_3
XTAP_1496 VGND VPWR sky130_fd_sc_hd__tapvpwrvgnd_1
XTAP_1485 VGND VPWR sky130_fd_sc_hd__tapvpwrvgnd_1
XFILLER_0_83_267 VGND VGND VPWR VPWR sky130_fd_sc_hd__decap_4
XFILLER_0_83_245 VGND VGND VPWR VPWR sky130_fd_sc_hd__fill_2
XFILLER_0_37_662 VGND VGND VPWR VPWR sky130_fd_sc_hd__fill_2
XFILLER_0_114_509 VGND VGND VPWR VPWR sky130_fd_sc_hd__fill_1
XFILLER_0_64_470 VGND VGND VPWR VPWR sky130_fd_sc_hd__decap_6
XFILLER_0_36_194 VGND VGND VPWR VPWR sky130_fd_sc_hd__fill_2
XFILLER_0_101_57 VPWR VGND VPWR VGND sky130_ef_sc_hd__decap_12
XFILLER_0_12_529 VGND VGND VPWR VPWR sky130_fd_sc_hd__decap_3
Xhold909 u_input_buffer.fifo_mem\[5\]\[4\] VGND VGND VPWR VPWR net1121 sky130_fd_sc_hd__dlygate4sd3_1
XFILLER_0_52_665 VGND VGND VPWR VPWR sky130_fd_sc_hd__fill_1
XFILLER_0_86_15 VPWR VGND VPWR VGND sky130_ef_sc_hd__decap_12
X_5070_ net273 _2010_ _2023_ VGND VGND VPWR VPWR _2035_ sky130_fd_sc_hd__mux2_1
X_4021_ u_sensor_interface.sensor_array\[0\]\[3\] net79 _1356_ VGND VGND VPWR VPWR
+ _1362_ sky130_fd_sc_hd__mux2_1
X_5972_ _2530_ VGND VGND VPWR VPWR _2531_ sky130_fd_sc_hd__clkbuf_4
X_8760_ clknet_leaf_100_clk _0849_ VGND VGND VPWR VPWR u_input_buffer.fifo_mem\[16\]\[14\]
+ sky130_fd_sc_hd__dfxtp_1
X_7711_ u_register_bank.window_cfg\[16\] _3812_ _3813_ u_register_bank.threshold_cfg\[16\]
+ _3834_ VGND VGND VPWR VPWR _3835_ sky130_fd_sc_hd__a221o_1
X_4923_ _1948_ VGND VGND VPWR VPWR _0352_ sky130_fd_sc_hd__clkbuf_1
X_8691_ clknet_leaf_47_clk _0780_ VGND VGND VPWR VPWR u_input_buffer.fifo_mem\[20\]\[9\]
+ sky130_fd_sc_hd__dfxtp_1
XFILLER_0_74_267 VGND VGND VPWR VPWR sky130_fd_sc_hd__fill_1
XFILLER_0_74_256 VGND VGND VPWR VPWR sky130_fd_sc_hd__fill_2
X_4854_ _1909_ VGND VGND VPWR VPWR _0322_ sky130_fd_sc_hd__clkbuf_1
X_7642_ _3781_ VGND VGND VPWR VPWR _3782_ sky130_fd_sc_hd__buf_4
X_7573_ _3741_ VGND VGND VPWR VPWR _1209_ sky130_fd_sc_hd__clkbuf_1
X_4785_ _1597_ _1598_ _1596_ VGND VGND VPWR VPWR _1872_ sky130_fd_sc_hd__or3b_4
XFILLER_0_27_172 VGND VGND VPWR VPWR sky130_fd_sc_hd__fill_2
X_6524_ _2826_ VGND VGND VPWR VPWR _1075_ sky130_fd_sc_hd__clkbuf_1
X_6455_ net346 _1376_ _2789_ VGND VGND VPWR VPWR _2790_ sky130_fd_sc_hd__mux2_1
XFILLER_0_15_389 VGND VGND VPWR VPWR sky130_fd_sc_hd__decap_3
XFILLER_0_113_597 VPWR VGND VPWR VGND sky130_ef_sc_hd__decap_12
X_6386_ _2752_ VGND VGND VPWR VPWR _2753_ sky130_fd_sc_hd__clkbuf_4
XFILLER_0_30_359 VGND VGND VPWR VPWR sky130_fd_sc_hd__decap_4
X_9174_ net172 _1262_ VGND VGND VPWR VPWR net130 sky130_fd_sc_hd__dfxtp_2
X_5406_ _2213_ VGND VGND VPWR VPWR _0570_ sky130_fd_sc_hd__clkbuf_1
X_5337_ net738 _2004_ _2169_ VGND VGND VPWR VPWR _2177_ sky130_fd_sc_hd__mux2_1
X_8125_ clknet_leaf_41_clk _0214_ VGND VGND VPWR VPWR u_input_buffer.fifo_mem\[55\]\[3\]
+ sky130_fd_sc_hd__dfxtp_1
XFILLER_0_11_573 VPWR VGND VPWR VGND sky130_ef_sc_hd__decap_12
X_5268_ _2140_ VGND VGND VPWR VPWR _0505_ sky130_fd_sc_hd__clkbuf_1
X_8056_ clknet_leaf_88_clk _0145_ VGND VGND VPWR VPWR u_input_buffer.fifo_mem\[60\]\[14\]
+ sky130_fd_sc_hd__dfxtp_1
X_7007_ u_input_buffer.fifo_mem\[2\]\[5\] _2984_ _2986_ u_input_buffer.fifo_mem\[32\]\[5\]
+ VGND VGND VPWR VPWR _3254_ sky130_fd_sc_hd__a22o_1
X_4219_ _1511_ VGND VGND VPWR VPWR _0085_ sky130_fd_sc_hd__clkbuf_1
X_5199_ net838 _2002_ _2097_ VGND VGND VPWR VPWR _2104_ sky130_fd_sc_hd__mux2_1
X_8958_ clknet_leaf_40_clk _1047_ VGND VGND VPWR VPWR u_input_buffer.fifo_mem\[3\]\[4\]
+ sky130_fd_sc_hd__dfxtp_1
X_7909_ clknet_leaf_62_clk net224 net195 VGND VGND VPWR VPWR u_register_bank.status_flags\[29\]
+ sky130_fd_sc_hd__dfrtp_1
X_8889_ clknet_leaf_92_clk _0978_ VGND VGND VPWR VPWR u_input_buffer.fifo_mem\[8\]\[15\]
+ sky130_fd_sc_hd__dfxtp_1
XFILLER_0_108_325 VGND VGND VPWR VPWR sky130_fd_sc_hd__decap_3
XFILLER_0_108_303 VGND VGND VPWR VPWR sky130_fd_sc_hd__fill_2
XFILLER_0_108_336 VGND VGND VPWR VPWR sky130_fd_sc_hd__fill_2
XFILLER_0_19_673 VGND VGND VPWR VPWR sky130_fd_sc_hd__decap_4
XFILLER_0_34_665 VPWR VGND VPWR VGND sky130_ef_sc_hd__decap_12
XFILLER_0_21_337 VGND VGND VPWR VPWR sky130_fd_sc_hd__fill_1
XFILLER_0_88_304 VGND VGND VPWR VPWR sky130_fd_sc_hd__decap_4
XFILLER_0_96_392 VGND VGND VPWR VPWR sky130_fd_sc_hd__fill_1
XFILLER_0_69_584 VGND VGND VPWR VPWR sky130_fd_sc_hd__decap_3
XTAP_1293 VGND VPWR sky130_fd_sc_hd__tapvpwrvgnd_1
XTAP_1271 VGND VPWR sky130_fd_sc_hd__tapvpwrvgnd_1
XTAP_1282 VGND VPWR sky130_fd_sc_hd__tapvpwrvgnd_1
XTAP_1260 VGND VPWR sky130_fd_sc_hd__tapvpwrvgnd_1
XFILLER_0_84_587 VGND VGND VPWR VPWR sky130_fd_sc_hd__fill_1
XFILLER_0_71_215 VGND VGND VPWR VPWR sky130_fd_sc_hd__fill_1
X_4570_ _1469_ net723 _1737_ VGND VGND VPWR VPWR _1754_ sky130_fd_sc_hd__mux2_1
XFILLER_0_21_54 VGND VGND VPWR VPWR sky130_fd_sc_hd__fill_2
XFILLER_0_108_3 VPWR VGND VPWR VGND sky130_ef_sc_hd__decap_12
XFILLER_0_21_65 VGND VGND VPWR VPWR sky130_fd_sc_hd__fill_2
XFILLER_0_25_665 VGND VGND VPWR VPWR sky130_fd_sc_hd__decap_6
XFILLER_0_25_676 VGND VGND VPWR VPWR sky130_fd_sc_hd__fill_2
XFILLER_0_52_462 VGND VGND VPWR VPWR sky130_fd_sc_hd__fill_1
Xhold728 u_input_buffer.fifo_mem\[40\]\[6\] VGND VGND VPWR VPWR net940 sky130_fd_sc_hd__dlygate4sd3_1
Xhold717 u_input_buffer.fifo_mem\[41\]\[14\] VGND VGND VPWR VPWR net929 sky130_fd_sc_hd__dlygate4sd3_1
Xhold706 u_input_buffer.fifo_mem\[29\]\[2\] VGND VGND VPWR VPWR net918 sky130_fd_sc_hd__dlygate4sd3_1
Xhold739 u_input_buffer.fifo_mem\[11\]\[5\] VGND VGND VPWR VPWR net951 sky130_fd_sc_hd__dlygate4sd3_1
X_6240_ net588 _2522_ _2661_ VGND VGND VPWR VPWR _2675_ sky130_fd_sc_hd__mux2_1
X_6171_ net1029 _2522_ _2624_ VGND VGND VPWR VPWR _2638_ sky130_fd_sc_hd__mux2_1
XFILLER_0_110_589 VPWR VGND VPWR VGND sky130_ef_sc_hd__decap_12
X_5122_ _1391_ net1115 _2060_ VGND VGND VPWR VPWR _2063_ sky130_fd_sc_hd__mux2_1
XFILLER_0_20_381 VGND VGND VPWR VPWR sky130_fd_sc_hd__decap_4
XFILLER_0_41_7 VGND VGND VPWR VPWR sky130_fd_sc_hd__decap_6
X_5053_ _2026_ VGND VGND VPWR VPWR _0404_ sky130_fd_sc_hd__clkbuf_1
X_4004_ u_sensor_interface.sensor_array\[1\]\[11\] net65 _1345_ VGND VGND VPWR VPWR
+ _1353_ sky130_fd_sc_hd__mux2_1
X_8812_ clknet_leaf_25_clk _0901_ VGND VGND VPWR VPWR u_input_buffer.fifo_mem\[12\]\[2\]
+ sky130_fd_sc_hd__dfxtp_1
XFILLER_0_1_42 VPWR VGND VPWR VGND sky130_ef_sc_hd__decap_12
XFILLER_0_94_329 VGND VGND VPWR VPWR sky130_fd_sc_hd__decap_4
XFILLER_0_75_510 VGND VGND VPWR VPWR sky130_fd_sc_hd__fill_1
X_5955_ _2519_ VGND VGND VPWR VPWR _0813_ sky130_fd_sc_hd__clkbuf_1
X_8743_ clknet_leaf_109_clk _0832_ VGND VGND VPWR VPWR u_input_buffer.fifo_mem\[17\]\[13\]
+ sky130_fd_sc_hd__dfxtp_1
X_4906_ net378 _1714_ _1934_ VGND VGND VPWR VPWR _1940_ sky130_fd_sc_hd__mux2_1
X_5886_ _2477_ VGND VGND VPWR VPWR _0786_ sky130_fd_sc_hd__clkbuf_1
X_8674_ clknet_leaf_6_clk _0763_ VGND VGND VPWR VPWR u_input_buffer.fifo_mem\[21\]\[8\]
+ sky130_fd_sc_hd__dfxtp_1
X_4837_ _1421_ net1301 _1893_ VGND VGND VPWR VPWR _1901_ sky130_fd_sc_hd__mux2_1
X_7625_ _3768_ VGND VGND VPWR VPWR _1234_ sky130_fd_sc_hd__clkbuf_1
X_4768_ _1863_ VGND VGND VPWR VPWR _0282_ sky130_fd_sc_hd__clkbuf_1
X_7556_ _3731_ VGND VGND VPWR VPWR _1202_ sky130_fd_sc_hd__clkbuf_1
X_6507_ net290 _1432_ _2807_ VGND VGND VPWR VPWR _2817_ sky130_fd_sc_hd__mux2_1
X_7487_ net1253 _1462_ _3677_ VGND VGND VPWR VPWR _3693_ sky130_fd_sc_hd__mux2_1
X_4699_ _1427_ net1030 _1817_ VGND VGND VPWR VPWR _1826_ sky130_fd_sc_hd__mux2_1
XFILLER_0_113_350 VGND VGND VPWR VPWR sky130_fd_sc_hd__fill_1
X_6438_ _2780_ VGND VGND VPWR VPWR _1035_ sky130_fd_sc_hd__clkbuf_1
X_9226_ net175 _1313_ net207 VGND VGND VPWR VPWR u_register_bank.sensor_enable\[27\]
+ sky130_fd_sc_hd__dfrtp_1
X_9157_ net181 _1245_ VGND VGND VPWR VPWR net143 sky130_fd_sc_hd__dfxtp_1
X_8108_ clknet_leaf_52_clk _0197_ VGND VGND VPWR VPWR u_input_buffer.fifo_mem\[56\]\[2\]
+ sky130_fd_sc_hd__dfxtp_1
X_6369_ net416 _2514_ _2735_ VGND VGND VPWR VPWR _2744_ sky130_fd_sc_hd__mux2_1
X_9088_ net174 _1176_ net206 VGND VGND VPWR VPWR u_register_bank.window_cfg\[2\] sky130_fd_sc_hd__dfrtp_1
Xhold11 u_sample_counter.sample_count\[15\] VGND VGND VPWR VPWR net223 sky130_fd_sc_hd__dlygate4sd3_1
Xhold22 u_sample_counter.sample_count\[9\] VGND VGND VPWR VPWR net234 sky130_fd_sc_hd__dlygate4sd3_1
Xhold44 u_analytics_engine.data_valid VGND VGND VPWR VPWR net256 sky130_fd_sc_hd__buf_1
Xhold33 u_sample_counter.sample_count\[22\] VGND VGND VPWR VPWR net245 sky130_fd_sc_hd__dlygate4sd3_1
Xhold55 u_sensor_interface.sensor_array\[0\]\[15\] VGND VGND VPWR VPWR net267 sky130_fd_sc_hd__dlygate4sd3_1
X_8039_ clknet_leaf_107_clk _0128_ VGND VGND VPWR VPWR u_input_buffer.fifo_mem\[61\]\[13\]
+ sky130_fd_sc_hd__dfxtp_1
Xhold99 u_sensor_interface.sensor_array\[0\]\[9\] VGND VGND VPWR VPWR net311 sky130_fd_sc_hd__dlygate4sd3_1
XFILLER_0_97_101 VGND VGND VPWR VPWR sky130_fd_sc_hd__decap_8
Xhold88 u_input_buffer.fifo_mem\[8\]\[5\] VGND VGND VPWR VPWR net300 sky130_fd_sc_hd__dlygate4sd3_1
Xhold66 u_input_buffer.fifo_mem\[52\]\[8\] VGND VGND VPWR VPWR net278 sky130_fd_sc_hd__dlygate4sd3_1
Xhold77 u_input_buffer.fifo_mem\[55\]\[10\] VGND VGND VPWR VPWR net289 sky130_fd_sc_hd__dlygate4sd3_1
XFILLER_0_98_668 VGND VGND VPWR VPWR sky130_fd_sc_hd__fill_1
XFILLER_0_78_381 VGND VGND VPWR VPWR sky130_fd_sc_hd__fill_1
XFILLER_0_109_601 VGND VGND VPWR VPWR sky130_fd_sc_hd__decap_8
XFILLER_0_109_634 VGND VGND VPWR VPWR sky130_fd_sc_hd__fill_1
XFILLER_0_93_362 VGND VGND VPWR VPWR sky130_fd_sc_hd__fill_1
XFILLER_0_81_502 VGND VGND VPWR VPWR sky130_fd_sc_hd__fill_2
XFILLER_0_66_587 VGND VGND VPWR VPWR sky130_fd_sc_hd__fill_1
XFILLER_0_26_418 VGND VGND VPWR VPWR sky130_fd_sc_hd__fill_2
XFILLER_0_53_259 VGND VGND VPWR VPWR sky130_fd_sc_hd__fill_2
XANTENNA_8 _3335_ VGND VGND VPWR VPWR sky130_fd_sc_hd__diode_2
XFILLER_0_22_635 VGND VGND VPWR VPWR sky130_fd_sc_hd__fill_2
XFILLER_0_21_167 VGND VGND VPWR VPWR sky130_fd_sc_hd__fill_1
XTAP_318 VGND VPWR sky130_fd_sc_hd__tapvpwrvgnd_1
XTAP_329 VGND VPWR sky130_fd_sc_hd__tapvpwrvgnd_1
XTAP_307 VGND VPWR sky130_fd_sc_hd__tapvpwrvgnd_1
XFILLER_0_83_27 VPWR VGND VPWR VGND sky130_ef_sc_hd__decap_12
XFILLER_0_16_65 VPWR VGND VPWR VGND sky130_ef_sc_hd__decap_12
Xclkbuf_leaf_108_clk clknet_3_0__leaf_clk VGND VGND VPWR VPWR clknet_leaf_108_clk
+ sky130_fd_sc_hd__clkbuf_16
XFILLER_0_9_629 VPWR VGND VPWR VGND sky130_ef_sc_hd__decap_12
X_5740_ net654 _2266_ _2387_ VGND VGND VPWR VPWR _2400_ sky130_fd_sc_hd__mux2_1
XTAP_1090 VGND VPWR sky130_fd_sc_hd__tapvpwrvgnd_1
XFILLER_0_115_615 VGND VGND VPWR VPWR sky130_fd_sc_hd__fill_1
XFILLER_0_84_395 VGND VGND VPWR VPWR sky130_fd_sc_hd__fill_1
X_5671_ _2363_ VGND VGND VPWR VPWR _0685_ sky130_fd_sc_hd__clkbuf_1
X_7410_ u_input_buffer.fifo_mem\[6\]\[15\] _3034_ _3036_ u_input_buffer.fifo_mem\[28\]\[15\]
+ _3646_ VGND VGND VPWR VPWR _3647_ sky130_fd_sc_hd__a221o_1
X_4622_ net658 _1714_ _1778_ VGND VGND VPWR VPWR _1784_ sky130_fd_sc_hd__mux2_1
XFILLER_0_72_568 VGND VGND VPWR VPWR sky130_fd_sc_hd__fill_2
X_8390_ clknet_leaf_93_clk _0479_ VGND VGND VPWR VPWR u_input_buffer.fifo_mem\[39\]\[12\]
+ sky130_fd_sc_hd__dfxtp_1
XFILLER_0_114_136 VGND VGND VPWR VPWR sky130_fd_sc_hd__decap_4
XFILLER_0_102_309 VGND VGND VPWR VPWR sky130_fd_sc_hd__decap_3
XFILLER_0_4_345 VPWR VGND VPWR VGND sky130_ef_sc_hd__decap_12
X_7341_ u_input_buffer.fifo_mem\[63\]\[13\] _2886_ _3075_ u_input_buffer.fifo_mem\[55\]\[13\]
+ _3579_ VGND VGND VPWR VPWR _3580_ sky130_fd_sc_hd__a221o_1
X_4553_ _1745_ VGND VGND VPWR VPWR _0185_ sky130_fd_sc_hd__clkbuf_1
Xhold536 u_input_buffer.fifo_mem\[56\]\[5\] VGND VGND VPWR VPWR net748 sky130_fd_sc_hd__dlygate4sd3_1
Xhold525 u_input_buffer.fifo_mem\[12\]\[5\] VGND VGND VPWR VPWR net737 sky130_fd_sc_hd__dlygate4sd3_1
Xhold503 u_input_buffer.fifo_mem\[6\]\[9\] VGND VGND VPWR VPWR net715 sky130_fd_sc_hd__dlygate4sd3_1
X_7272_ u_input_buffer.fifo_mem\[53\]\[12\] _2933_ _2935_ u_input_buffer.fifo_mem\[57\]\[12\]
+ VGND VGND VPWR VPWR _3512_ sky130_fd_sc_hd__a22o_1
X_4484_ _1699_ VGND VGND VPWR VPWR _0162_ sky130_fd_sc_hd__clkbuf_1
Xhold514 u_input_buffer.fifo_mem\[31\]\[15\] VGND VGND VPWR VPWR net726 sky130_fd_sc_hd__dlygate4sd3_1
Xhold547 u_input_buffer.fifo_mem\[11\]\[1\] VGND VGND VPWR VPWR net759 sky130_fd_sc_hd__dlygate4sd3_1
Xhold558 u_input_buffer.fifo_mem\[43\]\[3\] VGND VGND VPWR VPWR net770 sky130_fd_sc_hd__dlygate4sd3_1
X_6223_ _2666_ VGND VGND VPWR VPWR _0934_ sky130_fd_sc_hd__clkbuf_1
X_9011_ clknet_leaf_70_clk _1100_ VGND VGND VPWR VPWR u_input_buffer.fifo_mem\[0\]\[9\]
+ sky130_fd_sc_hd__dfxtp_1
Xhold569 u_input_buffer.fifo_mem\[17\]\[14\] VGND VGND VPWR VPWR net781 sky130_fd_sc_hd__dlygate4sd3_1
XFILLER_0_0_551 VGND VGND VPWR VPWR sky130_fd_sc_hd__decap_4
X_6154_ _2629_ VGND VGND VPWR VPWR _0902_ sky130_fd_sc_hd__clkbuf_1
XFILLER_0_0_584 VGND VGND VPWR VPWR sky130_fd_sc_hd__decap_4
XTAP_830 VGND VPWR sky130_fd_sc_hd__tapvpwrvgnd_1
XTAP_841 VGND VPWR sky130_fd_sc_hd__tapvpwrvgnd_1
XTAP_852 VGND VPWR sky130_fd_sc_hd__tapvpwrvgnd_1
X_6085_ net685 _2506_ _2587_ VGND VGND VPWR VPWR _2592_ sky130_fd_sc_hd__mux2_1
X_5105_ _2053_ VGND VGND VPWR VPWR _0429_ sky130_fd_sc_hd__clkbuf_1
XFILLER_0_57_72 VGND VGND VPWR VPWR sky130_fd_sc_hd__fill_1
XTAP_863 VGND VPWR sky130_fd_sc_hd__tapvpwrvgnd_1
XTAP_885 VGND VPWR sky130_fd_sc_hd__tapvpwrvgnd_1
XTAP_874 VGND VPWR sky130_fd_sc_hd__tapvpwrvgnd_1
X_5036_ net649 _2014_ _1989_ VGND VGND VPWR VPWR _2015_ sky130_fd_sc_hd__mux2_1
XTAP_896 VGND VPWR sky130_fd_sc_hd__tapvpwrvgnd_1
X_6987_ u_input_buffer.fifo_mem\[3\]\[4\] _3070_ _3072_ u_input_buffer.fifo_mem\[60\]\[4\]
+ VGND VGND VPWR VPWR _3235_ sky130_fd_sc_hd__a22o_1
X_5938_ _1408_ VGND VGND VPWR VPWR _2508_ sky130_fd_sc_hd__buf_4
X_8726_ clknet_leaf_10_clk _0815_ VGND VGND VPWR VPWR u_input_buffer.fifo_mem\[18\]\[12\]
+ sky130_fd_sc_hd__dfxtp_1
X_5869_ net622 _2258_ _2461_ VGND VGND VPWR VPWR _2469_ sky130_fd_sc_hd__mux2_1
X_8657_ clknet_leaf_54_clk _0746_ VGND VGND VPWR VPWR u_input_buffer.fifo_mem\[22\]\[7\]
+ sky130_fd_sc_hd__dfxtp_1
XFILLER_0_90_343 VGND VGND VPWR VPWR sky130_fd_sc_hd__fill_1
X_8588_ clknet_leaf_44_clk _0677_ VGND VGND VPWR VPWR u_input_buffer.fifo_mem\[26\]\[2\]
+ sky130_fd_sc_hd__dfxtp_1
X_7608_ net24 u_register_bank.threshold_cfg\[20\] _3759_ VGND VGND VPWR VPWR _3760_
+ sky130_fd_sc_hd__mux2_1
X_7539_ net24 u_register_bank.window_cfg\[20\] _3722_ VGND VGND VPWR VPWR _3723_ sky130_fd_sc_hd__mux2_1
X_9209_ net171 _1296_ net204 VGND VGND VPWR VPWR u_register_bank.sensor_enable\[10\]
+ sky130_fd_sc_hd__dfrtp_1
Xinput101 sensor_data_in[5] VGND VGND VPWR VPWR net101 sky130_fd_sc_hd__clkbuf_1
Xinput112 sensor_valid[2] VGND VGND VPWR VPWR net112 sky130_fd_sc_hd__buf_4
XFILLER_0_86_627 VGND VGND VPWR VPWR sky130_fd_sc_hd__decap_8
XPHY_151 VGND VGND VPWR VPWR sky130_fd_sc_hd__decap_3
XPHY_140 VGND VGND VPWR VPWR sky130_fd_sc_hd__decap_3
XPHY_184 VGND VGND VPWR VPWR sky130_fd_sc_hd__decap_3
XPHY_173 VGND VGND VPWR VPWR sky130_fd_sc_hd__decap_3
XPHY_162 VGND VGND VPWR VPWR sky130_fd_sc_hd__decap_3
XPHY_195 VGND VGND VPWR VPWR sky130_fd_sc_hd__decap_3
XFILLER_0_112_607 VPWR VGND VPWR VGND sky130_ef_sc_hd__decap_12
XFILLER_0_105_681 VGND VGND VPWR VPWR sky130_fd_sc_hd__decap_4
XFILLER_0_78_27 VGND VGND VPWR VPWR sky130_fd_sc_hd__fill_1
XFILLER_0_1_337 VPWR VGND VPWR VGND sky130_ef_sc_hd__decap_12
XFILLER_0_89_443 VGND VGND VPWR VPWR sky130_fd_sc_hd__fill_2
X_6910_ u_input_buffer.fifo_mem\[26\]\[2\] _3066_ _3068_ u_input_buffer.fifo_mem\[62\]\[2\]
+ _3159_ VGND VGND VPWR VPWR _3160_ sky130_fd_sc_hd__a221o_1
X_7890_ clknet_leaf_79_clk net236 net191 VGND VGND VPWR VPWR u_register_bank.status_flags\[10\]
+ sky130_fd_sc_hd__dfrtp_1
X_6841_ u_input_buffer.fifo_mem\[37\]\[1\] _2923_ _2926_ u_input_buffer.fifo_mem\[9\]\[1\]
+ VGND VGND VPWR VPWR _3092_ sky130_fd_sc_hd__a22o_1
XFILLER_0_9_426 VGND VGND VPWR VPWR sky130_fd_sc_hd__fill_2
XFILLER_0_43_74 VGND VGND VPWR VPWR sky130_fd_sc_hd__fill_1
X_3984_ _1342_ VGND VGND VPWR VPWR _0019_ sky130_fd_sc_hd__clkbuf_1
X_8511_ clknet_leaf_53_clk _0600_ VGND VGND VPWR VPWR u_input_buffer.fifo_mem\[31\]\[5\]
+ sky130_fd_sc_hd__dfxtp_1
XFILLER_0_85_671 VGND VGND VPWR VPWR sky130_fd_sc_hd__fill_1
X_6772_ _2924_ _3023_ VGND VGND VPWR VPWR _3024_ sky130_fd_sc_hd__and2_2
XFILLER_0_45_502 VGND VGND VPWR VPWR sky130_fd_sc_hd__fill_2
X_5723_ _2391_ VGND VGND VPWR VPWR _0709_ sky130_fd_sc_hd__clkbuf_1
X_8442_ clknet_leaf_28_clk _0531_ VGND VGND VPWR VPWR u_input_buffer.fifo_mem\[35\]\[0\]
+ sky130_fd_sc_hd__dfxtp_1
X_5654_ net485 _2248_ _2352_ VGND VGND VPWR VPWR _2355_ sky130_fd_sc_hd__mux2_1
XFILLER_0_5_665 VGND VGND VPWR VPWR sky130_fd_sc_hd__decap_6
X_8373_ clknet_leaf_93_clk _0462_ VGND VGND VPWR VPWR u_input_buffer.fifo_mem\[40\]\[11\]
+ sky130_fd_sc_hd__dfxtp_1
X_4605_ net335 _1734_ _1756_ VGND VGND VPWR VPWR _1773_ sky130_fd_sc_hd__mux2_1
X_5585_ net601 _2248_ _2315_ VGND VGND VPWR VPWR _2318_ sky130_fd_sc_hd__mux2_1
Xhold300 u_input_buffer.fifo_mem\[44\]\[3\] VGND VGND VPWR VPWR net512 sky130_fd_sc_hd__dlygate4sd3_1
X_7324_ _3547_ _3549_ _3553_ _3562_ VGND VGND VPWR VPWR _3563_ sky130_fd_sc_hd__or4_2
XFILLER_0_25_281 VGND VGND VPWR VPWR sky130_fd_sc_hd__decap_4
Xhold311 u_input_buffer.fifo_mem\[0\]\[13\] VGND VGND VPWR VPWR net523 sky130_fd_sc_hd__dlygate4sd3_1
Xhold333 u_input_buffer.fifo_mem\[50\]\[1\] VGND VGND VPWR VPWR net545 sky130_fd_sc_hd__dlygate4sd3_1
Xhold344 u_input_buffer.fifo_mem\[3\]\[13\] VGND VGND VPWR VPWR net556 sky130_fd_sc_hd__dlygate4sd3_1
XFILLER_0_7_30 VPWR VGND VPWR VGND sky130_ef_sc_hd__decap_12
X_4536_ _1735_ VGND VGND VPWR VPWR _0178_ sky130_fd_sc_hd__clkbuf_1
Xhold322 u_input_buffer.fifo_mem\[40\]\[14\] VGND VGND VPWR VPWR net534 sky130_fd_sc_hd__dlygate4sd3_1
XFILLER_0_111_673 VGND VGND VPWR VPWR sky130_fd_sc_hd__decap_3
X_4467_ net1294 _1616_ _1683_ VGND VGND VPWR VPWR _1691_ sky130_fd_sc_hd__mux2_1
Xhold377 u_input_buffer.fifo_mem\[51\]\[3\] VGND VGND VPWR VPWR net589 sky130_fd_sc_hd__dlygate4sd3_1
Xhold355 u_input_buffer.fifo_mem\[63\]\[13\] VGND VGND VPWR VPWR net567 sky130_fd_sc_hd__dlygate4sd3_1
X_7255_ _3489_ _3491_ _3493_ _3495_ VGND VGND VPWR VPWR _3496_ sky130_fd_sc_hd__or4_1
Xhold366 u_input_buffer.fifo_mem\[27\]\[10\] VGND VGND VPWR VPWR net578 sky130_fd_sc_hd__dlygate4sd3_1
Xhold388 u_input_buffer.fifo_mem\[14\]\[9\] VGND VGND VPWR VPWR net600 sky130_fd_sc_hd__dlygate4sd3_1
Xhold399 u_input_buffer.fifo_mem\[11\]\[7\] VGND VGND VPWR VPWR net611 sky130_fd_sc_hd__dlygate4sd3_1
X_7186_ _3422_ _3424_ _3426_ _3428_ VGND VGND VPWR VPWR _3429_ sky130_fd_sc_hd__or4_1
X_4398_ _1651_ VGND VGND VPWR VPWR _0124_ sky130_fd_sc_hd__clkbuf_1
X_6206_ net637 _2522_ _2643_ VGND VGND VPWR VPWR _2657_ sky130_fd_sc_hd__mux2_1
XFILLER_0_110_194 VGND VGND VPWR VPWR sky130_fd_sc_hd__fill_2
X_6137_ _1626_ net1235 _2606_ VGND VGND VPWR VPWR _2620_ sky130_fd_sc_hd__mux2_1
Xhold1000 u_input_buffer.fifo_mem\[33\]\[10\] VGND VGND VPWR VPWR net1212 sky130_fd_sc_hd__dlygate4sd3_1
XTAP_660 VGND VPWR sky130_fd_sc_hd__tapvpwrvgnd_1
Xhold1011 u_input_buffer.fifo_mem\[20\]\[15\] VGND VGND VPWR VPWR net1223 sky130_fd_sc_hd__dlygate4sd3_1
XTAP_671 VGND VPWR sky130_fd_sc_hd__tapvpwrvgnd_1
XTAP_682 VGND VPWR sky130_fd_sc_hd__tapvpwrvgnd_1
XTAP_693 VGND VPWR sky130_fd_sc_hd__tapvpwrvgnd_1
Xhold1033 u_input_buffer.fifo_mem\[53\]\[4\] VGND VGND VPWR VPWR net1245 sky130_fd_sc_hd__dlygate4sd3_1
Xhold1022 u_input_buffer.fifo_mem\[25\]\[2\] VGND VGND VPWR VPWR net1234 sky130_fd_sc_hd__dlygate4sd3_1
Xhold1055 u_input_buffer.fifo_mem\[62\]\[10\] VGND VGND VPWR VPWR net1267 sky130_fd_sc_hd__dlygate4sd3_1
Xhold1066 u_input_buffer.fifo_mem\[59\]\[14\] VGND VGND VPWR VPWR net1278 sky130_fd_sc_hd__dlygate4sd3_1
Xhold1044 u_input_buffer.fifo_mem\[37\]\[12\] VGND VGND VPWR VPWR net1256 sky130_fd_sc_hd__dlygate4sd3_1
X_6068_ _2582_ VGND VGND VPWR VPWR _0863_ sky130_fd_sc_hd__clkbuf_1
X_5019_ _2003_ VGND VGND VPWR VPWR _0393_ sky130_fd_sc_hd__clkbuf_1
Xhold1099 u_input_buffer.fifo_mem\[49\]\[5\] VGND VGND VPWR VPWR net1311 sky130_fd_sc_hd__dlygate4sd3_1
Xhold1088 u_input_buffer.fifo_mem\[49\]\[9\] VGND VGND VPWR VPWR net1300 sky130_fd_sc_hd__dlygate4sd3_1
Xhold1077 u_input_buffer.fifo_mem\[49\]\[12\] VGND VGND VPWR VPWR net1289 sky130_fd_sc_hd__dlygate4sd3_1
X_8709_ clknet_leaf_80_clk _0798_ VGND VGND VPWR VPWR u_input_buffer.fifo_mem\[19\]\[11\]
+ sky130_fd_sc_hd__dfxtp_1
XFILLER_0_75_192 VGND VGND VPWR VPWR sky130_fd_sc_hd__decap_4
XFILLER_0_16_270 VGND VGND VPWR VPWR sky130_fd_sc_hd__fill_2
XFILLER_0_101_150 VGND VGND VPWR VPWR sky130_fd_sc_hd__decap_6
XFILLER_0_64_29 VGND VGND VPWR VPWR sky130_fd_sc_hd__decap_3
XFILLER_0_98_262 VGND VGND VPWR VPWR sky130_fd_sc_hd__fill_2
XFILLER_0_59_638 VGND VGND VPWR VPWR sky130_fd_sc_hd__decap_6
XFILLER_0_73_129 VGND VGND VPWR VPWR sky130_fd_sc_hd__decap_4
XFILLER_0_67_682 VGND VGND VPWR VPWR sky130_fd_sc_hd__fill_1
XFILLER_0_13_55 VGND VGND VPWR VPWR sky130_fd_sc_hd__fill_1
XFILLER_0_6_407 VGND VGND VPWR VPWR sky130_fd_sc_hd__fill_2
XFILLER_0_39_373 VGND VGND VPWR VPWR sky130_fd_sc_hd__decap_8
XFILLER_0_89_15 VPWR VGND VPWR VGND sky130_ef_sc_hd__decap_12
XFILLER_0_2_613 VPWR VGND VPWR VGND sky130_ef_sc_hd__decap_12
X_5370_ _2194_ VGND VGND VPWR VPWR _0553_ sky130_fd_sc_hd__clkbuf_1
XFILLER_0_2_657 VPWR VGND VPWR VGND sky130_ef_sc_hd__decap_12
X_4321_ _1596_ _1599_ VGND VGND VPWR VPWR _1600_ sky130_fd_sc_hd__nand2_4
XFILLER_0_10_468 VGND VGND VPWR VPWR sky130_fd_sc_hd__fill_1
X_7040_ u_input_buffer.fifo_mem\[29\]\[6\] _2939_ _2941_ u_input_buffer.fifo_mem\[13\]\[6\]
+ _3285_ VGND VGND VPWR VPWR _3286_ sky130_fd_sc_hd__a221o_1
X_4252_ net216 _1531_ VGND VGND VPWR VPWR _0097_ sky130_fd_sc_hd__xor2_1
XFILLER_0_38_63 VGND VGND VPWR VPWR sky130_fd_sc_hd__decap_6
X_4183_ u_sample_counter.sample_count\[6\] u_sample_counter.sample_count\[7\] u_sample_counter.sample_count\[8\]
+ _1483_ VGND VGND VPWR VPWR _1487_ sky130_fd_sc_hd__and4_2
X_8991_ clknet_leaf_4_clk _1080_ VGND VGND VPWR VPWR u_input_buffer.fifo_mem\[1\]\[5\]
+ sky130_fd_sc_hd__dfxtp_1
X_7942_ clknet_leaf_84_clk _0032_ VGND VGND VPWR VPWR u_sensor_interface.sensor_array\[1\]\[14\]
+ sky130_fd_sc_hd__dfxtp_2
XFILLER_0_54_62 VGND VGND VPWR VPWR sky130_fd_sc_hd__fill_2
X_7873_ _3936_ VGND VGND VPWR VPWR _1314_ sky130_fd_sc_hd__clkbuf_1
XFILLER_0_92_416 VGND VGND VPWR VPWR sky130_fd_sc_hd__decap_4
XFILLER_0_77_468 VGND VGND VPWR VPWR sky130_fd_sc_hd__decap_4
X_6824_ _3075_ VGND VGND VPWR VPWR _3076_ sky130_fd_sc_hd__clkbuf_4
XFILLER_0_9_223 VGND VGND VPWR VPWR sky130_fd_sc_hd__fill_1
X_3967_ _1333_ VGND VGND VPWR VPWR _0011_ sky130_fd_sc_hd__clkbuf_1
X_6755_ _2917_ VGND VGND VPWR VPWR _3007_ sky130_fd_sc_hd__clkbuf_4
XFILLER_0_73_663 VGND VGND VPWR VPWR sky130_fd_sc_hd__fill_1
X_5706_ _1624_ net1062 _2369_ VGND VGND VPWR VPWR _2382_ sky130_fd_sc_hd__mux2_1
XFILLER_0_115_231 VGND VGND VPWR VPWR sky130_fd_sc_hd__decap_3
Xclkbuf_leaf_30_clk clknet_3_5__leaf_clk VGND VGND VPWR VPWR clknet_leaf_30_clk sky130_fd_sc_hd__clkbuf_16
X_8425_ clknet_leaf_99_clk _0514_ VGND VGND VPWR VPWR u_input_buffer.fifo_mem\[37\]\[15\]
+ sky130_fd_sc_hd__dfxtp_1
X_6686_ _2902_ _2906_ VGND VGND VPWR VPWR _2938_ sky130_fd_sc_hd__nor2_4
XFILLER_0_115_264 VGND VGND VPWR VPWR sky130_fd_sc_hd__decap_3
XFILLER_0_115_253 VGND VGND VPWR VPWR sky130_fd_sc_hd__decap_8
XFILLER_0_72_184 VGND VGND VPWR VPWR sky130_fd_sc_hd__decap_4
X_5637_ _2345_ VGND VGND VPWR VPWR _0669_ sky130_fd_sc_hd__clkbuf_1
X_5568_ _2308_ VGND VGND VPWR VPWR _0637_ sky130_fd_sc_hd__clkbuf_1
X_8356_ clknet_leaf_99_clk _0445_ VGND VGND VPWR VPWR u_input_buffer.fifo_mem\[41\]\[10\]
+ sky130_fd_sc_hd__dfxtp_1
Xhold130 u_input_buffer.fifo_mem\[11\]\[0\] VGND VGND VPWR VPWR net342 sky130_fd_sc_hd__dlygate4sd3_1
X_8287_ clknet_leaf_20_clk _0376_ VGND VGND VPWR VPWR u_input_buffer.fifo_mem\[45\]\[5\]
+ sky130_fd_sc_hd__dfxtp_1
Xhold152 u_input_buffer.fifo_mem\[56\]\[10\] VGND VGND VPWR VPWR net364 sky130_fd_sc_hd__dlygate4sd3_1
Xhold141 u_sensor_interface.sensor_array\[0\]\[11\] VGND VGND VPWR VPWR net353 sky130_fd_sc_hd__dlygate4sd3_1
X_7307_ u_input_buffer.fifo_mem\[21\]\[13\] _2908_ _2912_ u_input_buffer.fifo_mem\[25\]\[13\]
+ VGND VGND VPWR VPWR _3546_ sky130_fd_sc_hd__a22o_1
X_4519_ _1438_ VGND VGND VPWR VPWR _1724_ sky130_fd_sc_hd__buf_4
Xhold185 u_input_buffer.fifo_mem\[46\]\[2\] VGND VGND VPWR VPWR net397 sky130_fd_sc_hd__dlygate4sd3_1
Xhold163 u_input_buffer.fifo_mem\[54\]\[3\] VGND VGND VPWR VPWR net375 sky130_fd_sc_hd__dlygate4sd3_1
X_5499_ _2269_ VGND VGND VPWR VPWR _0607_ sky130_fd_sc_hd__clkbuf_1
X_7238_ u_input_buffer.fifo_mem\[36\]\[11\] _2950_ _2954_ u_input_buffer.fifo_mem\[35\]\[11\]
+ _3478_ VGND VGND VPWR VPWR _3479_ sky130_fd_sc_hd__a221o_1
Xhold174 u_input_buffer.fifo_mem\[32\]\[13\] VGND VGND VPWR VPWR net386 sky130_fd_sc_hd__dlygate4sd3_1
Xhold196 u_input_buffer.fifo_mem\[16\]\[13\] VGND VGND VPWR VPWR net408 sky130_fd_sc_hd__dlygate4sd3_1
X_7169_ u_input_buffer.fifo_mem\[47\]\[9\] _2879_ _3007_ _3009_ u_input_buffer.fifo_mem\[24\]\[9\]
+ VGND VGND VPWR VPWR _3412_ sky130_fd_sc_hd__a32o_1
Xclkbuf_leaf_97_clk clknet_3_1__leaf_clk VGND VGND VPWR VPWR clknet_leaf_97_clk sky130_fd_sc_hd__clkbuf_16
XTAP_490 VGND VPWR sky130_fd_sc_hd__tapvpwrvgnd_1
XTAP_1623 VGND VPWR sky130_fd_sc_hd__tapvpwrvgnd_1
XTAP_1612 VGND VPWR sky130_fd_sc_hd__tapvpwrvgnd_1
XTAP_1601 VGND VPWR sky130_fd_sc_hd__tapvpwrvgnd_1
XFILLER_0_68_457 VGND VGND VPWR VPWR sky130_fd_sc_hd__decap_3
XTAP_1645 VGND VPWR sky130_fd_sc_hd__tapvpwrvgnd_1
XTAP_1634 VGND VPWR sky130_fd_sc_hd__tapvpwrvgnd_1
XFILLER_0_83_449 VGND VGND VPWR VPWR sky130_fd_sc_hd__fill_1
XFILLER_0_49_682 VGND VGND VPWR VPWR sky130_fd_sc_hd__decap_4
XFILLER_0_36_354 VGND VGND VPWR VPWR sky130_fd_sc_hd__decap_8
Xclkbuf_leaf_21_clk clknet_3_4__leaf_clk VGND VGND VPWR VPWR clknet_leaf_21_clk sky130_fd_sc_hd__clkbuf_16
XFILLER_0_36_365 VGND VGND VPWR VPWR sky130_fd_sc_hd__decap_6
XFILLER_0_106_253 VGND VGND VPWR VPWR sky130_fd_sc_hd__decap_3
XFILLER_0_51_368 VGND VGND VPWR VPWR sky130_fd_sc_hd__fill_2
Xclkbuf_leaf_88_clk clknet_3_2__leaf_clk VGND VGND VPWR VPWR clknet_leaf_88_clk sky130_fd_sc_hd__clkbuf_16
X_4870_ net553 _1716_ _1912_ VGND VGND VPWR VPWR _1919_ sky130_fd_sc_hd__mux2_1
XFILLER_0_47_608 VGND VGND VPWR VPWR sky130_fd_sc_hd__decap_3
XFILLER_0_86_287 VGND VGND VPWR VPWR sky130_fd_sc_hd__fill_1
X_6540_ _2834_ VGND VGND VPWR VPWR _1083_ sky130_fd_sc_hd__clkbuf_1
Xclkbuf_leaf_12_clk clknet_3_1__leaf_clk VGND VGND VPWR VPWR clknet_leaf_12_clk sky130_fd_sc_hd__clkbuf_16
X_6471_ net293 _1426_ _2789_ VGND VGND VPWR VPWR _2798_ sky130_fd_sc_hd__mux2_1
XFILLER_0_70_666 VGND VGND VPWR VPWR sky130_fd_sc_hd__decap_3
X_8210_ clknet_leaf_14_clk _0299_ VGND VGND VPWR VPWR u_input_buffer.fifo_mem\[50\]\[8\]
+ sky130_fd_sc_hd__dfxtp_1
X_9190_ clknet_leaf_87_clk _1278_ net189 VGND VGND VPWR VPWR net162 sky130_fd_sc_hd__dfrtp_4
XFILLER_0_2_421 VGND VGND VPWR VPWR sky130_fd_sc_hd__decap_6
X_5422_ _2221_ VGND VGND VPWR VPWR _0578_ sky130_fd_sc_hd__clkbuf_1
X_8141_ clknet_leaf_41_clk _0230_ VGND VGND VPWR VPWR u_input_buffer.fifo_mem\[54\]\[3\]
+ sky130_fd_sc_hd__dfxtp_1
XFILLER_0_2_443 VPWR VGND VPWR VGND sky130_ef_sc_hd__decap_12
X_5353_ net308 _2020_ _2168_ VGND VGND VPWR VPWR _2185_ sky130_fd_sc_hd__mux2_1
XFILLER_0_100_418 VGND VGND VPWR VPWR sky130_fd_sc_hd__fill_2
X_4304_ _1535_ _1537_ _1558_ _1583_ VGND VGND VPWR VPWR _1584_ sky130_fd_sc_hd__o22a_1
X_8072_ clknet_leaf_86_clk _0161_ VGND VGND VPWR VPWR u_input_buffer.fifo_mem\[59\]\[14\]
+ sky130_fd_sc_hd__dfxtp_1
X_5284_ _2148_ VGND VGND VPWR VPWR _0513_ sky130_fd_sc_hd__clkbuf_1
X_7023_ u_input_buffer.fifo_mem\[23\]\[5\] _3046_ _3048_ u_input_buffer.fifo_mem\[20\]\[5\]
+ _3269_ VGND VGND VPWR VPWR _3270_ sky130_fd_sc_hd__a221o_1
Xclkbuf_leaf_79_clk clknet_3_3__leaf_clk VGND VGND VPWR VPWR clknet_leaf_79_clk sky130_fd_sc_hd__clkbuf_16
X_4235_ _1520_ _1521_ _1519_ VGND VGND VPWR VPWR _1522_ sky130_fd_sc_hd__nor3_1
X_4166_ _1475_ _1476_ VGND VGND VPWR VPWR _0067_ sky130_fd_sc_hd__nor2_1
X_8974_ clknet_leaf_24_clk _1063_ VGND VGND VPWR VPWR u_input_buffer.fifo_mem\[2\]\[4\]
+ sky130_fd_sc_hd__dfxtp_1
X_4097_ _1415_ _1418_ _0000_ VGND VGND VPWR VPWR _1419_ sky130_fd_sc_hd__mux2_1
X_7925_ clknet_leaf_110_clk _0015_ VGND VGND VPWR VPWR u_sensor_interface.sensor_array\[2\]\[13\]
+ sky130_fd_sc_hd__dfxtp_1
X_7856_ net24 u_register_bank.sensor_enable\[20\] _3927_ VGND VGND VPWR VPWR _3928_
+ sky130_fd_sc_hd__mux2_1
XFILLER_0_77_276 VGND VGND VPWR VPWR sky130_fd_sc_hd__fill_1
X_6807_ _2878_ _2924_ VGND VGND VPWR VPWR _3059_ sky130_fd_sc_hd__and2_2
X_7787_ net158 u_analytics_engine.data_in\[4\] _1474_ VGND VGND VPWR VPWR _3891_ sky130_fd_sc_hd__mux2_1
X_4999_ _1989_ VGND VGND VPWR VPWR _1990_ sky130_fd_sc_hd__buf_4
X_6738_ _2989_ VGND VGND VPWR VPWR _2990_ sky130_fd_sc_hd__clkbuf_4
XFILLER_0_18_365 VGND VGND VPWR VPWR sky130_fd_sc_hd__decap_8
XFILLER_0_33_335 VGND VGND VPWR VPWR sky130_fd_sc_hd__fill_1
X_6669_ _2920_ VGND VGND VPWR VPWR _2921_ sky130_fd_sc_hd__clkbuf_4
XFILLER_0_14_560 VPWR VGND VPWR VGND sky130_ef_sc_hd__decap_12
XFILLER_0_21_508 VGND VGND VPWR VPWR sky130_fd_sc_hd__fill_2
X_8408_ clknet_leaf_91_clk _0497_ VGND VGND VPWR VPWR u_input_buffer.fifo_mem\[38\]\[14\]
+ sky130_fd_sc_hd__dfxtp_1
XFILLER_0_103_256 VGND VGND VPWR VPWR sky130_fd_sc_hd__fill_2
X_8339_ clknet_leaf_28_clk _0428_ VGND VGND VPWR VPWR u_input_buffer.fifo_mem\[42\]\[9\]
+ sky130_fd_sc_hd__dfxtp_1
XFILLER_0_96_541 VGND VGND VPWR VPWR sky130_fd_sc_hd__fill_2
XTAP_1442 VGND VPWR sky130_fd_sc_hd__tapvpwrvgnd_1
XTAP_1431 VGND VPWR sky130_fd_sc_hd__tapvpwrvgnd_1
XTAP_1420 VGND VPWR sky130_fd_sc_hd__tapvpwrvgnd_1
XFILLER_0_96_552 VGND VGND VPWR VPWR sky130_fd_sc_hd__fill_2
XFILLER_0_61_19 VGND VGND VPWR VPWR sky130_fd_sc_hd__fill_1
XTAP_1475 VGND VPWR sky130_fd_sc_hd__tapvpwrvgnd_1
XTAP_1464 VGND VPWR sky130_fd_sc_hd__tapvpwrvgnd_1
XTAP_1453 VGND VPWR sky130_fd_sc_hd__tapvpwrvgnd_1
XTAP_1497 VGND VPWR sky130_fd_sc_hd__tapvpwrvgnd_1
XTAP_1486 VGND VPWR sky130_fd_sc_hd__tapvpwrvgnd_1
XFILLER_0_101_69 VPWR VGND VPWR VGND sky130_ef_sc_hd__decap_12
XFILLER_0_86_27 VGND VGND VPWR VPWR sky130_fd_sc_hd__fill_1
X_4020_ _1361_ VGND VGND VPWR VPWR _0036_ sky130_fd_sc_hd__clkbuf_1
Xclkbuf_leaf_1_clk clknet_3_1__leaf_clk VGND VGND VPWR VPWR clknet_leaf_1_clk sky130_fd_sc_hd__clkbuf_16
X_5971_ net166 _2295_ VGND VGND VPWR VPWR _2530_ sky130_fd_sc_hd__nand2_4
XFILLER_0_35_75 VGND VGND VPWR VPWR sky130_fd_sc_hd__fill_1
X_8690_ clknet_leaf_49_clk _0779_ VGND VGND VPWR VPWR u_input_buffer.fifo_mem\[20\]\[8\]
+ sky130_fd_sc_hd__dfxtp_1
XFILLER_0_87_574 VGND VGND VPWR VPWR sky130_fd_sc_hd__decap_4
X_7710_ u_register_bank.status_flags\[16\] _3814_ _3808_ u_register_bank.sensor_enable\[16\]
+ VGND VGND VPWR VPWR _3834_ sky130_fd_sc_hd__a22o_1
X_4922_ net322 _1730_ _1933_ VGND VGND VPWR VPWR _1948_ sky130_fd_sc_hd__mux2_1
X_7641_ net10 net205 VGND VGND VPWR VPWR _3781_ sky130_fd_sc_hd__nand2_2
XFILLER_0_51_30 VGND VGND VPWR VPWR sky130_fd_sc_hd__fill_1
X_4853_ _1469_ net1290 _1892_ VGND VGND VPWR VPWR _1909_ sky130_fd_sc_hd__mux2_1
XFILLER_0_47_449 VGND VGND VPWR VPWR sky130_fd_sc_hd__fill_2
X_7572_ net37 u_analytics_engine.threshold\[3\] _3737_ VGND VGND VPWR VPWR _3741_
+ sky130_fd_sc_hd__mux2_1
X_4784_ _1871_ VGND VGND VPWR VPWR _0290_ sky130_fd_sc_hd__clkbuf_1
X_6523_ _1588_ net824 _2825_ VGND VGND VPWR VPWR _2826_ sky130_fd_sc_hd__mux2_1
X_6454_ _2788_ VGND VGND VPWR VPWR _2789_ sky130_fd_sc_hd__buf_4
XFILLER_0_15_379 VGND VGND VPWR VPWR sky130_fd_sc_hd__fill_1
X_5405_ _1421_ net945 _2205_ VGND VGND VPWR VPWR _2213_ sky130_fd_sc_hd__mux2_1
X_9173_ net181 _1261_ VGND VGND VPWR VPWR net129 sky130_fd_sc_hd__dfxtp_2
XFILLER_0_62_3 VGND VGND VPWR VPWR sky130_fd_sc_hd__decap_8
XFILLER_0_11_541 VPWR VGND VPWR VGND sky130_ef_sc_hd__decap_12
XFILLER_0_23_390 VGND VGND VPWR VPWR sky130_fd_sc_hd__fill_2
X_6385_ _1815_ _2605_ VGND VGND VPWR VPWR _2752_ sky130_fd_sc_hd__nand2_4
X_8124_ clknet_leaf_49_clk _0213_ VGND VGND VPWR VPWR u_input_buffer.fifo_mem\[55\]\[2\]
+ sky130_fd_sc_hd__dfxtp_1
X_5336_ _2176_ VGND VGND VPWR VPWR _0537_ sky130_fd_sc_hd__clkbuf_1
XFILLER_0_11_585 VGND VGND VPWR VPWR sky130_fd_sc_hd__decap_6
X_5267_ _1415_ net1209 _2133_ VGND VGND VPWR VPWR _2140_ sky130_fd_sc_hd__mux2_1
X_8055_ clknet_leaf_88_clk _0144_ VGND VGND VPWR VPWR u_input_buffer.fifo_mem\[60\]\[13\]
+ sky130_fd_sc_hd__dfxtp_1
X_7006_ u_input_buffer.fifo_mem\[34\]\[5\] _2966_ _2969_ u_input_buffer.fifo_mem\[48\]\[5\]
+ _3252_ VGND VGND VPWR VPWR _3253_ sky130_fd_sc_hd__a221o_1
XFILLER_0_76_82 VGND VGND VPWR VPWR sky130_fd_sc_hd__fill_2
X_4218_ _1509_ _1510_ VGND VGND VPWR VPWR _1511_ sky130_fd_sc_hd__and2_1
X_5198_ _2103_ VGND VGND VPWR VPWR _0472_ sky130_fd_sc_hd__clkbuf_1
X_4149_ _1462_ VGND VGND VPWR VPWR _1463_ sky130_fd_sc_hd__clkbuf_2
X_8957_ clknet_leaf_42_clk _1046_ VGND VGND VPWR VPWR u_input_buffer.fifo_mem\[3\]\[3\]
+ sky130_fd_sc_hd__dfxtp_1
X_7908_ clknet_leaf_62_clk net237 net195 VGND VGND VPWR VPWR u_register_bank.status_flags\[28\]
+ sky130_fd_sc_hd__dfrtp_1
XFILLER_0_93_511 VGND VGND VPWR VPWR sky130_fd_sc_hd__fill_1
X_8888_ clknet_leaf_75_clk _0977_ VGND VGND VPWR VPWR u_input_buffer.fifo_mem\[8\]\[14\]
+ sky130_fd_sc_hd__dfxtp_1
XFILLER_0_65_257 VGND VGND VPWR VPWR sky130_fd_sc_hd__fill_2
X_7839_ net15 u_register_bank.sensor_enable\[12\] _3916_ VGND VGND VPWR VPWR _3919_
+ sky130_fd_sc_hd__mux2_1
XFILLER_0_80_216 VGND VGND VPWR VPWR sky130_fd_sc_hd__fill_2
XFILLER_0_65_279 VGND VGND VPWR VPWR sky130_fd_sc_hd__fill_1
XFILLER_0_18_151 VGND VGND VPWR VPWR sky130_fd_sc_hd__fill_2
XFILLER_0_33_154 VGND VGND VPWR VPWR sky130_fd_sc_hd__fill_1
XFILLER_0_34_677 VGND VGND VPWR VPWR sky130_fd_sc_hd__fill_1
XFILLER_0_84_522 VGND VGND VPWR VPWR sky130_fd_sc_hd__fill_1
XTAP_1250 VGND VPWR sky130_fd_sc_hd__tapvpwrvgnd_1
XTAP_1272 VGND VPWR sky130_fd_sc_hd__tapvpwrvgnd_1
XTAP_1283 VGND VPWR sky130_fd_sc_hd__tapvpwrvgnd_1
XTAP_1261 VGND VPWR sky130_fd_sc_hd__tapvpwrvgnd_1
XFILLER_0_29_449 VGND VGND VPWR VPWR sky130_fd_sc_hd__fill_2
XTAP_1294 VGND VPWR sky130_fd_sc_hd__tapvpwrvgnd_1
XFILLER_0_4_505 VPWR VGND VPWR VGND sky130_ef_sc_hd__decap_12
XFILLER_0_25_644 VPWR VGND VPWR VGND sky130_ef_sc_hd__decap_12
XFILLER_0_114_329 VGND VGND VPWR VPWR sky130_fd_sc_hd__decap_4
Xhold707 u_input_buffer.fifo_mem\[30\]\[10\] VGND VGND VPWR VPWR net919 sky130_fd_sc_hd__dlygate4sd3_1
Xhold718 u_input_buffer.fifo_mem\[21\]\[8\] VGND VGND VPWR VPWR net930 sky130_fd_sc_hd__dlygate4sd3_1
Xhold729 u_input_buffer.fifo_mem\[48\]\[12\] VGND VGND VPWR VPWR net941 sky130_fd_sc_hd__dlygate4sd3_1
X_6170_ _2637_ VGND VGND VPWR VPWR _0910_ sky130_fd_sc_hd__clkbuf_1
X_5121_ _2062_ VGND VGND VPWR VPWR _0436_ sky130_fd_sc_hd__clkbuf_1
X_5052_ net1041 _1992_ _2024_ VGND VGND VPWR VPWR _2026_ sky130_fd_sc_hd__mux2_1
X_4003_ _1352_ VGND VGND VPWR VPWR _0028_ sky130_fd_sc_hd__clkbuf_1
X_8811_ clknet_leaf_25_clk _0900_ VGND VGND VPWR VPWR u_input_buffer.fifo_mem\[12\]\[1\]
+ sky130_fd_sc_hd__dfxtp_1
X_8742_ clknet_leaf_109_clk _0831_ VGND VGND VPWR VPWR u_input_buffer.fifo_mem\[17\]\[12\]
+ sky130_fd_sc_hd__dfxtp_1
XFILLER_0_1_54 VGND VGND VPWR VPWR sky130_fd_sc_hd__fill_2
X_5954_ net961 _2518_ _2497_ VGND VGND VPWR VPWR _2519_ sky130_fd_sc_hd__mux2_1
XFILLER_0_1_87 VGND VGND VPWR VPWR sky130_fd_sc_hd__fill_1
XFILLER_0_87_393 VGND VGND VPWR VPWR sky130_fd_sc_hd__fill_2
X_4905_ _1939_ VGND VGND VPWR VPWR _0343_ sky130_fd_sc_hd__clkbuf_1
X_5885_ net1223 _2274_ _2460_ VGND VGND VPWR VPWR _2477_ sky130_fd_sc_hd__mux2_1
X_8673_ clknet_leaf_6_clk _0762_ VGND VGND VPWR VPWR u_input_buffer.fifo_mem\[21\]\[7\]
+ sky130_fd_sc_hd__dfxtp_1
X_4836_ _1900_ VGND VGND VPWR VPWR _0313_ sky130_fd_sc_hd__clkbuf_1
X_7624_ net32 u_register_bank.threshold_cfg\[28\] _3759_ VGND VGND VPWR VPWR _3768_
+ sky130_fd_sc_hd__mux2_1
XFILLER_0_47_279 VGND VGND VPWR VPWR sky130_fd_sc_hd__fill_1
X_7555_ net32 u_register_bank.window_cfg\[28\] _3722_ VGND VGND VPWR VPWR _3731_ sky130_fd_sc_hd__mux2_1
X_4767_ net502 _1718_ _1855_ VGND VGND VPWR VPWR _1863_ sky130_fd_sc_hd__mux2_1
X_6506_ _2816_ VGND VGND VPWR VPWR _1067_ sky130_fd_sc_hd__clkbuf_1
XFILLER_0_31_603 VPWR VGND VPWR VGND sky130_ef_sc_hd__decap_12
X_7486_ _3692_ VGND VGND VPWR VPWR _1171_ sky130_fd_sc_hd__clkbuf_1
XFILLER_0_30_102 VGND VGND VPWR VPWR sky130_fd_sc_hd__decap_3
X_4698_ _1825_ VGND VGND VPWR VPWR _0250_ sky130_fd_sc_hd__clkbuf_1
X_6437_ net316 _1426_ _2771_ VGND VGND VPWR VPWR _2780_ sky130_fd_sc_hd__mux2_1
X_9225_ net173 _1312_ net204 VGND VGND VPWR VPWR u_register_bank.sensor_enable\[26\]
+ sky130_fd_sc_hd__dfrtp_1
X_6368_ _2743_ VGND VGND VPWR VPWR _1002_ sky130_fd_sc_hd__clkbuf_1
X_9156_ net180 _1244_ VGND VGND VPWR VPWR net142 sky130_fd_sc_hd__dfxtp_1
XFILLER_0_11_360 VGND VGND VPWR VPWR sky130_fd_sc_hd__decap_3
X_8107_ clknet_leaf_56_clk _0196_ VGND VGND VPWR VPWR u_input_buffer.fifo_mem\[56\]\[1\]
+ sky130_fd_sc_hd__dfxtp_1
X_5319_ net283 _2020_ _2150_ VGND VGND VPWR VPWR _2167_ sky130_fd_sc_hd__mux2_1
Xhold23 u_sample_counter.sample_count\[7\] VGND VGND VPWR VPWR net235 sky130_fd_sc_hd__dlygate4sd3_1
X_9087_ net177 _1175_ net209 VGND VGND VPWR VPWR u_register_bank.window_cfg\[1\] sky130_fd_sc_hd__dfrtp_1
X_6299_ _2706_ VGND VGND VPWR VPWR _0970_ sky130_fd_sc_hd__clkbuf_1
Xhold12 u_sample_counter.sample_count\[29\] VGND VGND VPWR VPWR net224 sky130_fd_sc_hd__dlygate4sd3_1
Xhold34 u_sample_counter.sample_count\[0\] VGND VGND VPWR VPWR net246 sky130_fd_sc_hd__dlygate4sd3_1
Xhold56 u_input_buffer.fifo_mem\[47\]\[4\] VGND VGND VPWR VPWR net268 sky130_fd_sc_hd__dlygate4sd3_1
Xhold45 u_input_buffer.fifo_mem\[0\]\[9\] VGND VGND VPWR VPWR net257 sky130_fd_sc_hd__dlygate4sd3_1
X_8038_ clknet_leaf_106_clk _0127_ VGND VGND VPWR VPWR u_input_buffer.fifo_mem\[61\]\[12\]
+ sky130_fd_sc_hd__dfxtp_1
Xhold67 u_input_buffer.fifo_mem\[0\]\[5\] VGND VGND VPWR VPWR net279 sky130_fd_sc_hd__dlygate4sd3_1
Xhold78 u_input_buffer.fifo_mem\[2\]\[9\] VGND VGND VPWR VPWR net290 sky130_fd_sc_hd__dlygate4sd3_1
Xhold89 u_input_buffer.fifo_mem\[35\]\[14\] VGND VGND VPWR VPWR net301 sky130_fd_sc_hd__dlygate4sd3_1
XFILLER_0_97_113 VGND VGND VPWR VPWR sky130_fd_sc_hd__fill_2
XFILLER_0_66_599 VGND VGND VPWR VPWR sky130_fd_sc_hd__fill_1
XANTENNA_9 _3449_ VGND VGND VPWR VPWR sky130_fd_sc_hd__diode_2
XTAP_319 VGND VPWR sky130_fd_sc_hd__tapvpwrvgnd_1
XTAP_308 VGND VPWR sky130_fd_sc_hd__tapvpwrvgnd_1
XFILLER_0_83_39 VGND VGND VPWR VPWR sky130_fd_sc_hd__decap_8
XFILLER_0_107_57 VPWR VGND VPWR VGND sky130_ef_sc_hd__decap_12
XFILLER_0_16_77 VGND VGND VPWR VPWR sky130_fd_sc_hd__decap_6
XTAP_1091 VGND VPWR sky130_fd_sc_hd__tapvpwrvgnd_1
XTAP_1080 VGND VPWR sky130_fd_sc_hd__tapvpwrvgnd_1
X_5670_ net608 _2264_ _2351_ VGND VGND VPWR VPWR _2363_ sky130_fd_sc_hd__mux2_1
X_4621_ _1783_ VGND VGND VPWR VPWR _0215_ sky130_fd_sc_hd__clkbuf_1
XFILLER_0_4_302 VGND VGND VPWR VPWR sky130_fd_sc_hd__decap_6
XFILLER_0_4_357 VGND VGND VPWR VPWR sky130_fd_sc_hd__decap_6
X_7340_ u_input_buffer.fifo_mem\[54\]\[13\] _3077_ _3079_ u_input_buffer.fifo_mem\[46\]\[13\]
+ VGND VGND VPWR VPWR _3579_ sky130_fd_sc_hd__a22o_1
X_4552_ _1415_ net731 _1738_ VGND VGND VPWR VPWR _1745_ sky130_fd_sc_hd__mux2_1
Xhold526 u_input_buffer.fifo_mem\[35\]\[7\] VGND VGND VPWR VPWR net738 sky130_fd_sc_hd__dlygate4sd3_1
Xhold504 u_input_buffer.fifo_mem\[22\]\[5\] VGND VGND VPWR VPWR net716 sky130_fd_sc_hd__dlygate4sd3_1
Xhold515 u_input_buffer.fifo_mem\[18\]\[7\] VGND VGND VPWR VPWR net727 sky130_fd_sc_hd__dlygate4sd3_1
XFILLER_0_13_669 VGND VGND VPWR VPWR sky130_fd_sc_hd__decap_3
X_4483_ net895 _1632_ _1682_ VGND VGND VPWR VPWR _1699_ sky130_fd_sc_hd__mux2_1
X_7271_ u_input_buffer.fifo_mem\[41\]\[12\] _2918_ _2920_ u_input_buffer.fifo_mem\[45\]\[12\]
+ _3510_ VGND VGND VPWR VPWR _3511_ sky130_fd_sc_hd__a221o_1
Xhold559 u_input_buffer.fifo_mem\[35\]\[0\] VGND VGND VPWR VPWR net771 sky130_fd_sc_hd__dlygate4sd3_1
X_6222_ net690 _2504_ _2662_ VGND VGND VPWR VPWR _2666_ sky130_fd_sc_hd__mux2_1
X_9010_ clknet_leaf_70_clk _1099_ VGND VGND VPWR VPWR u_input_buffer.fifo_mem\[0\]\[8\]
+ sky130_fd_sc_hd__dfxtp_1
Xhold537 u_input_buffer.fifo_mem\[23\]\[12\] VGND VGND VPWR VPWR net749 sky130_fd_sc_hd__dlygate4sd3_1
Xhold548 u_input_buffer.fifo_mem\[57\]\[7\] VGND VGND VPWR VPWR net760 sky130_fd_sc_hd__dlygate4sd3_1
X_6153_ net377 _2504_ _2625_ VGND VGND VPWR VPWR _2629_ sky130_fd_sc_hd__mux2_1
XTAP_820 VGND VPWR sky130_fd_sc_hd__tapvpwrvgnd_1
XTAP_831 VGND VPWR sky130_fd_sc_hd__tapvpwrvgnd_1
XTAP_842 VGND VPWR sky130_fd_sc_hd__tapvpwrvgnd_1
XTAP_853 VGND VPWR sky130_fd_sc_hd__tapvpwrvgnd_1
X_6084_ _2591_ VGND VGND VPWR VPWR _0870_ sky130_fd_sc_hd__clkbuf_1
X_5104_ net302 _2010_ _2041_ VGND VGND VPWR VPWR _2053_ sky130_fd_sc_hd__mux2_1
XTAP_864 VGND VPWR sky130_fd_sc_hd__tapvpwrvgnd_1
XTAP_886 VGND VPWR sky130_fd_sc_hd__tapvpwrvgnd_1
XTAP_875 VGND VPWR sky130_fd_sc_hd__tapvpwrvgnd_1
X_5035_ _1450_ VGND VGND VPWR VPWR _2014_ sky130_fd_sc_hd__clkbuf_4
XTAP_897 VGND VPWR sky130_fd_sc_hd__tapvpwrvgnd_1
X_6986_ u_input_buffer.fifo_mem\[10\]\[4\] _3056_ _3058_ u_input_buffer.fifo_mem\[44\]\[4\]
+ _3233_ VGND VGND VPWR VPWR _3234_ sky130_fd_sc_hd__a221o_1
XFILLER_0_94_105 VGND VGND VPWR VPWR sky130_fd_sc_hd__fill_1
X_5937_ _2507_ VGND VGND VPWR VPWR _0807_ sky130_fd_sc_hd__clkbuf_1
X_8725_ clknet_leaf_10_clk _0814_ VGND VGND VPWR VPWR u_input_buffer.fifo_mem\[18\]\[11\]
+ sky130_fd_sc_hd__dfxtp_1
X_8656_ clknet_leaf_53_clk _0745_ VGND VGND VPWR VPWR u_input_buffer.fifo_mem\[22\]\[6\]
+ sky130_fd_sc_hd__dfxtp_1
X_5868_ _2468_ VGND VGND VPWR VPWR _0777_ sky130_fd_sc_hd__clkbuf_1
X_7607_ _3736_ VGND VGND VPWR VPWR _3759_ sky130_fd_sc_hd__buf_4
XFILLER_0_106_616 VGND VGND VPWR VPWR sky130_fd_sc_hd__decap_6
X_5799_ net295 _2256_ _2425_ VGND VGND VPWR VPWR _2432_ sky130_fd_sc_hd__mux2_1
X_8587_ clknet_leaf_43_clk _0676_ VGND VGND VPWR VPWR u_input_buffer.fifo_mem\[26\]\[1\]
+ sky130_fd_sc_hd__dfxtp_1
XFILLER_0_8_685 VGND VGND VPWR VPWR sky130_fd_sc_hd__fill_1
XFILLER_0_7_151 VGND VGND VPWR VPWR sky130_fd_sc_hd__decap_6
X_4819_ _1890_ VGND VGND VPWR VPWR _0306_ sky130_fd_sc_hd__clkbuf_1
X_7538_ _3699_ VGND VGND VPWR VPWR _3722_ sky130_fd_sc_hd__buf_4
X_7469_ net1003 _1408_ _3678_ VGND VGND VPWR VPWR _3684_ sky130_fd_sc_hd__mux2_1
XFILLER_0_113_181 VPWR VGND VPWR VGND sky130_ef_sc_hd__decap_12
X_9208_ net174 _1295_ net206 VGND VGND VPWR VPWR u_register_bank.sensor_enable\[9\]
+ sky130_fd_sc_hd__dfrtp_1
XFILLER_0_101_365 VGND VGND VPWR VPWR sky130_fd_sc_hd__fill_1
X_9139_ net177 _1227_ net209 VGND VGND VPWR VPWR u_register_bank.threshold_cfg\[21\]
+ sky130_fd_sc_hd__dfrtp_1
Xinput102 sensor_data_in[60] VGND VGND VPWR VPWR net102 sky130_fd_sc_hd__clkbuf_1
Xinput113 sensor_valid[3] VGND VGND VPWR VPWR net113 sky130_fd_sc_hd__buf_6
XFILLER_0_86_639 VGND VGND VPWR VPWR sky130_fd_sc_hd__fill_2
XFILLER_0_39_500 VGND VGND VPWR VPWR sky130_fd_sc_hd__decap_4
XPHY_152 VGND VGND VPWR VPWR sky130_fd_sc_hd__decap_3
XPHY_141 VGND VGND VPWR VPWR sky130_fd_sc_hd__decap_3
XFILLER_0_66_363 VGND VGND VPWR VPWR sky130_fd_sc_hd__fill_1
XPHY_130 VGND VGND VPWR VPWR sky130_fd_sc_hd__decap_3
XPHY_185 VGND VGND VPWR VPWR sky130_fd_sc_hd__decap_3
XFILLER_0_93_182 VGND VGND VPWR VPWR sky130_fd_sc_hd__fill_2
XPHY_174 VGND VGND VPWR VPWR sky130_fd_sc_hd__decap_3
XPHY_163 VGND VGND VPWR VPWR sky130_fd_sc_hd__decap_3
XPHY_196 VGND VGND VPWR VPWR sky130_fd_sc_hd__decap_3
Xclkbuf_3_1__f_clk clknet_0_clk VGND VGND VPWR VPWR clknet_3_1__leaf_clk sky130_fd_sc_hd__clkbuf_16
XFILLER_0_112_619 VPWR VGND VPWR VGND sky130_ef_sc_hd__decap_12
XFILLER_0_105_671 VGND VGND VPWR VPWR sky130_fd_sc_hd__fill_1
XFILLER_0_1_349 VGND VGND VPWR VPWR sky130_fd_sc_hd__decap_4
XFILLER_0_89_411 VGND VGND VPWR VPWR sky130_fd_sc_hd__fill_1
XFILLER_0_11_9 VPWR VGND VPWR VGND sky130_ef_sc_hd__decap_12
X_6840_ u_input_buffer.fifo_mem\[33\]\[1\] _2898_ _2904_ u_input_buffer.fifo_mem\[61\]\[1\]
+ _3090_ VGND VGND VPWR VPWR _3091_ sky130_fd_sc_hd__a221o_1
XFILLER_0_76_138 VGND VGND VPWR VPWR sky130_fd_sc_hd__fill_2
X_6771_ _2877_ _2876_ _2872_ _2873_ VGND VGND VPWR VPWR _3023_ sky130_fd_sc_hd__and4b_1
X_3983_ u_sensor_interface.sensor_array\[1\]\[1\] net54 _1334_ VGND VGND VPWR VPWR
+ _1342_ sky130_fd_sc_hd__mux2_1
X_5722_ net618 _2248_ _2388_ VGND VGND VPWR VPWR _2391_ sky130_fd_sc_hd__mux2_1
X_8510_ clknet_leaf_68_clk _0599_ VGND VGND VPWR VPWR u_input_buffer.fifo_mem\[31\]\[4\]
+ sky130_fd_sc_hd__dfxtp_1
XFILLER_0_45_514 VGND VGND VPWR VPWR sky130_fd_sc_hd__decap_3
XFILLER_0_115_424 VGND VGND VPWR VPWR sky130_fd_sc_hd__fill_2
X_5653_ _2354_ VGND VGND VPWR VPWR _0676_ sky130_fd_sc_hd__clkbuf_1
XFILLER_0_45_558 VGND VGND VPWR VPWR sky130_fd_sc_hd__fill_2
X_8441_ clknet_leaf_11_clk _0530_ VGND VGND VPWR VPWR u_input_buffer.fifo_mem\[36\]\[15\]
+ sky130_fd_sc_hd__dfxtp_1
XFILLER_0_115_457 VGND VGND VPWR VPWR sky130_fd_sc_hd__decap_3
X_5584_ _2317_ VGND VGND VPWR VPWR _0644_ sky130_fd_sc_hd__clkbuf_1
XFILLER_0_60_528 VGND VGND VPWR VPWR sky130_fd_sc_hd__fill_1
X_8372_ clknet_leaf_70_clk _0461_ VGND VGND VPWR VPWR u_input_buffer.fifo_mem\[40\]\[10\]
+ sky130_fd_sc_hd__dfxtp_1
X_4604_ _1772_ VGND VGND VPWR VPWR _0209_ sky130_fd_sc_hd__clkbuf_1
XFILLER_0_4_154 VGND VGND VPWR VPWR sky130_fd_sc_hd__fill_1
X_4535_ net392 _1734_ _1703_ VGND VGND VPWR VPWR _1735_ sky130_fd_sc_hd__mux2_1
Xhold301 u_input_buffer.fifo_mem\[54\]\[13\] VGND VGND VPWR VPWR net513 sky130_fd_sc_hd__dlygate4sd3_1
X_7323_ _3555_ _3557_ _3559_ _3561_ VGND VGND VPWR VPWR _3562_ sky130_fd_sc_hd__or4_1
Xhold323 u_input_buffer.fifo_mem\[42\]\[0\] VGND VGND VPWR VPWR net535 sky130_fd_sc_hd__dlygate4sd3_1
Xhold312 u_input_buffer.fifo_mem\[18\]\[0\] VGND VGND VPWR VPWR net524 sky130_fd_sc_hd__dlygate4sd3_1
Xhold334 u_input_buffer.fifo_mem\[2\]\[3\] VGND VGND VPWR VPWR net546 sky130_fd_sc_hd__dlygate4sd3_1
XFILLER_0_7_42 VPWR VGND VPWR VGND sky130_ef_sc_hd__decap_12
XFILLER_0_111_641 VPWR VGND VPWR VGND sky130_ef_sc_hd__decap_12
Xhold378 u_input_buffer.fifo_mem\[48\]\[0\] VGND VGND VPWR VPWR net590 sky130_fd_sc_hd__dlygate4sd3_1
X_4466_ _1690_ VGND VGND VPWR VPWR _0153_ sky130_fd_sc_hd__clkbuf_1
Xhold367 u_input_buffer.fifo_mem\[51\]\[4\] VGND VGND VPWR VPWR net579 sky130_fd_sc_hd__dlygate4sd3_1
Xhold345 u_input_buffer.fifo_mem\[20\]\[11\] VGND VGND VPWR VPWR net557 sky130_fd_sc_hd__dlygate4sd3_1
X_7254_ u_input_buffer.fifo_mem\[6\]\[11\] _3034_ _3036_ u_input_buffer.fifo_mem\[28\]\[11\]
+ _3494_ VGND VGND VPWR VPWR _3495_ sky130_fd_sc_hd__a221o_1
Xhold356 u_input_buffer.fifo_mem\[47\]\[8\] VGND VGND VPWR VPWR net568 sky130_fd_sc_hd__dlygate4sd3_1
XFILLER_0_110_151 VGND VGND VPWR VPWR sky130_fd_sc_hd__decap_6
Xhold389 u_input_buffer.fifo_mem\[28\]\[2\] VGND VGND VPWR VPWR net601 sky130_fd_sc_hd__dlygate4sd3_1
X_7185_ u_input_buffer.fifo_mem\[63\]\[9\] _2886_ _3076_ u_input_buffer.fifo_mem\[55\]\[9\]
+ _3427_ VGND VGND VPWR VPWR _3428_ sky130_fd_sc_hd__a221o_1
X_4397_ _1433_ net1072 _1641_ VGND VGND VPWR VPWR _1651_ sky130_fd_sc_hd__mux2_1
XFILLER_0_0_360 VGND VGND VPWR VPWR sky130_fd_sc_hd__decap_4
X_6205_ _2656_ VGND VGND VPWR VPWR _0926_ sky130_fd_sc_hd__clkbuf_1
X_6136_ _2619_ VGND VGND VPWR VPWR _0894_ sky130_fd_sc_hd__clkbuf_1
XFILLER_0_0_393 VGND VGND VPWR VPWR sky130_fd_sc_hd__decap_8
XTAP_661 VGND VPWR sky130_fd_sc_hd__tapvpwrvgnd_1
XTAP_650 VGND VPWR sky130_fd_sc_hd__tapvpwrvgnd_1
Xhold1001 u_input_buffer.fifo_mem\[41\]\[9\] VGND VGND VPWR VPWR net1213 sky130_fd_sc_hd__dlygate4sd3_1
Xhold1023 u_input_buffer.fifo_mem\[13\]\[12\] VGND VGND VPWR VPWR net1235 sky130_fd_sc_hd__dlygate4sd3_1
Xhold1012 u_input_buffer.fifo_mem\[29\]\[6\] VGND VGND VPWR VPWR net1224 sky130_fd_sc_hd__dlygate4sd3_1
XTAP_672 VGND VPWR sky130_fd_sc_hd__tapvpwrvgnd_1
XTAP_683 VGND VPWR sky130_fd_sc_hd__tapvpwrvgnd_1
XTAP_694 VGND VPWR sky130_fd_sc_hd__tapvpwrvgnd_1
Xhold1034 u_input_buffer.fifo_mem\[44\]\[2\] VGND VGND VPWR VPWR net1246 sky130_fd_sc_hd__dlygate4sd3_1
Xhold1067 u_input_buffer.fifo_mem\[31\]\[1\] VGND VGND VPWR VPWR net1279 sky130_fd_sc_hd__dlygate4sd3_1
Xhold1045 u_input_buffer.fifo_mem\[61\]\[13\] VGND VGND VPWR VPWR net1257 sky130_fd_sc_hd__dlygate4sd3_1
Xhold1056 u_input_buffer.fifo_mem\[49\]\[10\] VGND VGND VPWR VPWR net1268 sky130_fd_sc_hd__dlygate4sd3_1
X_6067_ net306 _2522_ _2568_ VGND VGND VPWR VPWR _2582_ sky130_fd_sc_hd__mux2_1
X_5018_ net670 _2002_ _1990_ VGND VGND VPWR VPWR _2003_ sky130_fd_sc_hd__mux2_1
Xhold1089 u_input_buffer.fifo_mem\[49\]\[7\] VGND VGND VPWR VPWR net1301 sky130_fd_sc_hd__dlygate4sd3_1
Xhold1078 u_input_buffer.fifo_mem\[49\]\[15\] VGND VGND VPWR VPWR net1290 sky130_fd_sc_hd__dlygate4sd3_1
XFILLER_0_82_108 VGND VGND VPWR VPWR sky130_fd_sc_hd__decap_6
X_6969_ u_input_buffer.fifo_mem\[12\]\[4\] _2980_ _2982_ u_input_buffer.fifo_mem\[18\]\[4\]
+ _3216_ VGND VGND VPWR VPWR _3217_ sky130_fd_sc_hd__a221o_1
XFILLER_0_48_363 VGND VGND VPWR VPWR sky130_fd_sc_hd__fill_1
X_8708_ clknet_leaf_73_clk _0797_ VGND VGND VPWR VPWR u_input_buffer.fifo_mem\[19\]\[10\]
+ sky130_fd_sc_hd__dfxtp_1
X_8639_ clknet_leaf_52_clk _0728_ VGND VGND VPWR VPWR u_input_buffer.fifo_mem\[23\]\[5\]
+ sky130_fd_sc_hd__dfxtp_1
XFILLER_0_90_141 VGND VGND VPWR VPWR sky130_fd_sc_hd__fill_2
XFILLER_0_44_580 VGND VGND VPWR VPWR sky130_fd_sc_hd__fill_2
Xhold890 u_input_buffer.fifo_mem\[25\]\[10\] VGND VGND VPWR VPWR net1102 sky130_fd_sc_hd__dlygate4sd3_1
XFILLER_0_80_29 VPWR VGND VPWR VGND sky130_ef_sc_hd__decap_12
XFILLER_0_58_138 VGND VGND VPWR VPWR sky130_fd_sc_hd__fill_2
XFILLER_0_27_503 VGND VGND VPWR VPWR sky130_fd_sc_hd__fill_1
XFILLER_0_39_363 VGND VGND VPWR VPWR sky130_fd_sc_hd__fill_1
XFILLER_0_89_27 VPWR VGND VPWR VGND sky130_ef_sc_hd__decap_12
XFILLER_0_35_580 VGND VGND VPWR VPWR sky130_fd_sc_hd__decap_8
XFILLER_0_2_625 VPWR VGND VPWR VGND sky130_ef_sc_hd__decap_12
XFILLER_0_1_146 VGND VGND VPWR VPWR sky130_fd_sc_hd__decap_3
XFILLER_0_2_669 VPWR VGND VPWR VGND sky130_ef_sc_hd__decap_12
X_4320_ _1597_ _1598_ VGND VGND VPWR VPWR _1599_ sky130_fd_sc_hd__and2_2
X_4251_ _1531_ _1532_ VGND VGND VPWR VPWR _0096_ sky130_fd_sc_hd__nor2_1
X_4182_ net235 _1484_ VGND VGND VPWR VPWR _0073_ sky130_fd_sc_hd__xnor2_1
X_8990_ clknet_leaf_4_clk _1079_ VGND VGND VPWR VPWR u_input_buffer.fifo_mem\[1\]\[4\]
+ sky130_fd_sc_hd__dfxtp_1
X_7941_ clknet_leaf_84_clk _0031_ VGND VGND VPWR VPWR u_sensor_interface.sensor_array\[1\]\[13\]
+ sky130_fd_sc_hd__dfxtp_1
X_7872_ net32 u_register_bank.sensor_enable\[28\] _3927_ VGND VGND VPWR VPWR _3936_
+ sky130_fd_sc_hd__mux2_1
X_6823_ _2885_ _2882_ _3023_ VGND VGND VPWR VPWR _3075_ sky130_fd_sc_hd__and3_2
X_3966_ u_sensor_interface.sensor_array\[2\]\[9\] net81 _1323_ VGND VGND VPWR VPWR
+ _1333_ sky130_fd_sc_hd__mux2_1
X_6754_ _3005_ VGND VGND VPWR VPWR _3006_ sky130_fd_sc_hd__clkbuf_4
X_5705_ _2381_ VGND VGND VPWR VPWR _0701_ sky130_fd_sc_hd__clkbuf_1
XFILLER_0_9_279 VGND VGND VPWR VPWR sky130_fd_sc_hd__fill_1
X_6685_ u_input_buffer.fifo_mem\[53\]\[0\] _2934_ _2936_ u_input_buffer.fifo_mem\[57\]\[0\]
+ VGND VGND VPWR VPWR _2937_ sky130_fd_sc_hd__a22o_1
XFILLER_0_92_3 VPWR VGND VPWR VGND sky130_ef_sc_hd__decap_12
X_8424_ clknet_leaf_100_clk _0513_ VGND VGND VPWR VPWR u_input_buffer.fifo_mem\[37\]\[14\]
+ sky130_fd_sc_hd__dfxtp_1
X_5636_ net578 _2264_ _2333_ VGND VGND VPWR VPWR _2345_ sky130_fd_sc_hd__mux2_1
X_8355_ clknet_leaf_20_clk _0444_ VGND VGND VPWR VPWR u_input_buffer.fifo_mem\[41\]\[9\]
+ sky130_fd_sc_hd__dfxtp_1
XFILLER_0_13_252 VGND VGND VPWR VPWR sky130_fd_sc_hd__fill_1
X_5567_ _1439_ net1057 _2296_ VGND VGND VPWR VPWR _2308_ sky130_fd_sc_hd__mux2_1
XFILLER_0_41_561 VGND VGND VPWR VPWR sky130_fd_sc_hd__decap_6
Xhold120 u_sensor_interface.sensor_array\[1\]\[0\] VGND VGND VPWR VPWR net332 sky130_fd_sc_hd__dlygate4sd3_1
Xhold142 u_input_buffer.fifo_mem\[15\]\[1\] VGND VGND VPWR VPWR net354 sky130_fd_sc_hd__dlygate4sd3_1
X_4518_ _1723_ VGND VGND VPWR VPWR _0172_ sky130_fd_sc_hd__clkbuf_1
X_8286_ clknet_leaf_21_clk _0375_ VGND VGND VPWR VPWR u_input_buffer.fifo_mem\[45\]\[4\]
+ sky130_fd_sc_hd__dfxtp_1
Xhold153 u_input_buffer.fifo_mem\[54\]\[15\] VGND VGND VPWR VPWR net365 sky130_fd_sc_hd__dlygate4sd3_1
X_5498_ net924 _2268_ _2243_ VGND VGND VPWR VPWR _2269_ sky130_fd_sc_hd__mux2_1
X_7306_ u_analytics_engine.data_in\[12\] _2892_ _3544_ _3545_ VGND VGND VPWR VPWR
+ _1138_ sky130_fd_sc_hd__a22o_1
Xhold131 u_input_buffer.fifo_mem\[47\]\[10\] VGND VGND VPWR VPWR net343 sky130_fd_sc_hd__dlygate4sd3_1
Xhold164 u_sensor_interface.sensor_array\[1\]\[4\] VGND VGND VPWR VPWR net376 sky130_fd_sc_hd__dlygate4sd3_1
Xhold175 u_input_buffer.fifo_mem\[15\]\[7\] VGND VGND VPWR VPWR net387 sky130_fd_sc_hd__dlygate4sd3_1
Xhold186 u_input_buffer.fifo_mem\[12\]\[9\] VGND VGND VPWR VPWR net398 sky130_fd_sc_hd__dlygate4sd3_1
XFILLER_0_0_9 VGND VGND VPWR VPWR sky130_fd_sc_hd__fill_1
X_4449_ _1678_ _1679_ VGND VGND VPWR VPWR _1680_ sky130_fd_sc_hd__nor2_1
X_7237_ u_input_buffer.fifo_mem\[14\]\[11\] _2957_ _2960_ u_input_buffer.fifo_mem\[42\]\[11\]
+ VGND VGND VPWR VPWR _3478_ sky130_fd_sc_hd__a22o_1
Xhold197 u_input_buffer.fifo_mem\[18\]\[15\] VGND VGND VPWR VPWR net409 sky130_fd_sc_hd__dlygate4sd3_1
XFILLER_0_95_81 VGND VGND VPWR VPWR sky130_fd_sc_hd__decap_8
X_7168_ _3395_ _3397_ _3401_ _3410_ VGND VGND VPWR VPWR _3411_ sky130_fd_sc_hd__or4_2
X_7099_ _3337_ _3339_ _3341_ _3343_ VGND VGND VPWR VPWR _3344_ sky130_fd_sc_hd__or4_1
XTAP_491 VGND VPWR sky130_fd_sc_hd__tapvpwrvgnd_1
XTAP_480 VGND VPWR sky130_fd_sc_hd__tapvpwrvgnd_1
X_6119_ _1608_ net1127 _2607_ VGND VGND VPWR VPWR _2611_ sky130_fd_sc_hd__mux2_1
XFILLER_0_68_403 VGND VGND VPWR VPWR sky130_fd_sc_hd__decap_4
XTAP_1624 VGND VPWR sky130_fd_sc_hd__tapvpwrvgnd_1
XTAP_1613 VGND VPWR sky130_fd_sc_hd__tapvpwrvgnd_1
XTAP_1602 VGND VPWR sky130_fd_sc_hd__tapvpwrvgnd_1
XTAP_1646 VGND VPWR sky130_fd_sc_hd__tapvpwrvgnd_1
XTAP_1635 VGND VPWR sky130_fd_sc_hd__tapvpwrvgnd_1
XFILLER_0_48_160 VGND VGND VPWR VPWR sky130_fd_sc_hd__fill_1
XFILLER_0_63_141 VGND VGND VPWR VPWR sky130_fd_sc_hd__fill_1
XFILLER_0_106_265 VGND VGND VPWR VPWR sky130_fd_sc_hd__decap_3
XFILLER_0_32_550 VGND VGND VPWR VPWR sky130_fd_sc_hd__fill_2
XFILLER_0_115_13 VGND VGND VPWR VPWR sky130_fd_sc_hd__decap_8
XFILLER_0_59_436 VGND VGND VPWR VPWR sky130_fd_sc_hd__decap_3
XFILLER_0_115_57 VGND VGND VPWR VPWR sky130_fd_sc_hd__fill_2
XFILLER_0_74_406 VGND VGND VPWR VPWR sky130_fd_sc_hd__fill_2
XFILLER_0_70_601 VGND VGND VPWR VPWR sky130_fd_sc_hd__fill_1
XFILLER_0_54_141 VGND VGND VPWR VPWR sky130_fd_sc_hd__fill_2
X_6470_ _2797_ VGND VGND VPWR VPWR _1050_ sky130_fd_sc_hd__clkbuf_1
XFILLER_0_70_645 VPWR VGND VPWR VGND sky130_ef_sc_hd__decap_12
X_5421_ _1469_ net996 _2204_ VGND VGND VPWR VPWR _2221_ sky130_fd_sc_hd__mux2_1
X_8140_ clknet_leaf_34_clk _0229_ VGND VGND VPWR VPWR u_input_buffer.fifo_mem\[54\]\[2\]
+ sky130_fd_sc_hd__dfxtp_1
XFILLER_0_2_455 VPWR VGND VPWR VGND sky130_ef_sc_hd__decap_12
X_5352_ _2184_ VGND VGND VPWR VPWR _0545_ sky130_fd_sc_hd__clkbuf_1
X_4303_ _1561_ _1562_ _1569_ _1581_ _1582_ VGND VGND VPWR VPWR _1583_ sky130_fd_sc_hd__o221a_1
XFILLER_0_2_477 VPWR VGND VPWR VGND sky130_ef_sc_hd__decap_12
X_8071_ clknet_leaf_91_clk _0160_ VGND VGND VPWR VPWR u_input_buffer.fifo_mem\[59\]\[13\]
+ sky130_fd_sc_hd__dfxtp_1
XFILLER_0_50_391 VGND VGND VPWR VPWR sky130_fd_sc_hd__fill_1
X_7022_ u_input_buffer.fifo_mem\[39\]\[5\] _3050_ _3052_ u_input_buffer.fifo_mem\[40\]\[5\]
+ VGND VGND VPWR VPWR _3269_ sky130_fd_sc_hd__a22o_1
X_5283_ _1463_ net814 _2132_ VGND VGND VPWR VPWR _2148_ sky130_fd_sc_hd__mux2_1
XFILLER_0_49_96 VGND VGND VPWR VPWR sky130_fd_sc_hd__decap_4
X_4234_ u_sample_counter.sample_count\[25\] VGND VGND VPWR VPWR _1521_ sky130_fd_sc_hd__inv_2
X_4165_ u_analytics_engine.data_valid u_sample_counter.sample_count\[1\] net246 VGND
+ VGND VPWR VPWR _1476_ sky130_fd_sc_hd__and3_1
XFILLER_0_65_73 VGND VGND VPWR VPWR sky130_fd_sc_hd__decap_4
X_4096_ _1417_ u_sensor_interface.sensor_array\[3\]\[6\] _1381_ VGND VGND VPWR VPWR
+ _1418_ sky130_fd_sc_hd__mux2_1
X_8973_ clknet_leaf_18_clk _1062_ VGND VGND VPWR VPWR u_input_buffer.fifo_mem\[2\]\[3\]
+ sky130_fd_sc_hd__dfxtp_1
X_7924_ clknet_leaf_26_clk _0014_ VGND VGND VPWR VPWR u_sensor_interface.sensor_array\[2\]\[12\]
+ sky130_fd_sc_hd__dfxtp_2
XFILLER_0_77_222 VGND VGND VPWR VPWR sky130_fd_sc_hd__fill_2
X_7855_ _3904_ VGND VGND VPWR VPWR _3927_ sky130_fd_sc_hd__buf_4
X_6806_ _3057_ VGND VGND VPWR VPWR _3058_ sky130_fd_sc_hd__clkbuf_4
X_7786_ _3890_ VGND VGND VPWR VPWR _1273_ sky130_fd_sc_hd__clkbuf_1
XFILLER_0_58_491 VGND VGND VPWR VPWR sky130_fd_sc_hd__fill_2
X_4998_ _1659_ _1930_ VGND VGND VPWR VPWR _1989_ sky130_fd_sc_hd__nor2_4
X_3949_ _1324_ VGND VGND VPWR VPWR _0002_ sky130_fd_sc_hd__clkbuf_1
X_6737_ _2900_ _2953_ VGND VGND VPWR VPWR _2989_ sky130_fd_sc_hd__nor2_4
XFILLER_0_60_122 VGND VGND VPWR VPWR sky130_fd_sc_hd__fill_2
X_6668_ _2896_ _2902_ VGND VGND VPWR VPWR _2920_ sky130_fd_sc_hd__nor2_4
X_5619_ _2336_ VGND VGND VPWR VPWR _0660_ sky130_fd_sc_hd__clkbuf_1
XFILLER_0_61_656 VPWR VGND VPWR VGND sky130_ef_sc_hd__decap_12
X_6599_ u_input_buffer.count\[0\] u_input_buffer.count\[1\] u_input_buffer.count\[2\]
+ net997 VGND VGND VPWR VPWR _2867_ sky130_fd_sc_hd__o31a_1
X_8407_ clknet_leaf_93_clk _0496_ VGND VGND VPWR VPWR u_input_buffer.fifo_mem\[38\]\[13\]
+ sky130_fd_sc_hd__dfxtp_1
X_8338_ clknet_leaf_30_clk _0427_ VGND VGND VPWR VPWR u_input_buffer.fifo_mem\[42\]\[8\]
+ sky130_fd_sc_hd__dfxtp_1
XFILLER_0_14_572 VPWR VGND VPWR VGND sky130_ef_sc_hd__decap_12
XFILLER_0_103_279 VGND VGND VPWR VPWR sky130_fd_sc_hd__fill_1
X_8269_ clknet_leaf_41_clk _0358_ VGND VGND VPWR VPWR u_input_buffer.fifo_mem\[46\]\[3\]
+ sky130_fd_sc_hd__dfxtp_1
XFILLER_0_88_509 VGND VGND VPWR VPWR sky130_fd_sc_hd__decap_4
XFILLER_0_96_531 VGND VGND VPWR VPWR sky130_fd_sc_hd__fill_1
XTAP_1432 VGND VPWR sky130_fd_sc_hd__tapvpwrvgnd_1
XTAP_1421 VGND VPWR sky130_fd_sc_hd__tapvpwrvgnd_1
XTAP_1410 VGND VPWR sky130_fd_sc_hd__tapvpwrvgnd_1
XTAP_1465 VGND VPWR sky130_fd_sc_hd__tapvpwrvgnd_1
XTAP_1443 VGND VPWR sky130_fd_sc_hd__tapvpwrvgnd_1
XTAP_1454 VGND VPWR sky130_fd_sc_hd__tapvpwrvgnd_1
XFILLER_0_68_266 VGND VGND VPWR VPWR sky130_fd_sc_hd__fill_1
XFILLER_0_56_417 VGND VGND VPWR VPWR sky130_fd_sc_hd__decap_3
XTAP_1498 VGND VPWR sky130_fd_sc_hd__tapvpwrvgnd_1
XTAP_1487 VGND VPWR sky130_fd_sc_hd__tapvpwrvgnd_1
XTAP_1476 VGND VPWR sky130_fd_sc_hd__tapvpwrvgnd_1
XFILLER_0_101_15 VPWR VGND VPWR VGND sky130_ef_sc_hd__decap_12
XFILLER_0_36_174 VGND VGND VPWR VPWR sky130_fd_sc_hd__fill_2
XFILLER_0_107_574 VGND VGND VPWR VPWR sky130_fd_sc_hd__fill_1
XFILLER_0_12_509 VPWR VGND VPWR VGND sky130_ef_sc_hd__decap_12
XFILLER_0_51_133 VGND VGND VPWR VPWR sky130_fd_sc_hd__decap_3
XFILLER_0_51_166 VGND VGND VPWR VPWR sky130_fd_sc_hd__fill_2
XFILLER_0_20_531 VGND VGND VPWR VPWR sky130_fd_sc_hd__fill_1
XFILLER_0_19_55 VGND VGND VPWR VPWR sky130_fd_sc_hd__fill_1
XFILLER_0_59_222 VGND VGND VPWR VPWR sky130_fd_sc_hd__fill_2
X_5970_ _2529_ VGND VGND VPWR VPWR _0818_ sky130_fd_sc_hd__clkbuf_1
XFILLER_0_87_564 VGND VGND VPWR VPWR sky130_fd_sc_hd__fill_1
X_4921_ _1947_ VGND VGND VPWR VPWR _0351_ sky130_fd_sc_hd__clkbuf_1
X_7640_ u_register_bank.window_cfg\[0\] _3772_ _3773_ u_analytics_engine.threshold\[0\]
+ _3779_ VGND VGND VPWR VPWR _3780_ sky130_fd_sc_hd__a221o_1
X_4852_ _1908_ VGND VGND VPWR VPWR _0321_ sky130_fd_sc_hd__clkbuf_1
XFILLER_0_74_225 VGND VGND VPWR VPWR sky130_fd_sc_hd__fill_1
X_7571_ _3740_ VGND VGND VPWR VPWR _1208_ sky130_fd_sc_hd__clkbuf_1
XFILLER_0_28_653 VGND VGND VPWR VPWR sky130_fd_sc_hd__fill_1
X_4783_ net705 _1734_ _1854_ VGND VGND VPWR VPWR _1871_ sky130_fd_sc_hd__mux2_1
XFILLER_0_51_86 VGND VGND VPWR VPWR sky130_fd_sc_hd__fill_1
XFILLER_0_7_569 VGND VGND VPWR VPWR sky130_fd_sc_hd__fill_2
X_6522_ _2824_ VGND VGND VPWR VPWR _2825_ sky130_fd_sc_hd__buf_4
XFILLER_0_42_111 VGND VGND VPWR VPWR sky130_fd_sc_hd__fill_2
XFILLER_0_70_453 VGND VGND VPWR VPWR sky130_fd_sc_hd__fill_2
X_6453_ _1853_ _2567_ VGND VGND VPWR VPWR _2788_ sky130_fd_sc_hd__nor2_4
XFILLER_0_42_166 VGND VGND VPWR VPWR sky130_fd_sc_hd__fill_2
X_9172_ net173 _1260_ VGND VGND VPWR VPWR net128 sky130_fd_sc_hd__dfxtp_1
X_5404_ _2212_ VGND VGND VPWR VPWR _0569_ sky130_fd_sc_hd__clkbuf_1
X_8123_ clknet_leaf_36_clk _0212_ VGND VGND VPWR VPWR u_input_buffer.fifo_mem\[55\]\[1\]
+ sky130_fd_sc_hd__dfxtp_1
X_6384_ _2751_ VGND VGND VPWR VPWR _1010_ sky130_fd_sc_hd__clkbuf_1
XFILLER_0_100_249 VGND VGND VPWR VPWR sky130_fd_sc_hd__decap_3
X_5335_ net457 _2002_ _2169_ VGND VGND VPWR VPWR _2176_ sky130_fd_sc_hd__mux2_1
XFILLER_0_11_553 VGND VGND VPWR VPWR sky130_fd_sc_hd__decap_6
XFILLER_0_76_61 VPWR VGND VPWR VGND sky130_ef_sc_hd__decap_12
X_5266_ _2139_ VGND VGND VPWR VPWR _0504_ sky130_fd_sc_hd__clkbuf_1
X_8054_ clknet_leaf_88_clk _0143_ VGND VGND VPWR VPWR u_input_buffer.fifo_mem\[60\]\[12\]
+ sky130_fd_sc_hd__dfxtp_1
X_7005_ u_input_buffer.fifo_mem\[16\]\[5\] _2971_ _2973_ u_input_buffer.fifo_mem\[49\]\[5\]
+ _2975_ VGND VGND VPWR VPWR _3252_ sky130_fd_sc_hd__a221o_1
X_4217_ u_sample_counter.sample_count\[19\] _1507_ VGND VGND VPWR VPWR _1510_ sky130_fd_sc_hd__or2_1
X_5197_ net1201 _2000_ _2097_ VGND VGND VPWR VPWR _2103_ sky130_fd_sc_hd__mux2_1
X_4148_ u_input_buffer.data_in\[14\] VGND VGND VPWR VPWR _1462_ sky130_fd_sc_hd__clkbuf_4
X_8956_ clknet_leaf_44_clk _1045_ VGND VGND VPWR VPWR u_input_buffer.fifo_mem\[3\]\[2\]
+ sky130_fd_sc_hd__dfxtp_1
X_4079_ _1402_ VGND VGND VPWR VPWR _1403_ sky130_fd_sc_hd__buf_2
X_7907_ clknet_leaf_78_clk net225 net190 VGND VGND VPWR VPWR u_register_bank.status_flags\[27\]
+ sky130_fd_sc_hd__dfrtp_1
XFILLER_0_78_597 VGND VGND VPWR VPWR sky130_fd_sc_hd__fill_1
X_8887_ clknet_leaf_76_clk _0976_ VGND VGND VPWR VPWR u_input_buffer.fifo_mem\[8\]\[13\]
+ sky130_fd_sc_hd__dfxtp_1
XFILLER_0_19_620 VPWR VGND VPWR VGND sky130_ef_sc_hd__decap_12
XFILLER_0_19_642 VGND VGND VPWR VPWR sky130_fd_sc_hd__decap_3
X_7838_ _3918_ VGND VGND VPWR VPWR _1297_ sky130_fd_sc_hd__clkbuf_1
X_7769_ _3879_ net135 _3852_ VGND VGND VPWR VPWR _3880_ sky130_fd_sc_hd__mux2_1
XFILLER_0_80_206 VGND VGND VPWR VPWR sky130_fd_sc_hd__fill_1
XFILLER_0_18_141 VGND VGND VPWR VPWR sky130_fd_sc_hd__fill_1
XFILLER_0_34_634 VGND VGND VPWR VPWR sky130_fd_sc_hd__decap_8
XFILLER_0_61_431 VGND VGND VPWR VPWR sky130_fd_sc_hd__fill_1
XFILLER_0_33_122 VGND VGND VPWR VPWR sky130_fd_sc_hd__decap_4
XFILLER_0_104_555 VGND VGND VPWR VPWR sky130_fd_sc_hd__decap_6
XFILLER_0_33_188 VGND VGND VPWR VPWR sky130_fd_sc_hd__fill_2
XFILLER_0_88_339 VGND VGND VPWR VPWR sky130_fd_sc_hd__fill_2
XFILLER_0_96_350 VGND VGND VPWR VPWR sky130_fd_sc_hd__fill_2
XFILLER_0_84_512 VGND VGND VPWR VPWR sky130_fd_sc_hd__fill_2
XTAP_1240 VGND VPWR sky130_fd_sc_hd__tapvpwrvgnd_1
XTAP_1273 VGND VPWR sky130_fd_sc_hd__tapvpwrvgnd_1
XTAP_1284 VGND VPWR sky130_fd_sc_hd__tapvpwrvgnd_1
XTAP_1262 VGND VPWR sky130_fd_sc_hd__tapvpwrvgnd_1
XTAP_1251 VGND VPWR sky130_fd_sc_hd__tapvpwrvgnd_1
XTAP_1295 VGND VPWR sky130_fd_sc_hd__tapvpwrvgnd_1
XFILLER_0_84_589 VGND VGND VPWR VPWR sky130_fd_sc_hd__decap_8
XFILLER_0_25_623 VGND VGND VPWR VPWR sky130_fd_sc_hd__fill_1
XFILLER_0_4_517 VPWR VGND VPWR VGND sky130_ef_sc_hd__decap_12
XFILLER_0_24_122 VGND VGND VPWR VPWR sky130_fd_sc_hd__fill_1
XFILLER_0_25_656 VGND VGND VPWR VPWR sky130_fd_sc_hd__fill_2
Xhold719 u_input_buffer.fifo_mem\[58\]\[6\] VGND VGND VPWR VPWR net931 sky130_fd_sc_hd__dlygate4sd3_1
Xhold708 u_input_buffer.fifo_mem\[5\]\[7\] VGND VGND VPWR VPWR net920 sky130_fd_sc_hd__dlygate4sd3_1
XFILLER_0_52_475 VGND VGND VPWR VPWR sky130_fd_sc_hd__fill_1
X_5120_ _1385_ net1229 _2060_ VGND VGND VPWR VPWR _2062_ sky130_fd_sc_hd__mux2_1
X_5051_ _2025_ VGND VGND VPWR VPWR _0403_ sky130_fd_sc_hd__clkbuf_1
X_4002_ net773 net64 _1345_ VGND VGND VPWR VPWR _1352_ sky130_fd_sc_hd__mux2_1
X_8810_ clknet_leaf_25_clk _0899_ VGND VGND VPWR VPWR u_input_buffer.fifo_mem\[12\]\[0\]
+ sky130_fd_sc_hd__dfxtp_1
XFILLER_0_94_309 VGND VGND VPWR VPWR sky130_fd_sc_hd__decap_4
X_8741_ clknet_leaf_110_clk _0830_ VGND VGND VPWR VPWR u_input_buffer.fifo_mem\[17\]\[11\]
+ sky130_fd_sc_hd__dfxtp_1
XFILLER_0_87_350 VGND VGND VPWR VPWR sky130_fd_sc_hd__fill_1
X_5953_ _1438_ VGND VGND VPWR VPWR _2518_ sky130_fd_sc_hd__buf_4
X_4904_ net268 _1712_ _1934_ VGND VGND VPWR VPWR _1939_ sky130_fd_sc_hd__mux2_1
X_5884_ _2476_ VGND VGND VPWR VPWR _0785_ sky130_fd_sc_hd__clkbuf_1
X_8672_ clknet_leaf_7_clk _0761_ VGND VGND VPWR VPWR u_input_buffer.fifo_mem\[21\]\[6\]
+ sky130_fd_sc_hd__dfxtp_1
XFILLER_0_47_236 VGND VGND VPWR VPWR sky130_fd_sc_hd__decap_3
X_4835_ _1415_ net1316 _1893_ VGND VGND VPWR VPWR _1900_ sky130_fd_sc_hd__mux2_1
XFILLER_0_7_333 VGND VGND VPWR VPWR sky130_fd_sc_hd__decap_3
XFILLER_0_16_601 VPWR VGND VPWR VGND sky130_ef_sc_hd__decap_12
X_7623_ _3767_ VGND VGND VPWR VPWR _1233_ sky130_fd_sc_hd__clkbuf_1
X_4766_ _1862_ VGND VGND VPWR VPWR _0281_ sky130_fd_sc_hd__clkbuf_1
XFILLER_0_7_355 VGND VGND VPWR VPWR sky130_fd_sc_hd__fill_1
X_7554_ _3730_ VGND VGND VPWR VPWR _1201_ sky130_fd_sc_hd__clkbuf_1
X_6505_ net548 _1426_ _2807_ VGND VGND VPWR VPWR _2816_ sky130_fd_sc_hd__mux2_1
XFILLER_0_113_330 VGND VGND VPWR VPWR sky130_fd_sc_hd__decap_6
X_7485_ net567 _1456_ _3677_ VGND VGND VPWR VPWR _3692_ sky130_fd_sc_hd__mux2_1
XFILLER_0_31_615 VGND VGND VPWR VPWR sky130_fd_sc_hd__fill_1
X_4697_ _1421_ net950 _1817_ VGND VGND VPWR VPWR _1825_ sky130_fd_sc_hd__mux2_1
XFILLER_0_101_503 VGND VGND VPWR VPWR sky130_fd_sc_hd__fill_1
X_6436_ _2779_ VGND VGND VPWR VPWR _1034_ sky130_fd_sc_hd__clkbuf_1
X_9224_ net176 _1311_ net208 VGND VGND VPWR VPWR u_register_bank.sensor_enable\[25\]
+ sky130_fd_sc_hd__dfrtp_1
XFILLER_0_3_561 VPWR VGND VPWR VGND sky130_ef_sc_hd__decap_12
X_9155_ net181 _1243_ VGND VGND VPWR VPWR net141 sky130_fd_sc_hd__dfxtp_1
X_6367_ net897 _2512_ _2735_ VGND VGND VPWR VPWR _2743_ sky130_fd_sc_hd__mux2_1
X_8106_ clknet_leaf_52_clk _0195_ VGND VGND VPWR VPWR u_input_buffer.fifo_mem\[56\]\[0\]
+ sky130_fd_sc_hd__dfxtp_1
XFILLER_0_101_569 VGND VGND VPWR VPWR sky130_fd_sc_hd__fill_1
X_5318_ _2166_ VGND VGND VPWR VPWR _0529_ sky130_fd_sc_hd__clkbuf_1
X_9086_ net179 _1174_ net209 VGND VGND VPWR VPWR u_register_bank.window_cfg\[0\] sky130_fd_sc_hd__dfrtp_1
X_6298_ net477 _2512_ _2698_ VGND VGND VPWR VPWR _2706_ sky130_fd_sc_hd__mux2_1
Xhold13 u_sample_counter.sample_count\[27\] VGND VGND VPWR VPWR net225 sky130_fd_sc_hd__dlygate4sd3_1
Xhold35 u_sample_counter.sample_count\[3\] VGND VGND VPWR VPWR net247 sky130_fd_sc_hd__dlygate4sd3_1
Xhold46 _1135_ VGND VGND VPWR VPWR net258 sky130_fd_sc_hd__dlygate4sd3_1
X_8037_ clknet_leaf_107_clk _0126_ VGND VGND VPWR VPWR u_input_buffer.fifo_mem\[61\]\[11\]
+ sky130_fd_sc_hd__dfxtp_1
X_5249_ net1141 _2018_ _2114_ VGND VGND VPWR VPWR _2130_ sky130_fd_sc_hd__mux2_1
Xhold24 u_sample_counter.sample_count\[10\] VGND VGND VPWR VPWR net236 sky130_fd_sc_hd__dlygate4sd3_1
Xhold57 u_sensor_interface.sensor_array\[3\]\[0\] VGND VGND VPWR VPWR net269 sky130_fd_sc_hd__dlygate4sd3_1
Xhold68 u_input_buffer.fifo_mem\[0\]\[15\] VGND VGND VPWR VPWR net280 sky130_fd_sc_hd__dlygate4sd3_1
Xhold79 u_input_buffer.fifo_mem\[56\]\[11\] VGND VGND VPWR VPWR net291 sky130_fd_sc_hd__dlygate4sd3_1
X_8939_ clknet_leaf_38_clk _1028_ VGND VGND VPWR VPWR u_input_buffer.fifo_mem\[4\]\[1\]
+ sky130_fd_sc_hd__dfxtp_1
XFILLER_0_109_614 VGND VGND VPWR VPWR sky130_fd_sc_hd__fill_2
XFILLER_0_66_545 VGND VGND VPWR VPWR sky130_fd_sc_hd__fill_1
XFILLER_0_109_647 VGND VGND VPWR VPWR sky130_fd_sc_hd__decap_8
XFILLER_0_104_374 VGND VGND VPWR VPWR sky130_fd_sc_hd__fill_2
XFILLER_0_104_363 VGND VGND VPWR VPWR sky130_fd_sc_hd__fill_1
XFILLER_0_104_385 VGND VGND VPWR VPWR sky130_fd_sc_hd__fill_1
XFILLER_0_21_169 VGND VGND VPWR VPWR sky130_fd_sc_hd__fill_1
XTAP_309 VGND VPWR sky130_fd_sc_hd__tapvpwrvgnd_1
XFILLER_0_107_69 VGND VGND VPWR VPWR sky130_fd_sc_hd__decap_3
XFILLER_0_97_670 VGND VGND VPWR VPWR sky130_fd_sc_hd__fill_2
XFILLER_0_76_309 VGND VGND VPWR VPWR sky130_fd_sc_hd__fill_2
XFILLER_0_9_609 VGND VGND VPWR VPWR sky130_fd_sc_hd__decap_6
XFILLER_0_8_108 VGND VGND VPWR VPWR sky130_fd_sc_hd__fill_1
XFILLER_0_29_225 VGND VGND VPWR VPWR sky130_fd_sc_hd__fill_1
XFILLER_0_32_11 VGND VGND VPWR VPWR sky130_fd_sc_hd__fill_1
XTAP_1092 VGND VPWR sky130_fd_sc_hd__tapvpwrvgnd_1
XTAP_1081 VGND VPWR sky130_fd_sc_hd__tapvpwrvgnd_1
XTAP_1070 VGND VPWR sky130_fd_sc_hd__tapvpwrvgnd_1
XFILLER_0_57_567 VGND VGND VPWR VPWR sky130_fd_sc_hd__decap_3
X_4620_ net988 _1712_ _1778_ VGND VGND VPWR VPWR _1783_ sky130_fd_sc_hd__mux2_1
XFILLER_0_44_206 VGND VGND VPWR VPWR sky130_fd_sc_hd__decap_4
XFILLER_0_115_639 VGND VGND VPWR VPWR sky130_fd_sc_hd__decap_4
XFILLER_0_115_617 VPWR VGND VPWR VGND sky130_ef_sc_hd__decap_12
XFILLER_0_113_3 VPWR VGND VPWR VGND sky130_ef_sc_hd__decap_12
X_4551_ _1744_ VGND VGND VPWR VPWR _0184_ sky130_fd_sc_hd__clkbuf_1
XFILLER_0_52_250 VGND VGND VPWR VPWR sky130_fd_sc_hd__fill_2
Xhold527 u_input_buffer.fifo_mem\[54\]\[5\] VGND VGND VPWR VPWR net739 sky130_fd_sc_hd__dlygate4sd3_1
Xhold516 u_input_buffer.fifo_mem\[20\]\[8\] VGND VGND VPWR VPWR net728 sky130_fd_sc_hd__dlygate4sd3_1
X_4482_ _1698_ VGND VGND VPWR VPWR _0161_ sky130_fd_sc_hd__clkbuf_1
XFILLER_0_13_637 VPWR VGND VPWR VGND sky130_ef_sc_hd__decap_12
X_7270_ u_input_buffer.fifo_mem\[37\]\[12\] _2922_ _2925_ u_input_buffer.fifo_mem\[9\]\[12\]
+ VGND VGND VPWR VPWR _3510_ sky130_fd_sc_hd__a22o_1
Xhold505 u_input_buffer.fifo_mem\[2\]\[13\] VGND VGND VPWR VPWR net717 sky130_fd_sc_hd__dlygate4sd3_1
X_6221_ _2665_ VGND VGND VPWR VPWR _0933_ sky130_fd_sc_hd__clkbuf_1
Xhold549 u_input_buffer.fifo_mem\[30\]\[5\] VGND VGND VPWR VPWR net761 sky130_fd_sc_hd__dlygate4sd3_1
Xhold538 u_input_buffer.fifo_mem\[23\]\[1\] VGND VGND VPWR VPWR net750 sky130_fd_sc_hd__dlygate4sd3_1
XFILLER_0_0_531 VGND VGND VPWR VPWR sky130_fd_sc_hd__fill_1
X_6152_ _2628_ VGND VGND VPWR VPWR _0901_ sky130_fd_sc_hd__clkbuf_1
XFILLER_0_21_670 VGND VGND VPWR VPWR sky130_fd_sc_hd__fill_2
XFILLER_0_21_681 VGND VGND VPWR VPWR sky130_fd_sc_hd__decap_4
XTAP_810 VGND VPWR sky130_fd_sc_hd__tapvpwrvgnd_1
X_5103_ _2052_ VGND VGND VPWR VPWR _0428_ sky130_fd_sc_hd__clkbuf_1
XTAP_821 VGND VPWR sky130_fd_sc_hd__tapvpwrvgnd_1
XTAP_832 VGND VPWR sky130_fd_sc_hd__tapvpwrvgnd_1
XTAP_843 VGND VPWR sky130_fd_sc_hd__tapvpwrvgnd_1
X_6083_ net349 _2504_ _2587_ VGND VGND VPWR VPWR _2591_ sky130_fd_sc_hd__mux2_1
XTAP_854 VGND VPWR sky130_fd_sc_hd__tapvpwrvgnd_1
XTAP_865 VGND VPWR sky130_fd_sc_hd__tapvpwrvgnd_1
XTAP_876 VGND VPWR sky130_fd_sc_hd__tapvpwrvgnd_1
X_5034_ _2013_ VGND VGND VPWR VPWR _0398_ sky130_fd_sc_hd__clkbuf_1
XTAP_887 VGND VPWR sky130_fd_sc_hd__tapvpwrvgnd_1
XTAP_898 VGND VPWR sky130_fd_sc_hd__tapvpwrvgnd_1
XFILLER_0_18_3 VPWR VGND VPWR VGND sky130_ef_sc_hd__decap_12
X_6985_ u_input_buffer.fifo_mem\[15\]\[4\] _3060_ _3062_ u_input_buffer.fifo_mem\[43\]\[4\]
+ VGND VGND VPWR VPWR _3233_ sky130_fd_sc_hd__a22o_1
XFILLER_0_95_629 VGND VGND VPWR VPWR sky130_fd_sc_hd__fill_2
XFILLER_0_94_117 VGND VGND VPWR VPWR sky130_fd_sc_hd__fill_1
XFILLER_0_79_169 VGND VGND VPWR VPWR sky130_fd_sc_hd__fill_2
X_5936_ net853 _2506_ _2498_ VGND VGND VPWR VPWR _2507_ sky130_fd_sc_hd__mux2_1
X_8724_ clknet_leaf_13_clk _0813_ VGND VGND VPWR VPWR u_input_buffer.fifo_mem\[18\]\[10\]
+ sky130_fd_sc_hd__dfxtp_1
X_8655_ clknet_leaf_53_clk _0744_ VGND VGND VPWR VPWR u_input_buffer.fifo_mem\[22\]\[5\]
+ sky130_fd_sc_hd__dfxtp_1
X_5867_ net810 _2256_ _2461_ VGND VGND VPWR VPWR _2468_ sky130_fd_sc_hd__mux2_1
XFILLER_0_75_375 VGND VGND VPWR VPWR sky130_fd_sc_hd__fill_1
XFILLER_0_63_537 VGND VGND VPWR VPWR sky130_fd_sc_hd__decap_6
X_7606_ _3758_ VGND VGND VPWR VPWR _1225_ sky130_fd_sc_hd__clkbuf_1
X_5798_ _2431_ VGND VGND VPWR VPWR _0744_ sky130_fd_sc_hd__clkbuf_1
XFILLER_0_90_356 VGND VGND VPWR VPWR sky130_fd_sc_hd__fill_1
XFILLER_0_90_334 VGND VGND VPWR VPWR sky130_fd_sc_hd__fill_1
X_8586_ clknet_leaf_44_clk _0675_ VGND VGND VPWR VPWR u_input_buffer.fifo_mem\[26\]\[0\]
+ sky130_fd_sc_hd__dfxtp_1
X_4818_ net304 _1734_ _1873_ VGND VGND VPWR VPWR _1890_ sky130_fd_sc_hd__mux2_1
XFILLER_0_16_464 VPWR VGND VPWR VGND sky130_ef_sc_hd__decap_12
X_7537_ _3721_ VGND VGND VPWR VPWR _1193_ sky130_fd_sc_hd__clkbuf_1
XFILLER_0_43_250 VGND VGND VPWR VPWR sky130_fd_sc_hd__decap_4
X_4749_ _1852_ VGND VGND VPWR VPWR _0274_ sky130_fd_sc_hd__clkbuf_1
X_7468_ _3683_ VGND VGND VPWR VPWR _1162_ sky130_fd_sc_hd__clkbuf_1
X_9207_ net179 _1294_ net210 VGND VGND VPWR VPWR u_register_bank.sensor_enable\[8\]
+ sky130_fd_sc_hd__dfrtp_1
X_6419_ _1834_ _2567_ VGND VGND VPWR VPWR _2770_ sky130_fd_sc_hd__nor2_4
XFILLER_0_113_193 VGND VGND VPWR VPWR sky130_fd_sc_hd__decap_4
X_7399_ u_input_buffer.fifo_mem\[50\]\[15\] _2994_ _2996_ u_input_buffer.fifo_mem\[4\]\[15\]
+ VGND VGND VPWR VPWR _3636_ sky130_fd_sc_hd__a22o_1
X_9138_ net176 _1226_ net208 VGND VGND VPWR VPWR u_register_bank.threshold_cfg\[20\]
+ sky130_fd_sc_hd__dfrtp_1
X_9069_ clknet_leaf_34_clk net256 net194 VGND VGND VPWR VPWR net146 sky130_fd_sc_hd__dfrtp_2
Xinput103 sensor_data_in[61] VGND VGND VPWR VPWR net103 sky130_fd_sc_hd__buf_1
XFILLER_0_58_309 VGND VGND VPWR VPWR sky130_fd_sc_hd__fill_1
XPHY_142 VGND VGND VPWR VPWR sky130_fd_sc_hd__decap_3
XPHY_131 VGND VGND VPWR VPWR sky130_fd_sc_hd__decap_3
XPHY_120 VGND VGND VPWR VPWR sky130_fd_sc_hd__decap_3
XPHY_175 VGND VGND VPWR VPWR sky130_fd_sc_hd__decap_3
XPHY_164 VGND VGND VPWR VPWR sky130_fd_sc_hd__decap_3
XPHY_153 VGND VGND VPWR VPWR sky130_fd_sc_hd__decap_3
XPHY_197 VGND VGND VPWR VPWR sky130_fd_sc_hd__decap_3
XPHY_186 VGND VGND VPWR VPWR sky130_fd_sc_hd__decap_3
XFILLER_0_78_29 VPWR VGND VPWR VGND sky130_ef_sc_hd__decap_12
XFILLER_0_34_272 VGND VGND VPWR VPWR sky130_fd_sc_hd__fill_1
XFILLER_0_111_119 VGND VGND VPWR VPWR sky130_fd_sc_hd__fill_1
XFILLER_0_1_328 VGND VGND VPWR VPWR sky130_fd_sc_hd__decap_8
XFILLER_0_94_17 VGND VGND VPWR VPWR sky130_fd_sc_hd__decap_8
XFILLER_0_27_55 VGND VGND VPWR VPWR sky130_fd_sc_hd__fill_1
X_3982_ _1341_ VGND VGND VPWR VPWR _0018_ sky130_fd_sc_hd__clkbuf_1
X_6770_ u_input_buffer.fifo_mem\[27\]\[0\] _3013_ _3015_ u_input_buffer.fifo_mem\[59\]\[0\]
+ _3021_ VGND VGND VPWR VPWR _3022_ sky130_fd_sc_hd__a221o_1
XPHY_0 VGND VGND VPWR VPWR sky130_fd_sc_hd__decap_3
XFILLER_0_91_109 VGND VGND VPWR VPWR sky130_fd_sc_hd__decap_3
XFILLER_0_85_673 VGND VGND VPWR VPWR sky130_fd_sc_hd__decap_6
X_5721_ _2390_ VGND VGND VPWR VPWR _0708_ sky130_fd_sc_hd__clkbuf_1
XFILLER_0_72_312 VGND VGND VPWR VPWR sky130_fd_sc_hd__fill_2
X_5652_ net602 _2246_ _2352_ VGND VGND VPWR VPWR _2354_ sky130_fd_sc_hd__mux2_1
X_8440_ clknet_leaf_13_clk _0529_ VGND VGND VPWR VPWR u_input_buffer.fifo_mem\[36\]\[14\]
+ sky130_fd_sc_hd__dfxtp_1
XFILLER_0_115_447 VGND VGND VPWR VPWR sky130_fd_sc_hd__fill_1
X_8371_ clknet_leaf_51_clk _0460_ VGND VGND VPWR VPWR u_input_buffer.fifo_mem\[40\]\[9\]
+ sky130_fd_sc_hd__dfxtp_1
X_5583_ net707 _2246_ _2315_ VGND VGND VPWR VPWR _2317_ sky130_fd_sc_hd__mux2_1
XFILLER_0_72_378 VGND VGND VPWR VPWR sky130_fd_sc_hd__fill_1
X_4603_ net415 _1732_ _1756_ VGND VGND VPWR VPWR _1772_ sky130_fd_sc_hd__mux2_1
Xhold302 u_input_buffer.fifo_mem\[34\]\[8\] VGND VGND VPWR VPWR net514 sky130_fd_sc_hd__dlygate4sd3_1
X_4534_ _1468_ VGND VGND VPWR VPWR _1734_ sky130_fd_sc_hd__clkbuf_4
X_7322_ u_input_buffer.fifo_mem\[51\]\[13\] _2989_ _2992_ u_input_buffer.fifo_mem\[11\]\[13\]
+ _3560_ VGND VGND VPWR VPWR _3561_ sky130_fd_sc_hd__a221o_1
Xhold313 u_input_buffer.fifo_mem\[10\]\[4\] VGND VGND VPWR VPWR net525 sky130_fd_sc_hd__dlygate4sd3_1
Xhold324 u_input_buffer.fifo_mem\[2\]\[0\] VGND VGND VPWR VPWR net536 sky130_fd_sc_hd__dlygate4sd3_1
Xhold335 u_input_buffer.fifo_mem\[62\]\[0\] VGND VGND VPWR VPWR net547 sky130_fd_sc_hd__dlygate4sd3_1
XFILLER_0_7_54 VGND VGND VPWR VPWR sky130_fd_sc_hd__fill_2
XFILLER_0_4_177 VGND VGND VPWR VPWR sky130_fd_sc_hd__fill_1
XFILLER_0_40_231 VGND VGND VPWR VPWR sky130_fd_sc_hd__fill_2
XFILLER_0_40_253 VGND VGND VPWR VPWR sky130_fd_sc_hd__fill_1
Xhold346 u_input_buffer.fifo_mem\[52\]\[0\] VGND VGND VPWR VPWR net558 sky130_fd_sc_hd__dlygate4sd3_1
XFILLER_0_111_653 VPWR VGND VPWR VGND sky130_ef_sc_hd__decap_12
XFILLER_0_110_141 VGND VGND VPWR VPWR sky130_fd_sc_hd__fill_1
Xhold357 u_input_buffer.fifo_mem\[23\]\[7\] VGND VGND VPWR VPWR net569 sky130_fd_sc_hd__dlygate4sd3_1
X_4465_ net1259 _1614_ _1683_ VGND VGND VPWR VPWR _1690_ sky130_fd_sc_hd__mux2_1
Xhold368 u_sensor_interface.sensor_array\[3\]\[12\] VGND VGND VPWR VPWR net580 sky130_fd_sc_hd__dlygate4sd3_1
X_7253_ u_input_buffer.fifo_mem\[52\]\[11\] _3038_ _3040_ u_input_buffer.fifo_mem\[56\]\[11\]
+ VGND VGND VPWR VPWR _3494_ sky130_fd_sc_hd__a22o_1
Xhold379 u_input_buffer.fifo_mem\[26\]\[4\] VGND VGND VPWR VPWR net591 sky130_fd_sc_hd__dlygate4sd3_1
X_7184_ u_input_buffer.fifo_mem\[54\]\[9\] _3078_ _3080_ u_input_buffer.fifo_mem\[46\]\[9\]
+ VGND VGND VPWR VPWR _3427_ sky130_fd_sc_hd__a22o_1
X_4396_ _1650_ VGND VGND VPWR VPWR _0123_ sky130_fd_sc_hd__clkbuf_1
X_6204_ net787 _2520_ _2643_ VGND VGND VPWR VPWR _2656_ sky130_fd_sc_hd__mux2_1
X_6135_ _1624_ net1222 _2606_ VGND VGND VPWR VPWR _2619_ sky130_fd_sc_hd__mux2_1
XTAP_640 VGND VPWR sky130_fd_sc_hd__tapvpwrvgnd_1
XTAP_651 VGND VPWR sky130_fd_sc_hd__tapvpwrvgnd_1
Xhold1024 u_input_buffer.fifo_mem\[45\]\[1\] VGND VGND VPWR VPWR net1236 sky130_fd_sc_hd__dlygate4sd3_1
Xhold1013 u_input_buffer.fifo_mem\[21\]\[11\] VGND VGND VPWR VPWR net1225 sky130_fd_sc_hd__dlygate4sd3_1
Xhold1002 u_input_buffer.fifo_mem\[29\]\[3\] VGND VGND VPWR VPWR net1214 sky130_fd_sc_hd__dlygate4sd3_1
XTAP_662 VGND VPWR sky130_fd_sc_hd__tapvpwrvgnd_1
XTAP_673 VGND VPWR sky130_fd_sc_hd__tapvpwrvgnd_1
XTAP_684 VGND VPWR sky130_fd_sc_hd__tapvpwrvgnd_1
XTAP_695 VGND VPWR sky130_fd_sc_hd__tapvpwrvgnd_1
X_6066_ _2581_ VGND VGND VPWR VPWR _0862_ sky130_fd_sc_hd__clkbuf_1
XFILLER_0_84_83 VGND VGND VPWR VPWR sky130_fd_sc_hd__fill_1
X_5017_ _1414_ VGND VGND VPWR VPWR _2002_ sky130_fd_sc_hd__buf_4
Xhold1046 u_input_buffer.fifo_mem\[9\]\[3\] VGND VGND VPWR VPWR net1258 sky130_fd_sc_hd__dlygate4sd3_1
Xhold1057 u_input_buffer.fifo_mem\[38\]\[8\] VGND VGND VPWR VPWR net1269 sky130_fd_sc_hd__dlygate4sd3_1
Xhold1035 u_input_buffer.fifo_mem\[1\]\[7\] VGND VGND VPWR VPWR net1247 sky130_fd_sc_hd__dlygate4sd3_1
XFILLER_0_84_94 VGND VGND VPWR VPWR sky130_fd_sc_hd__fill_1
Xhold1079 u_input_buffer.fifo_mem\[9\]\[11\] VGND VGND VPWR VPWR net1291 sky130_fd_sc_hd__dlygate4sd3_1
Xhold1068 u_input_buffer.fifo_mem\[17\]\[0\] VGND VGND VPWR VPWR net1280 sky130_fd_sc_hd__dlygate4sd3_1
XFILLER_0_95_404 VGND VGND VPWR VPWR sky130_fd_sc_hd__fill_1
XFILLER_0_67_106 VGND VGND VPWR VPWR sky130_fd_sc_hd__fill_1
X_6968_ u_input_buffer.fifo_mem\[2\]\[4\] _2984_ _2986_ u_input_buffer.fifo_mem\[32\]\[4\]
+ VGND VGND VPWR VPWR _3216_ sky130_fd_sc_hd__a22o_1
X_8707_ clknet_leaf_65_clk _0796_ VGND VGND VPWR VPWR u_input_buffer.fifo_mem\[19\]\[9\]
+ sky130_fd_sc_hd__dfxtp_1
XFILLER_0_91_610 VGND VGND VPWR VPWR sky130_fd_sc_hd__decap_6
X_6899_ u_input_buffer.fifo_mem\[27\]\[2\] _3013_ _3015_ u_input_buffer.fifo_mem\[59\]\[2\]
+ _3148_ VGND VGND VPWR VPWR _3149_ sky130_fd_sc_hd__a221o_1
X_5919_ net884 _2274_ _2478_ VGND VGND VPWR VPWR _2495_ sky130_fd_sc_hd__mux2_1
XFILLER_0_106_403 VGND VGND VPWR VPWR sky130_fd_sc_hd__fill_1
X_8638_ clknet_leaf_47_clk _0727_ VGND VGND VPWR VPWR u_input_buffer.fifo_mem\[23\]\[4\]
+ sky130_fd_sc_hd__dfxtp_1
XFILLER_0_63_356 VGND VGND VPWR VPWR sky130_fd_sc_hd__fill_1
XFILLER_0_8_472 VGND VGND VPWR VPWR sky130_fd_sc_hd__decap_4
XFILLER_0_91_676 VGND VGND VPWR VPWR sky130_fd_sc_hd__decap_8
X_8569_ clknet_leaf_92_clk _0658_ VGND VGND VPWR VPWR u_input_buffer.fifo_mem\[28\]\[15\]
+ sky130_fd_sc_hd__dfxtp_1
XFILLER_0_90_197 VGND VGND VPWR VPWR sky130_fd_sc_hd__fill_1
XFILLER_0_102_631 VPWR VGND VPWR VGND sky130_ef_sc_hd__decap_12
Xhold880 u_input_buffer.fifo_mem\[56\]\[6\] VGND VGND VPWR VPWR net1092 sky130_fd_sc_hd__dlygate4sd3_1
Xhold891 u_input_buffer.fifo_mem\[37\]\[2\] VGND VGND VPWR VPWR net1103 sky130_fd_sc_hd__dlygate4sd3_1
XFILLER_0_98_242 VGND VGND VPWR VPWR sky130_fd_sc_hd__fill_2
XFILLER_0_13_57 VGND VGND VPWR VPWR sky130_fd_sc_hd__decap_8
XFILLER_0_109_241 VGND VGND VPWR VPWR sky130_fd_sc_hd__decap_8
XFILLER_0_89_39 VPWR VGND VPWR VGND sky130_ef_sc_hd__decap_12
XFILLER_0_81_175 VGND VGND VPWR VPWR sky130_fd_sc_hd__fill_1
XFILLER_0_2_637 VGND VGND VPWR VPWR sky130_fd_sc_hd__decap_6
XFILLER_0_22_253 VGND VGND VPWR VPWR sky130_fd_sc_hd__decap_3
XFILLER_0_50_595 VGND VGND VPWR VPWR sky130_fd_sc_hd__fill_2
XFILLER_0_10_437 VGND VGND VPWR VPWR sky130_fd_sc_hd__decap_4
XFILLER_0_1_169 VGND VGND VPWR VPWR sky130_fd_sc_hd__decap_6
X_4250_ net165 _1529_ net219 VGND VGND VPWR VPWR _1532_ sky130_fd_sc_hd__a21oi_1
X_4181_ _1486_ VGND VGND VPWR VPWR _0072_ sky130_fd_sc_hd__clkbuf_1
XFILLER_0_38_43 VGND VGND VPWR VPWR sky130_fd_sc_hd__decap_4
X_7940_ clknet_leaf_87_clk _0030_ VGND VGND VPWR VPWR u_sensor_interface.sensor_array\[1\]\[12\]
+ sky130_fd_sc_hd__dfxtp_1
X_7871_ _3935_ VGND VGND VPWR VPWR _1313_ sky130_fd_sc_hd__clkbuf_1
XFILLER_0_89_275 VGND VGND VPWR VPWR sky130_fd_sc_hd__decap_4
X_6822_ u_input_buffer.fifo_mem\[26\]\[0\] _3066_ _3068_ u_input_buffer.fifo_mem\[62\]\[0\]
+ _3073_ VGND VGND VPWR VPWR _3074_ sky130_fd_sc_hd__a221o_1
XFILLER_0_77_459 VGND VGND VPWR VPWR sky130_fd_sc_hd__fill_1
X_3965_ _1332_ VGND VGND VPWR VPWR _0010_ sky130_fd_sc_hd__clkbuf_1
XFILLER_0_57_150 VGND VGND VPWR VPWR sky130_fd_sc_hd__fill_2
XFILLER_0_9_236 VGND VGND VPWR VPWR sky130_fd_sc_hd__decap_3
X_6753_ _2906_ _2953_ VGND VGND VPWR VPWR _3005_ sky130_fd_sc_hd__nor2_4
X_5704_ _1622_ net1102 _2369_ VGND VGND VPWR VPWR _2381_ sky130_fd_sc_hd__mux2_1
XFILLER_0_18_559 VGND VGND VPWR VPWR sky130_fd_sc_hd__fill_2
X_6684_ _2935_ VGND VGND VPWR VPWR _2936_ sky130_fd_sc_hd__clkbuf_4
X_5635_ _2344_ VGND VGND VPWR VPWR _0668_ sky130_fd_sc_hd__clkbuf_1
X_8423_ clknet_leaf_107_clk _0512_ VGND VGND VPWR VPWR u_input_buffer.fifo_mem\[37\]\[13\]
+ sky130_fd_sc_hd__dfxtp_1
XFILLER_0_33_518 VGND VGND VPWR VPWR sky130_fd_sc_hd__fill_1
XFILLER_0_72_197 VGND VGND VPWR VPWR sky130_fd_sc_hd__fill_2
XFILLER_0_60_326 VGND VGND VPWR VPWR sky130_fd_sc_hd__fill_2
X_8354_ clknet_leaf_19_clk _0443_ VGND VGND VPWR VPWR u_input_buffer.fifo_mem\[41\]\[8\]
+ sky130_fd_sc_hd__dfxtp_1
X_5566_ _2307_ VGND VGND VPWR VPWR _0636_ sky130_fd_sc_hd__clkbuf_1
Xhold110 u_input_buffer.fifo_mem\[47\]\[13\] VGND VGND VPWR VPWR net322 sky130_fd_sc_hd__dlygate4sd3_1
Xhold121 u_sensor_interface.sensor_array\[2\]\[0\] VGND VGND VPWR VPWR net333 sky130_fd_sc_hd__dlygate4sd3_1
X_8285_ clknet_leaf_21_clk _0374_ VGND VGND VPWR VPWR u_input_buffer.fifo_mem\[45\]\[3\]
+ sky130_fd_sc_hd__dfxtp_1
X_4517_ net1023 _1722_ _1704_ VGND VGND VPWR VPWR _1723_ sky130_fd_sc_hd__mux2_1
X_5497_ _1450_ VGND VGND VPWR VPWR _2268_ sky130_fd_sc_hd__clkbuf_4
Xhold132 u_input_buffer.fifo_mem\[16\]\[15\] VGND VGND VPWR VPWR net344 sky130_fd_sc_hd__dlygate4sd3_1
X_7305_ net562 _3085_ _3087_ VGND VGND VPWR VPWR _3545_ sky130_fd_sc_hd__o21a_1
Xhold143 u_input_buffer.fifo_mem\[43\]\[11\] VGND VGND VPWR VPWR net355 sky130_fd_sc_hd__dlygate4sd3_1
Xhold154 u_input_buffer.fifo_mem\[63\]\[6\] VGND VGND VPWR VPWR net366 sky130_fd_sc_hd__dlygate4sd3_1
Xhold165 u_input_buffer.fifo_mem\[12\]\[3\] VGND VGND VPWR VPWR net377 sky130_fd_sc_hd__dlygate4sd3_1
X_7236_ u_input_buffer.fifo_mem\[1\]\[11\] _2931_ _3474_ _3476_ VGND VGND VPWR VPWR
+ _3477_ sky130_fd_sc_hd__a211o_1
X_4448_ u_input_buffer.wr_ptr\[2\] _1597_ VGND VGND VPWR VPWR _1679_ sky130_fd_sc_hd__or2b_1
Xhold176 u_input_buffer.fifo_mem\[52\]\[10\] VGND VGND VPWR VPWR net388 sky130_fd_sc_hd__dlygate4sd3_1
XFILLER_0_111_483 VGND VGND VPWR VPWR sky130_fd_sc_hd__fill_2
Xhold198 u_input_buffer.fifo_mem\[50\]\[3\] VGND VGND VPWR VPWR net410 sky130_fd_sc_hd__dlygate4sd3_1
Xhold187 u_input_buffer.fifo_mem\[28\]\[9\] VGND VGND VPWR VPWR net399 sky130_fd_sc_hd__dlygate4sd3_1
X_7167_ _3403_ _3405_ _3407_ _3409_ VGND VGND VPWR VPWR _3410_ sky130_fd_sc_hd__or4_1
X_4379_ _1377_ net1262 _1641_ VGND VGND VPWR VPWR _1642_ sky130_fd_sc_hd__mux2_1
X_7098_ u_input_buffer.fifo_mem\[6\]\[7\] _3035_ _3037_ u_input_buffer.fifo_mem\[28\]\[7\]
+ _3342_ VGND VGND VPWR VPWR _3343_ sky130_fd_sc_hd__a221o_1
XTAP_470 VGND VPWR sky130_fd_sc_hd__tapvpwrvgnd_1
XTAP_492 VGND VPWR sky130_fd_sc_hd__tapvpwrvgnd_1
XTAP_481 VGND VPWR sky130_fd_sc_hd__tapvpwrvgnd_1
X_6118_ _2610_ VGND VGND VPWR VPWR _0885_ sky130_fd_sc_hd__clkbuf_1
X_6049_ net792 _2504_ _2569_ VGND VGND VPWR VPWR _2573_ sky130_fd_sc_hd__mux2_1
XTAP_1614 VGND VPWR sky130_fd_sc_hd__tapvpwrvgnd_1
XTAP_1603 VGND VPWR sky130_fd_sc_hd__tapvpwrvgnd_1
XTAP_1647 VGND VPWR sky130_fd_sc_hd__tapvpwrvgnd_1
XTAP_1636 VGND VPWR sky130_fd_sc_hd__tapvpwrvgnd_1
XTAP_1625 VGND VPWR sky130_fd_sc_hd__tapvpwrvgnd_1
XFILLER_0_49_651 VGND VGND VPWR VPWR sky130_fd_sc_hd__decap_3
XFILLER_0_64_632 VPWR VGND VPWR VGND sky130_ef_sc_hd__decap_12
XFILLER_0_102_450 VGND VGND VPWR VPWR sky130_fd_sc_hd__decap_4
XFILLER_0_91_18 VPWR VGND VPWR VGND sky130_ef_sc_hd__decap_12
XFILLER_0_99_595 VGND VGND VPWR VPWR sky130_fd_sc_hd__fill_1
XFILLER_0_27_345 VGND VGND VPWR VPWR sky130_fd_sc_hd__fill_2
XFILLER_0_40_11 VGND VGND VPWR VPWR sky130_fd_sc_hd__decap_3
XFILLER_0_55_665 VGND VGND VPWR VPWR sky130_fd_sc_hd__decap_6
XFILLER_0_42_337 VGND VGND VPWR VPWR sky130_fd_sc_hd__decap_4
XFILLER_0_54_197 VGND VGND VPWR VPWR sky130_fd_sc_hd__decap_6
XFILLER_0_70_657 VGND VGND VPWR VPWR sky130_fd_sc_hd__fill_1
X_5420_ _2220_ VGND VGND VPWR VPWR _0577_ sky130_fd_sc_hd__clkbuf_1
X_5351_ net301 _2018_ _2168_ VGND VGND VPWR VPWR _2184_ sky130_fd_sc_hd__mux2_1
X_4302_ _1567_ _1565_ VGND VGND VPWR VPWR _1582_ sky130_fd_sc_hd__or2_1
XFILLER_0_2_467 VGND VGND VPWR VPWR sky130_fd_sc_hd__decap_8
XFILLER_0_2_489 VPWR VGND VPWR VGND sky130_ef_sc_hd__decap_12
X_8070_ clknet_leaf_91_clk _0159_ VGND VGND VPWR VPWR u_input_buffer.fifo_mem\[59\]\[12\]
+ sky130_fd_sc_hd__dfxtp_1
X_5282_ _2147_ VGND VGND VPWR VPWR _0512_ sky130_fd_sc_hd__clkbuf_1
X_7021_ _3261_ _3263_ _3265_ _3267_ VGND VGND VPWR VPWR _3268_ sky130_fd_sc_hd__or4_1
X_4233_ u_sample_counter.sample_count\[24\] VGND VGND VPWR VPWR _1520_ sky130_fd_sc_hd__inv_2
X_4164_ _1474_ net243 net227 VGND VGND VPWR VPWR _1475_ sky130_fd_sc_hd__a21oi_1
X_8972_ clknet_leaf_26_clk _1061_ VGND VGND VPWR VPWR u_input_buffer.fifo_mem\[2\]\[2\]
+ sky130_fd_sc_hd__dfxtp_1
X_4095_ _1416_ u_sensor_interface.sensor_array\[2\]\[6\] _1379_ VGND VGND VPWR VPWR
+ _1417_ sky130_fd_sc_hd__mux2_1
X_7923_ clknet_leaf_23_clk _0013_ VGND VGND VPWR VPWR u_sensor_interface.sensor_array\[2\]\[11\]
+ sky130_fd_sc_hd__dfxtp_1
XFILLER_0_77_256 VPWR VGND VPWR VGND sky130_ef_sc_hd__decap_12
XFILLER_0_77_234 VGND VGND VPWR VPWR sky130_fd_sc_hd__decap_6
X_7854_ _3926_ VGND VGND VPWR VPWR _1305_ sky130_fd_sc_hd__clkbuf_1
X_7785_ net157 u_analytics_engine.data_in\[3\] _1474_ VGND VGND VPWR VPWR _3890_ sky130_fd_sc_hd__mux2_1
X_6805_ _2896_ _2978_ VGND VGND VPWR VPWR _3057_ sky130_fd_sc_hd__nor2_2
X_4997_ _1376_ VGND VGND VPWR VPWR _1988_ sky130_fd_sc_hd__buf_4
X_6736_ u_input_buffer.fifo_mem\[12\]\[0\] _2980_ _2982_ u_input_buffer.fifo_mem\[18\]\[0\]
+ _2987_ VGND VGND VPWR VPWR _2988_ sky130_fd_sc_hd__a221o_1
XFILLER_0_46_643 VGND VGND VPWR VPWR sky130_fd_sc_hd__fill_1
X_3948_ net333 net71 _1323_ VGND VGND VPWR VPWR _1324_ sky130_fd_sc_hd__mux2_1
XFILLER_0_46_665 VGND VGND VPWR VPWR sky130_fd_sc_hd__decap_4
X_6667_ _2918_ VGND VGND VPWR VPWR _2919_ sky130_fd_sc_hd__clkbuf_4
X_5618_ net1069 _2246_ _2334_ VGND VGND VPWR VPWR _2336_ sky130_fd_sc_hd__mux2_1
XFILLER_0_61_668 VGND VGND VPWR VPWR sky130_fd_sc_hd__decap_4
X_6598_ _1593_ VGND VGND VPWR VPWR _2866_ sky130_fd_sc_hd__inv_2
X_8406_ clknet_leaf_92_clk _0495_ VGND VGND VPWR VPWR u_input_buffer.fifo_mem\[38\]\[12\]
+ sky130_fd_sc_hd__dfxtp_1
X_8337_ clknet_leaf_32_clk _0426_ VGND VGND VPWR VPWR u_input_buffer.fifo_mem\[42\]\[7\]
+ sky130_fd_sc_hd__dfxtp_1
XFILLER_0_103_225 VGND VGND VPWR VPWR sky130_fd_sc_hd__decap_4
XFILLER_0_14_584 VGND VGND VPWR VPWR sky130_fd_sc_hd__decap_4
X_5549_ _1385_ net667 _2297_ VGND VGND VPWR VPWR _2299_ sky130_fd_sc_hd__mux2_1
X_8268_ clknet_leaf_34_clk _0357_ VGND VGND VPWR VPWR u_input_buffer.fifo_mem\[46\]\[2\]
+ sky130_fd_sc_hd__dfxtp_1
X_7219_ u_input_buffer.fifo_mem\[15\]\[10\] _3059_ _3061_ u_input_buffer.fifo_mem\[43\]\[10\]
+ VGND VGND VPWR VPWR _3461_ sky130_fd_sc_hd__a22o_1
X_8199_ clknet_leaf_9_clk _0288_ VGND VGND VPWR VPWR u_input_buffer.fifo_mem\[51\]\[13\]
+ sky130_fd_sc_hd__dfxtp_1
XTAP_1433 VGND VPWR sky130_fd_sc_hd__tapvpwrvgnd_1
XTAP_1422 VGND VPWR sky130_fd_sc_hd__tapvpwrvgnd_1
XTAP_1411 VGND VPWR sky130_fd_sc_hd__tapvpwrvgnd_1
XTAP_1400 VGND VPWR sky130_fd_sc_hd__tapvpwrvgnd_1
XFILLER_0_68_234 VGND VGND VPWR VPWR sky130_fd_sc_hd__fill_2
XTAP_1466 VGND VPWR sky130_fd_sc_hd__tapvpwrvgnd_1
XTAP_1455 VGND VPWR sky130_fd_sc_hd__tapvpwrvgnd_1
XTAP_1444 VGND VPWR sky130_fd_sc_hd__tapvpwrvgnd_1
XFILLER_0_96_587 VGND VGND VPWR VPWR sky130_fd_sc_hd__fill_1
XTAP_1499 VGND VPWR sky130_fd_sc_hd__tapvpwrvgnd_1
XTAP_1488 VGND VPWR sky130_fd_sc_hd__tapvpwrvgnd_1
XTAP_1477 VGND VPWR sky130_fd_sc_hd__tapvpwrvgnd_1
XFILLER_0_24_304 VGND VGND VPWR VPWR sky130_fd_sc_hd__decap_4
XFILLER_0_101_27 VPWR VGND VPWR VGND sky130_ef_sc_hd__decap_12
XFILLER_0_36_197 VGND VGND VPWR VPWR sky130_fd_sc_hd__fill_1
XFILLER_0_86_29 VPWR VGND VPWR VGND sky130_ef_sc_hd__decap_12
XFILLER_0_35_11 VGND VGND VPWR VPWR sky130_fd_sc_hd__fill_2
XFILLER_0_35_33 VGND VGND VPWR VPWR sky130_fd_sc_hd__decap_4
XFILLER_0_35_55 VGND VGND VPWR VPWR sky130_fd_sc_hd__fill_1
X_4920_ net1054 _1728_ _1933_ VGND VGND VPWR VPWR _1947_ sky130_fd_sc_hd__mux2_1
X_4851_ _1463_ net1160 _1892_ VGND VGND VPWR VPWR _1908_ sky130_fd_sc_hd__mux2_1
X_7570_ net34 u_analytics_engine.threshold\[2\] _3737_ VGND VGND VPWR VPWR _3740_
+ sky130_fd_sc_hd__mux2_1
X_4782_ _1870_ VGND VGND VPWR VPWR _0289_ sky130_fd_sc_hd__clkbuf_1
XFILLER_0_7_559 VGND VGND VPWR VPWR sky130_fd_sc_hd__fill_1
X_6521_ net166 _2605_ VGND VGND VPWR VPWR _2824_ sky130_fd_sc_hd__nand2_4
X_6452_ _2787_ VGND VGND VPWR VPWR _1042_ sky130_fd_sc_hd__clkbuf_1
XFILLER_0_113_534 VPWR VGND VPWR VGND sky130_ef_sc_hd__decap_12
X_9171_ net179 _1259_ VGND VGND VPWR VPWR net127 sky130_fd_sc_hd__dfxtp_1
X_5403_ _1415_ net1307 _2205_ VGND VGND VPWR VPWR _2212_ sky130_fd_sc_hd__mux2_1
X_8122_ clknet_leaf_35_clk _0211_ VGND VGND VPWR VPWR u_input_buffer.fifo_mem\[55\]\[0\]
+ sky130_fd_sc_hd__dfxtp_1
X_6383_ net605 _2528_ _2734_ VGND VGND VPWR VPWR _2751_ sky130_fd_sc_hd__mux2_1
X_5334_ _2175_ VGND VGND VPWR VPWR _0536_ sky130_fd_sc_hd__clkbuf_1
X_5265_ _1409_ net1163 _2133_ VGND VGND VPWR VPWR _2139_ sky130_fd_sc_hd__mux2_1
X_8053_ clknet_leaf_88_clk _0142_ VGND VGND VPWR VPWR u_input_buffer.fifo_mem\[60\]\[11\]
+ sky130_fd_sc_hd__dfxtp_1
X_7004_ u_input_buffer.fifo_mem\[36\]\[5\] _2951_ _2955_ u_input_buffer.fifo_mem\[35\]\[5\]
+ _3250_ VGND VGND VPWR VPWR _3251_ sky130_fd_sc_hd__a221o_1
X_5196_ _2102_ VGND VGND VPWR VPWR _0471_ sky130_fd_sc_hd__clkbuf_1
XFILLER_0_76_73 VGND VGND VPWR VPWR sky130_fd_sc_hd__decap_4
X_4216_ u_sample_counter.sample_count\[19\] _1507_ VGND VGND VPWR VPWR _1509_ sky130_fd_sc_hd__nand2_1
X_4147_ _1461_ VGND VGND VPWR VPWR _0063_ sky130_fd_sc_hd__clkbuf_1
X_8955_ clknet_leaf_40_clk _1044_ VGND VGND VPWR VPWR u_input_buffer.fifo_mem\[3\]\[1\]
+ sky130_fd_sc_hd__dfxtp_1
X_4078_ u_input_buffer.data_in\[4\] VGND VGND VPWR VPWR _1402_ sky130_fd_sc_hd__clkbuf_4
XFILLER_0_78_554 VGND VGND VPWR VPWR sky130_fd_sc_hd__decap_3
X_8886_ clknet_leaf_80_clk _0975_ VGND VGND VPWR VPWR u_input_buffer.fifo_mem\[8\]\[12\]
+ sky130_fd_sc_hd__dfxtp_1
X_7906_ clknet_leaf_78_clk net228 net190 VGND VGND VPWR VPWR u_register_bank.status_flags\[26\]
+ sky130_fd_sc_hd__dfrtp_1
XFILLER_0_93_502 VGND VGND VPWR VPWR sky130_fd_sc_hd__fill_2
X_7837_ net14 u_register_bank.sensor_enable\[11\] _3916_ VGND VGND VPWR VPWR _3918_
+ sky130_fd_sc_hd__mux2_1
XFILLER_0_38_418 VGND VGND VPWR VPWR sky130_fd_sc_hd__fill_2
XFILLER_0_19_632 VGND VGND VPWR VPWR sky130_fd_sc_hd__fill_1
X_7768_ u_register_bank.window_cfg\[29\] _3847_ _3848_ u_register_bank.threshold_cfg\[29\]
+ _3878_ VGND VGND VPWR VPWR _3879_ sky130_fd_sc_hd__a221o_1
XFILLER_0_73_281 VGND VGND VPWR VPWR sky130_fd_sc_hd__fill_2
X_7699_ u_register_bank.window_cfg\[13\] _3812_ _3813_ u_analytics_engine.threshold\[13\]
+ _3825_ VGND VGND VPWR VPWR _3826_ sky130_fd_sc_hd__a221o_1
X_6719_ _2970_ VGND VGND VPWR VPWR _2971_ sky130_fd_sc_hd__clkbuf_4
XFILLER_0_33_167 VGND VGND VPWR VPWR sky130_fd_sc_hd__fill_1
XFILLER_0_104_589 VGND VGND VPWR VPWR sky130_fd_sc_hd__fill_2
XFILLER_0_88_329 VGND VGND VPWR VPWR sky130_fd_sc_hd__fill_1
XFILLER_0_96_373 VGND VGND VPWR VPWR sky130_fd_sc_hd__fill_2
XTAP_1241 VGND VPWR sky130_fd_sc_hd__tapvpwrvgnd_1
XTAP_1230 VGND VPWR sky130_fd_sc_hd__tapvpwrvgnd_1
XFILLER_0_96_384 VGND VGND VPWR VPWR sky130_fd_sc_hd__decap_8
XTAP_1274 VGND VPWR sky130_fd_sc_hd__tapvpwrvgnd_1
XTAP_1263 VGND VPWR sky130_fd_sc_hd__tapvpwrvgnd_1
XTAP_1252 VGND VPWR sky130_fd_sc_hd__tapvpwrvgnd_1
XTAP_1296 VGND VPWR sky130_fd_sc_hd__tapvpwrvgnd_1
XTAP_1285 VGND VPWR sky130_fd_sc_hd__tapvpwrvgnd_1
XFILLER_0_37_495 VGND VGND VPWR VPWR sky130_fd_sc_hd__decap_8
XFILLER_0_114_309 VGND VGND VPWR VPWR sky130_fd_sc_hd__decap_6
XFILLER_0_107_361 VGND VGND VPWR VPWR sky130_fd_sc_hd__fill_1
XFILLER_0_4_529 VGND VGND VPWR VPWR sky130_fd_sc_hd__decap_3
Xhold709 u_input_buffer.fifo_mem\[53\]\[9\] VGND VGND VPWR VPWR net921 sky130_fd_sc_hd__dlygate4sd3_1
XFILLER_0_24_189 VGND VGND VPWR VPWR sky130_fd_sc_hd__decap_6
X_5050_ net1068 _1988_ _2024_ VGND VGND VPWR VPWR _2025_ sky130_fd_sc_hd__mux2_1
X_4001_ _1351_ VGND VGND VPWR VPWR _0027_ sky130_fd_sc_hd__clkbuf_1
XFILLER_0_79_318 VGND VGND VPWR VPWR sky130_fd_sc_hd__fill_2
X_5952_ _2517_ VGND VGND VPWR VPWR _0812_ sky130_fd_sc_hd__clkbuf_1
X_8740_ clknet_leaf_104_clk _0829_ VGND VGND VPWR VPWR u_input_buffer.fifo_mem\[17\]\[10\]
+ sky130_fd_sc_hd__dfxtp_1
XFILLER_0_75_502 VGND VGND VPWR VPWR sky130_fd_sc_hd__fill_2
X_4903_ _1938_ VGND VGND VPWR VPWR _0342_ sky130_fd_sc_hd__clkbuf_1
XFILLER_0_62_42 VGND VGND VPWR VPWR sky130_fd_sc_hd__fill_1
X_5883_ net519 _2272_ _2460_ VGND VGND VPWR VPWR _2476_ sky130_fd_sc_hd__mux2_1
X_8671_ clknet_leaf_5_clk _0760_ VGND VGND VPWR VPWR u_input_buffer.fifo_mem\[21\]\[5\]
+ sky130_fd_sc_hd__dfxtp_1
X_4834_ _1899_ VGND VGND VPWR VPWR _0312_ sky130_fd_sc_hd__clkbuf_1
X_7622_ net31 u_register_bank.threshold_cfg\[27\] _3759_ VGND VGND VPWR VPWR _3767_
+ sky130_fd_sc_hd__mux2_1
X_4765_ net646 _1716_ _1855_ VGND VGND VPWR VPWR _1862_ sky130_fd_sc_hd__mux2_1
XFILLER_0_16_613 VPWR VGND VPWR VGND sky130_ef_sc_hd__decap_12
X_7553_ net31 u_register_bank.window_cfg\[27\] _3722_ VGND VGND VPWR VPWR _3730_ sky130_fd_sc_hd__mux2_1
X_6504_ _2815_ VGND VGND VPWR VPWR _1066_ sky130_fd_sc_hd__clkbuf_1
X_9223_ net175 _1310_ net207 VGND VGND VPWR VPWR u_register_bank.sensor_enable\[24\]
+ sky130_fd_sc_hd__dfrtp_1
XFILLER_0_15_167 VGND VGND VPWR VPWR sky130_fd_sc_hd__fill_1
X_7484_ _3691_ VGND VGND VPWR VPWR _1170_ sky130_fd_sc_hd__clkbuf_1
X_4696_ _1824_ VGND VGND VPWR VPWR _0249_ sky130_fd_sc_hd__clkbuf_1
X_6435_ net745 _1420_ _2771_ VGND VGND VPWR VPWR _2779_ sky130_fd_sc_hd__mux2_1
XFILLER_0_3_573 VPWR VGND VPWR VGND sky130_ef_sc_hd__decap_12
X_9154_ net181 _1242_ VGND VGND VPWR VPWR net140 sky130_fd_sc_hd__dfxtp_1
X_6366_ _2742_ VGND VGND VPWR VPWR _1001_ sky130_fd_sc_hd__clkbuf_1
XFILLER_0_101_559 VGND VGND VPWR VPWR sky130_fd_sc_hd__fill_1
X_9085_ clknet_leaf_88_clk _1173_ VGND VGND VPWR VPWR u_input_buffer.fifo_mem\[63\]\[15\]
+ sky130_fd_sc_hd__dfxtp_1
X_8105_ clknet_leaf_104_clk _0194_ VGND VGND VPWR VPWR u_input_buffer.fifo_mem\[57\]\[15\]
+ sky130_fd_sc_hd__dfxtp_1
X_5317_ net666 _2018_ _2150_ VGND VGND VPWR VPWR _2166_ sky130_fd_sc_hd__mux2_1
X_6297_ _2705_ VGND VGND VPWR VPWR _0969_ sky130_fd_sc_hd__clkbuf_1
Xhold14 u_sample_counter.sample_count\[20\] VGND VGND VPWR VPWR net226 sky130_fd_sc_hd__dlygate4sd3_1
X_8036_ clknet_leaf_106_clk _0125_ VGND VGND VPWR VPWR u_input_buffer.fifo_mem\[61\]\[10\]
+ sky130_fd_sc_hd__dfxtp_1
Xhold25 u_sample_counter.sample_count\[28\] VGND VGND VPWR VPWR net237 sky130_fd_sc_hd__buf_1
Xhold47 u_sensor_interface.sensor_array\[0\]\[13\] VGND VGND VPWR VPWR net259 sky130_fd_sc_hd__dlygate4sd3_1
Xhold36 u_input_buffer.wr_ptr\[5\] VGND VGND VPWR VPWR net248 sky130_fd_sc_hd__dlygate4sd3_1
X_5248_ _2129_ VGND VGND VPWR VPWR _0496_ sky130_fd_sc_hd__clkbuf_1
Xhold58 u_input_buffer.fifo_mem\[32\]\[2\] VGND VGND VPWR VPWR net270 sky130_fd_sc_hd__dlygate4sd3_1
Xhold69 u_input_buffer.fifo_mem\[3\]\[2\] VGND VGND VPWR VPWR net281 sky130_fd_sc_hd__dlygate4sd3_1
X_5179_ _2092_ VGND VGND VPWR VPWR _0464_ sky130_fd_sc_hd__clkbuf_1
X_8938_ clknet_leaf_36_clk _1027_ VGND VGND VPWR VPWR u_input_buffer.fifo_mem\[4\]\[0\]
+ sky130_fd_sc_hd__dfxtp_1
XFILLER_0_78_340 VGND VGND VPWR VPWR sky130_fd_sc_hd__decap_6
X_8869_ clknet_leaf_0_clk _0958_ VGND VGND VPWR VPWR u_input_buffer.fifo_mem\[9\]\[11\]
+ sky130_fd_sc_hd__dfxtp_1
XFILLER_0_109_626 VGND VGND VPWR VPWR sky130_fd_sc_hd__decap_8
XFILLER_0_19_440 VGND VGND VPWR VPWR sky130_fd_sc_hd__decap_8
XFILLER_0_93_398 VGND VGND VPWR VPWR sky130_fd_sc_hd__fill_2
XFILLER_0_34_421 VGND VGND VPWR VPWR sky130_fd_sc_hd__fill_1
XFILLER_0_22_616 VGND VGND VPWR VPWR sky130_fd_sc_hd__decap_3
XFILLER_0_22_627 VGND VGND VPWR VPWR sky130_fd_sc_hd__decap_8
XFILLER_0_107_15 VPWR VGND VPWR VGND sky130_ef_sc_hd__decap_12
XFILLER_0_57_513 VGND VGND VPWR VPWR sky130_fd_sc_hd__fill_1
XTAP_1082 VGND VPWR sky130_fd_sc_hd__tapvpwrvgnd_1
XTAP_1071 VGND VPWR sky130_fd_sc_hd__tapvpwrvgnd_1
XTAP_1060 VGND VPWR sky130_fd_sc_hd__tapvpwrvgnd_1
XTAP_1093 VGND VPWR sky130_fd_sc_hd__tapvpwrvgnd_1
XFILLER_0_115_629 VGND VGND VPWR VPWR sky130_fd_sc_hd__decap_4
XFILLER_0_37_281 VGND VGND VPWR VPWR sky130_fd_sc_hd__fill_2
XFILLER_0_37_292 VGND VGND VPWR VPWR sky130_fd_sc_hd__fill_2
XFILLER_0_80_571 VGND VGND VPWR VPWR sky130_fd_sc_hd__fill_1
X_4550_ _1409_ net1085 _1738_ VGND VGND VPWR VPWR _1744_ sky130_fd_sc_hd__mux2_1
Xhold506 u_input_buffer.fifo_mem\[38\]\[5\] VGND VGND VPWR VPWR net718 sky130_fd_sc_hd__dlygate4sd3_1
Xhold517 u_input_buffer.fifo_mem\[44\]\[10\] VGND VGND VPWR VPWR net729 sky130_fd_sc_hd__dlygate4sd3_1
XFILLER_0_13_649 VPWR VGND VPWR VGND sky130_ef_sc_hd__decap_12
X_4481_ net1278 _1630_ _1682_ VGND VGND VPWR VPWR _1698_ sky130_fd_sc_hd__mux2_1
XFILLER_0_40_413 VGND VGND VPWR VPWR sky130_fd_sc_hd__fill_1
Xhold539 u_input_buffer.fifo_mem\[52\]\[4\] VGND VGND VPWR VPWR net751 sky130_fd_sc_hd__dlygate4sd3_1
X_6220_ net927 _2502_ _2662_ VGND VGND VPWR VPWR _2665_ sky130_fd_sc_hd__mux2_1
Xhold528 u_input_buffer.fifo_mem\[46\]\[3\] VGND VGND VPWR VPWR net740 sky130_fd_sc_hd__dlygate4sd3_1
X_6151_ net669 _2502_ _2625_ VGND VGND VPWR VPWR _2628_ sky130_fd_sc_hd__mux2_1
XFILLER_0_0_565 VGND VGND VPWR VPWR sky130_fd_sc_hd__fill_1
XTAP_800 VGND VPWR sky130_fd_sc_hd__tapvpwrvgnd_1
X_5102_ net873 _2008_ _2042_ VGND VGND VPWR VPWR _2052_ sky130_fd_sc_hd__mux2_1
XFILLER_0_57_53 VGND VGND VPWR VPWR sky130_fd_sc_hd__decap_3
XFILLER_0_0_576 VGND VGND VPWR VPWR sky130_fd_sc_hd__fill_2
XTAP_811 VGND VPWR sky130_fd_sc_hd__tapvpwrvgnd_1
XTAP_822 VGND VPWR sky130_fd_sc_hd__tapvpwrvgnd_1
XTAP_833 VGND VPWR sky130_fd_sc_hd__tapvpwrvgnd_1
XTAP_844 VGND VPWR sky130_fd_sc_hd__tapvpwrvgnd_1
X_6082_ _2590_ VGND VGND VPWR VPWR _0869_ sky130_fd_sc_hd__clkbuf_1
XTAP_855 VGND VPWR sky130_fd_sc_hd__tapvpwrvgnd_1
XTAP_866 VGND VPWR sky130_fd_sc_hd__tapvpwrvgnd_1
XTAP_877 VGND VPWR sky130_fd_sc_hd__tapvpwrvgnd_1
X_5033_ net1036 _2012_ _1989_ VGND VGND VPWR VPWR _2013_ sky130_fd_sc_hd__mux2_1
XTAP_888 VGND VPWR sky130_fd_sc_hd__tapvpwrvgnd_1
XTAP_899 VGND VPWR sky130_fd_sc_hd__tapvpwrvgnd_1
X_6984_ u_input_buffer.fifo_mem\[23\]\[4\] _3046_ _3048_ u_input_buffer.fifo_mem\[20\]\[4\]
+ _3231_ VGND VGND VPWR VPWR _3232_ sky130_fd_sc_hd__a221o_1
X_5935_ _1402_ VGND VGND VPWR VPWR _2506_ sky130_fd_sc_hd__buf_4
X_8723_ clknet_leaf_19_clk _0812_ VGND VGND VPWR VPWR u_input_buffer.fifo_mem\[18\]\[9\]
+ sky130_fd_sc_hd__dfxtp_1
X_5866_ _2467_ VGND VGND VPWR VPWR _0776_ sky130_fd_sc_hd__clkbuf_1
X_8654_ clknet_leaf_59_clk _0743_ VGND VGND VPWR VPWR u_input_buffer.fifo_mem\[22\]\[4\]
+ sky130_fd_sc_hd__dfxtp_1
Xclkbuf_leaf_60_clk clknet_3_6__leaf_clk VGND VGND VPWR VPWR clknet_leaf_60_clk sky130_fd_sc_hd__clkbuf_16
XFILLER_0_8_643 VGND VGND VPWR VPWR sky130_fd_sc_hd__fill_1
X_4817_ _1889_ VGND VGND VPWR VPWR _0305_ sky130_fd_sc_hd__clkbuf_1
X_7605_ net22 u_register_bank.threshold_cfg\[19\] _3748_ VGND VGND VPWR VPWR _3758_
+ sky130_fd_sc_hd__mux2_1
X_5797_ net716 _2254_ _2425_ VGND VGND VPWR VPWR _2431_ sky130_fd_sc_hd__mux2_1
XFILLER_0_7_175 VGND VGND VPWR VPWR sky130_fd_sc_hd__fill_1
X_8585_ clknet_leaf_85_clk _0674_ VGND VGND VPWR VPWR u_input_buffer.fifo_mem\[27\]\[15\]
+ sky130_fd_sc_hd__dfxtp_1
XFILLER_0_31_402 VGND VGND VPWR VPWR sky130_fd_sc_hd__fill_1
X_7536_ net22 u_register_bank.window_cfg\[19\] _3711_ VGND VGND VPWR VPWR _3721_ sky130_fd_sc_hd__mux2_1
X_4748_ net287 _1734_ _1835_ VGND VGND VPWR VPWR _1852_ sky130_fd_sc_hd__mux2_1
X_7467_ net276 _1402_ _3678_ VGND VGND VPWR VPWR _3683_ sky130_fd_sc_hd__mux2_1
X_4679_ _1814_ VGND VGND VPWR VPWR _0242_ sky130_fd_sc_hd__clkbuf_1
XFILLER_0_114_684 VGND VGND VPWR VPWR sky130_fd_sc_hd__fill_2
XFILLER_0_113_161 VGND VGND VPWR VPWR sky130_fd_sc_hd__decap_6
X_9206_ net182 _1293_ net211 VGND VGND VPWR VPWR u_register_bank.sensor_enable\[7\]
+ sky130_fd_sc_hd__dfrtp_1
X_6418_ _2769_ VGND VGND VPWR VPWR _1026_ sky130_fd_sc_hd__clkbuf_1
XFILLER_0_101_334 VGND VGND VPWR VPWR sky130_fd_sc_hd__fill_2
X_9137_ net173 _1225_ net203 VGND VGND VPWR VPWR u_register_bank.threshold_cfg\[19\]
+ sky130_fd_sc_hd__dfrtp_1
X_7398_ u_input_buffer.fifo_mem\[12\]\[15\] _2979_ _2981_ u_input_buffer.fifo_mem\[18\]\[15\]
+ _3634_ VGND VGND VPWR VPWR _3635_ sky130_fd_sc_hd__a221o_1
XFILLER_0_101_389 VGND VGND VPWR VPWR sky130_fd_sc_hd__decap_3
X_6349_ net671 _2528_ _2716_ VGND VGND VPWR VPWR _2733_ sky130_fd_sc_hd__mux2_1
Xinput104 sensor_data_in[62] VGND VGND VPWR VPWR net104 sky130_fd_sc_hd__buf_2
X_9068_ clknet_leaf_103_clk _1157_ VGND VGND VPWR VPWR u_sensor_interface.sensor_array\[3\]\[15\]
+ sky130_fd_sc_hd__dfxtp_1
X_8019_ clknet_leaf_70_clk _0108_ VGND VGND VPWR VPWR u_input_buffer.fifo_mem\[62\]\[9\]
+ sky130_fd_sc_hd__dfxtp_1
XFILLER_0_79_671 VGND VGND VPWR VPWR sky130_fd_sc_hd__fill_1
XPHY_143 VGND VGND VPWR VPWR sky130_fd_sc_hd__decap_3
XPHY_132 VGND VGND VPWR VPWR sky130_fd_sc_hd__decap_3
XPHY_121 VGND VGND VPWR VPWR sky130_fd_sc_hd__decap_3
XPHY_110 VGND VGND VPWR VPWR sky130_fd_sc_hd__decap_3
Xclkbuf_leaf_51_clk clknet_3_7__leaf_clk VGND VGND VPWR VPWR clknet_leaf_51_clk sky130_fd_sc_hd__clkbuf_16
XPHY_176 VGND VGND VPWR VPWR sky130_fd_sc_hd__decap_3
XPHY_165 VGND VGND VPWR VPWR sky130_fd_sc_hd__decap_3
XPHY_154 VGND VGND VPWR VPWR sky130_fd_sc_hd__decap_3
XFILLER_0_66_365 VGND VGND VPWR VPWR sky130_fd_sc_hd__fill_2
XPHY_198 VGND VGND VPWR VPWR sky130_fd_sc_hd__decap_3
XPHY_187 VGND VGND VPWR VPWR sky130_fd_sc_hd__decap_3
XFILLER_0_62_582 VGND VGND VPWR VPWR sky130_fd_sc_hd__fill_1
XFILLER_0_94_29 VPWR VGND VPWR VGND sky130_ef_sc_hd__decap_12
XFILLER_0_76_107 VGND VGND VPWR VPWR sky130_fd_sc_hd__fill_2
X_3981_ net332 net53 _1334_ VGND VGND VPWR VPWR _1341_ sky130_fd_sc_hd__mux2_1
XPHY_1 VGND VGND VPWR VPWR sky130_fd_sc_hd__decap_3
X_5720_ net318 _2246_ _2388_ VGND VGND VPWR VPWR _2390_ sky130_fd_sc_hd__mux2_1
XFILLER_0_43_99 VGND VGND VPWR VPWR sky130_fd_sc_hd__fill_2
Xclkbuf_leaf_42_clk clknet_3_6__leaf_clk VGND VGND VPWR VPWR clknet_leaf_42_clk sky130_fd_sc_hd__clkbuf_16
X_5651_ _2353_ VGND VGND VPWR VPWR _0675_ sky130_fd_sc_hd__clkbuf_1
X_8370_ clknet_leaf_50_clk _0459_ VGND VGND VPWR VPWR u_input_buffer.fifo_mem\[40\]\[8\]
+ sky130_fd_sc_hd__dfxtp_1
X_5582_ _2316_ VGND VGND VPWR VPWR _0643_ sky130_fd_sc_hd__clkbuf_1
XFILLER_0_72_357 VGND VGND VPWR VPWR sky130_fd_sc_hd__decap_4
X_4602_ _1771_ VGND VGND VPWR VPWR _0208_ sky130_fd_sc_hd__clkbuf_1
X_4533_ _1733_ VGND VGND VPWR VPWR _0177_ sky130_fd_sc_hd__clkbuf_1
X_7321_ u_input_buffer.fifo_mem\[50\]\[13\] _2994_ _2996_ u_input_buffer.fifo_mem\[4\]\[13\]
+ VGND VGND VPWR VPWR _3560_ sky130_fd_sc_hd__a22o_1
Xhold314 u_input_buffer.fifo_mem\[34\]\[7\] VGND VGND VPWR VPWR net526 sky130_fd_sc_hd__dlygate4sd3_1
Xhold303 u_input_buffer.fifo_mem\[47\]\[3\] VGND VGND VPWR VPWR net515 sky130_fd_sc_hd__dlygate4sd3_1
Xhold325 u_input_buffer.fifo_mem\[51\]\[9\] VGND VGND VPWR VPWR net537 sky130_fd_sc_hd__dlygate4sd3_1
X_7252_ u_input_buffer.fifo_mem\[7\]\[11\] _3024_ _3026_ u_input_buffer.fifo_mem\[22\]\[11\]
+ _3492_ VGND VGND VPWR VPWR _3493_ sky130_fd_sc_hd__a221o_1
Xhold358 u_input_buffer.fifo_mem\[7\]\[6\] VGND VGND VPWR VPWR net570 sky130_fd_sc_hd__dlygate4sd3_1
X_4464_ _1689_ VGND VGND VPWR VPWR _0152_ sky130_fd_sc_hd__clkbuf_1
Xhold336 u_input_buffer.fifo_mem\[2\]\[8\] VGND VGND VPWR VPWR net548 sky130_fd_sc_hd__dlygate4sd3_1
Xhold369 u_input_buffer.fifo_mem\[8\]\[9\] VGND VGND VPWR VPWR net581 sky130_fd_sc_hd__dlygate4sd3_1
X_6203_ _2655_ VGND VGND VPWR VPWR _0925_ sky130_fd_sc_hd__clkbuf_1
Xhold347 u_input_buffer.fifo_mem\[26\]\[11\] VGND VGND VPWR VPWR net559 sky130_fd_sc_hd__dlygate4sd3_1
XFILLER_0_111_665 VGND VGND VPWR VPWR sky130_fd_sc_hd__decap_6
X_7183_ u_input_buffer.fifo_mem\[26\]\[9\] _3066_ _3068_ u_input_buffer.fifo_mem\[62\]\[9\]
+ _3425_ VGND VGND VPWR VPWR _3426_ sky130_fd_sc_hd__a221o_1
XFILLER_0_40_298 VGND VGND VPWR VPWR sky130_fd_sc_hd__fill_1
X_4395_ _1427_ net840 _1641_ VGND VGND VPWR VPWR _1650_ sky130_fd_sc_hd__mux2_1
XFILLER_0_110_197 VGND VGND VPWR VPWR sky130_fd_sc_hd__fill_2
X_6134_ _2618_ VGND VGND VPWR VPWR _0893_ sky130_fd_sc_hd__clkbuf_1
XTAP_630 VGND VPWR sky130_fd_sc_hd__tapvpwrvgnd_1
XTAP_652 VGND VPWR sky130_fd_sc_hd__tapvpwrvgnd_1
XTAP_641 VGND VPWR sky130_fd_sc_hd__tapvpwrvgnd_1
Xhold1003 u_input_buffer.fifo_mem\[36\]\[5\] VGND VGND VPWR VPWR net1215 sky130_fd_sc_hd__dlygate4sd3_1
Xhold1014 u_input_buffer.fifo_mem\[41\]\[5\] VGND VGND VPWR VPWR net1226 sky130_fd_sc_hd__dlygate4sd3_1
XTAP_663 VGND VPWR sky130_fd_sc_hd__tapvpwrvgnd_1
XTAP_674 VGND VPWR sky130_fd_sc_hd__tapvpwrvgnd_1
XTAP_685 VGND VPWR sky130_fd_sc_hd__tapvpwrvgnd_1
X_6065_ net911 _2520_ _2568_ VGND VGND VPWR VPWR _2581_ sky130_fd_sc_hd__mux2_1
X_5016_ _2001_ VGND VGND VPWR VPWR _0392_ sky130_fd_sc_hd__clkbuf_1
Xhold1047 u_input_buffer.fifo_mem\[59\]\[6\] VGND VGND VPWR VPWR net1259 sky130_fd_sc_hd__dlygate4sd3_1
Xhold1058 u_input_buffer.fifo_mem\[57\]\[10\] VGND VGND VPWR VPWR net1270 sky130_fd_sc_hd__dlygate4sd3_1
XFILLER_0_30_3 VGND VGND VPWR VPWR sky130_fd_sc_hd__fill_1
Xhold1036 u_input_buffer.fifo_mem\[53\]\[5\] VGND VGND VPWR VPWR net1248 sky130_fd_sc_hd__dlygate4sd3_1
XTAP_696 VGND VPWR sky130_fd_sc_hd__tapvpwrvgnd_1
Xhold1025 u_input_buffer.fifo_mem\[34\]\[13\] VGND VGND VPWR VPWR net1237 sky130_fd_sc_hd__dlygate4sd3_1
Xhold1069 u_input_buffer.fifo_mem\[17\]\[8\] VGND VGND VPWR VPWR net1281 sky130_fd_sc_hd__dlygate4sd3_1
X_6967_ u_input_buffer.fifo_mem\[34\]\[4\] _2966_ _2969_ u_input_buffer.fifo_mem\[48\]\[4\]
+ _3214_ VGND VGND VPWR VPWR _3215_ sky130_fd_sc_hd__a221o_1
XFILLER_0_76_641 VGND VGND VPWR VPWR sky130_fd_sc_hd__decap_3
XFILLER_0_76_630 VGND VGND VPWR VPWR sky130_fd_sc_hd__fill_2
X_5918_ _2494_ VGND VGND VPWR VPWR _0801_ sky130_fd_sc_hd__clkbuf_1
X_8706_ clknet_leaf_77_clk _0795_ VGND VGND VPWR VPWR u_input_buffer.fifo_mem\[19\]\[8\]
+ sky130_fd_sc_hd__dfxtp_1
Xclkbuf_leaf_33_clk clknet_3_5__leaf_clk VGND VGND VPWR VPWR clknet_leaf_33_clk sky130_fd_sc_hd__clkbuf_16
X_6898_ u_input_buffer.fifo_mem\[31\]\[2\] _3017_ _3020_ u_input_buffer.fifo_mem\[38\]\[2\]
+ VGND VGND VPWR VPWR _3148_ sky130_fd_sc_hd__a22o_1
X_8637_ clknet_leaf_46_clk _0726_ VGND VGND VPWR VPWR u_input_buffer.fifo_mem\[23\]\[3\]
+ sky130_fd_sc_hd__dfxtp_1
X_5849_ _1630_ net973 _2442_ VGND VGND VPWR VPWR _2458_ sky130_fd_sc_hd__mux2_1
XFILLER_0_36_549 VGND VGND VPWR VPWR sky130_fd_sc_hd__fill_2
XFILLER_0_63_379 VGND VGND VPWR VPWR sky130_fd_sc_hd__decap_4
X_8568_ clknet_leaf_75_clk _0657_ VGND VGND VPWR VPWR u_input_buffer.fifo_mem\[28\]\[14\]
+ sky130_fd_sc_hd__dfxtp_1
X_7519_ _3712_ VGND VGND VPWR VPWR _1184_ sky130_fd_sc_hd__clkbuf_1
XFILLER_0_44_593 VPWR VGND VPWR VGND sky130_ef_sc_hd__decap_12
X_8499_ clknet_leaf_18_clk _0588_ VGND VGND VPWR VPWR u_input_buffer.fifo_mem\[32\]\[9\]
+ sky130_fd_sc_hd__dfxtp_1
XFILLER_0_102_643 VGND VGND VPWR VPWR sky130_fd_sc_hd__fill_1
XFILLER_0_31_276 VGND VGND VPWR VPWR sky130_fd_sc_hd__decap_4
XFILLER_0_102_665 VPWR VGND VPWR VGND sky130_ef_sc_hd__decap_12
Xhold881 u_input_buffer.fifo_mem\[60\]\[2\] VGND VGND VPWR VPWR net1093 sky130_fd_sc_hd__dlygate4sd3_1
Xhold870 u_input_buffer.fifo_mem\[21\]\[15\] VGND VGND VPWR VPWR net1082 sky130_fd_sc_hd__dlygate4sd3_1
Xhold892 u_input_buffer.fifo_mem\[1\]\[8\] VGND VGND VPWR VPWR net1104 sky130_fd_sc_hd__dlygate4sd3_1
XFILLER_0_86_438 VGND VGND VPWR VPWR sky130_fd_sc_hd__fill_1
XFILLER_0_104_27 VGND VGND VPWR VPWR sky130_fd_sc_hd__fill_1
XFILLER_0_82_600 VGND VGND VPWR VPWR sky130_fd_sc_hd__fill_1
Xclkbuf_leaf_24_clk clknet_3_4__leaf_clk VGND VGND VPWR VPWR clknet_leaf_24_clk sky130_fd_sc_hd__clkbuf_16
XFILLER_0_66_184 VGND VGND VPWR VPWR sky130_fd_sc_hd__decap_3
XFILLER_0_109_297 VGND VGND VPWR VPWR sky130_fd_sc_hd__decap_3
XFILLER_0_54_368 VPWR VGND VPWR VGND sky130_ef_sc_hd__decap_12
XFILLER_0_1_104 VGND VGND VPWR VPWR sky130_fd_sc_hd__decap_4
X_4180_ _1484_ _1485_ VGND VGND VPWR VPWR _1486_ sky130_fd_sc_hd__and2_1
XFILLER_0_38_33 VGND VGND VPWR VPWR sky130_fd_sc_hd__fill_1
X_7870_ net31 u_register_bank.sensor_enable\[27\] _3927_ VGND VGND VPWR VPWR _3935_
+ sky130_fd_sc_hd__mux2_1
X_6821_ u_input_buffer.fifo_mem\[3\]\[0\] _3070_ _3072_ u_input_buffer.fifo_mem\[60\]\[0\]
+ VGND VGND VPWR VPWR _3073_ sky130_fd_sc_hd__a22o_1
XFILLER_0_77_449 VGND VGND VPWR VPWR sky130_fd_sc_hd__fill_1
X_3964_ u_sensor_interface.sensor_array\[2\]\[8\] net80 _1323_ VGND VGND VPWR VPWR
+ _1332_ sky130_fd_sc_hd__mux2_1
XFILLER_0_85_460 VGND VGND VPWR VPWR sky130_fd_sc_hd__decap_4
Xclkbuf_leaf_15_clk clknet_3_4__leaf_clk VGND VGND VPWR VPWR clknet_leaf_15_clk sky130_fd_sc_hd__clkbuf_16
XFILLER_0_57_140 VGND VGND VPWR VPWR sky130_fd_sc_hd__fill_1
X_6752_ _3003_ VGND VGND VPWR VPWR _3004_ sky130_fd_sc_hd__clkbuf_4
X_6683_ _2885_ _2882_ _2911_ VGND VGND VPWR VPWR _2935_ sky130_fd_sc_hd__and3_4
XFILLER_0_45_335 VGND VGND VPWR VPWR sky130_fd_sc_hd__fill_1
X_5703_ _2380_ VGND VGND VPWR VPWR _0700_ sky130_fd_sc_hd__clkbuf_1
XFILLER_0_115_223 VGND VGND VPWR VPWR sky130_fd_sc_hd__fill_1
XFILLER_0_70_97 VGND VGND VPWR VPWR sky130_fd_sc_hd__decap_3
X_5634_ net965 _2262_ _2334_ VGND VGND VPWR VPWR _2344_ sky130_fd_sc_hd__mux2_1
X_8422_ clknet_leaf_106_clk _0511_ VGND VGND VPWR VPWR u_input_buffer.fifo_mem\[37\]\[12\]
+ sky130_fd_sc_hd__dfxtp_1
X_8353_ clknet_leaf_19_clk _0442_ VGND VGND VPWR VPWR u_input_buffer.fifo_mem\[41\]\[7\]
+ sky130_fd_sc_hd__dfxtp_1
XFILLER_0_115_278 VGND VGND VPWR VPWR sky130_fd_sc_hd__fill_2
Xhold100 u_input_buffer.fifo_mem\[19\]\[0\] VGND VGND VPWR VPWR net312 sky130_fd_sc_hd__dlygate4sd3_1
XFILLER_0_78_3 VGND VGND VPWR VPWR sky130_fd_sc_hd__decap_8
X_7304_ _3525_ _3534_ _3543_ VGND VGND VPWR VPWR _3544_ sky130_fd_sc_hd__or3_1
X_5565_ _1433_ net1275 _2297_ VGND VGND VPWR VPWR _2307_ sky130_fd_sc_hd__mux2_1
Xhold133 u_input_buffer.fifo_mem\[58\]\[0\] VGND VGND VPWR VPWR net345 sky130_fd_sc_hd__dlygate4sd3_1
Xhold122 u_input_buffer.fifo_mem\[55\]\[0\] VGND VGND VPWR VPWR net334 sky130_fd_sc_hd__dlygate4sd3_1
Xhold111 u_input_buffer.fifo_mem\[38\]\[6\] VGND VGND VPWR VPWR net323 sky130_fd_sc_hd__dlygate4sd3_1
X_8284_ clknet_leaf_22_clk _0373_ VGND VGND VPWR VPWR u_input_buffer.fifo_mem\[45\]\[2\]
+ sky130_fd_sc_hd__dfxtp_1
X_4516_ _1432_ VGND VGND VPWR VPWR _1722_ sky130_fd_sc_hd__clkbuf_4
X_5496_ _2267_ VGND VGND VPWR VPWR _0606_ sky130_fd_sc_hd__clkbuf_1
Xhold144 u_input_buffer.fifo_mem\[40\]\[15\] VGND VGND VPWR VPWR net356 sky130_fd_sc_hd__dlygate4sd3_1
Xhold177 u_input_buffer.fifo_mem\[36\]\[9\] VGND VGND VPWR VPWR net389 sky130_fd_sc_hd__dlygate4sd3_1
Xhold166 u_input_buffer.fifo_mem\[47\]\[5\] VGND VGND VPWR VPWR net378 sky130_fd_sc_hd__dlygate4sd3_1
X_7235_ u_input_buffer.fifo_mem\[29\]\[11\] _2938_ _2940_ u_input_buffer.fifo_mem\[13\]\[11\]
+ _3475_ VGND VGND VPWR VPWR _3476_ sky130_fd_sc_hd__a221o_1
XFILLER_0_1_671 VGND VGND VPWR VPWR sky130_fd_sc_hd__fill_1
X_4447_ u_input_buffer.wr_ptr\[1\] _1637_ VGND VGND VPWR VPWR _1678_ sky130_fd_sc_hd__nand2_1
Xhold155 u_input_buffer.fifo_mem\[52\]\[14\] VGND VGND VPWR VPWR net367 sky130_fd_sc_hd__dlygate4sd3_1
Xhold188 u_input_buffer.fifo_mem\[24\]\[5\] VGND VGND VPWR VPWR net400 sky130_fd_sc_hd__dlygate4sd3_1
X_7166_ u_input_buffer.fifo_mem\[51\]\[9\] _2990_ _2993_ u_input_buffer.fifo_mem\[11\]\[9\]
+ _3408_ VGND VGND VPWR VPWR _3409_ sky130_fd_sc_hd__a221o_1
Xhold199 u_sensor_interface.sensor_array\[2\]\[14\] VGND VGND VPWR VPWR net411 sky130_fd_sc_hd__dlygate4sd3_1
XTAP_460 VGND VPWR sky130_fd_sc_hd__tapvpwrvgnd_1
X_6117_ _1606_ net1142 _2607_ VGND VGND VPWR VPWR _2610_ sky130_fd_sc_hd__mux2_1
X_4378_ _1640_ VGND VGND VPWR VPWR _1641_ sky130_fd_sc_hd__buf_4
X_7097_ u_input_buffer.fifo_mem\[52\]\[7\] _3039_ _3041_ u_input_buffer.fifo_mem\[56\]\[7\]
+ VGND VGND VPWR VPWR _3342_ sky130_fd_sc_hd__a22o_1
XTAP_471 VGND VPWR sky130_fd_sc_hd__tapvpwrvgnd_1
XTAP_493 VGND VPWR sky130_fd_sc_hd__tapvpwrvgnd_1
XTAP_482 VGND VPWR sky130_fd_sc_hd__tapvpwrvgnd_1
X_6048_ _2572_ VGND VGND VPWR VPWR _0853_ sky130_fd_sc_hd__clkbuf_1
XTAP_1615 VGND VPWR sky130_fd_sc_hd__tapvpwrvgnd_1
XTAP_1604 VGND VPWR sky130_fd_sc_hd__tapvpwrvgnd_1
XFILLER_0_68_416 VGND VGND VPWR VPWR sky130_fd_sc_hd__decap_4
XTAP_1637 VGND VPWR sky130_fd_sc_hd__tapvpwrvgnd_1
XTAP_1626 VGND VPWR sky130_fd_sc_hd__tapvpwrvgnd_1
X_7999_ clknet_leaf_62_clk _0088_ net195 VGND VGND VPWR VPWR u_sample_counter.sample_count\[22\]
+ sky130_fd_sc_hd__dfrtp_1
XFILLER_0_49_630 VGND VGND VPWR VPWR sky130_fd_sc_hd__fill_1
XFILLER_0_95_279 VGND VGND VPWR VPWR sky130_fd_sc_hd__fill_1
XFILLER_0_76_493 VGND VGND VPWR VPWR sky130_fd_sc_hd__fill_2
XFILLER_0_8_270 VGND VGND VPWR VPWR sky130_fd_sc_hd__fill_2
XFILLER_0_102_495 VGND VGND VPWR VPWR sky130_fd_sc_hd__fill_1
XFILLER_0_102_473 VGND VGND VPWR VPWR sky130_fd_sc_hd__decap_3
XFILLER_0_2_413 VGND VGND VPWR VPWR sky130_fd_sc_hd__decap_6
XFILLER_0_35_390 VGND VGND VPWR VPWR sky130_fd_sc_hd__fill_2
XFILLER_0_112_248 VGND VGND VPWR VPWR sky130_fd_sc_hd__decap_4
X_5350_ _2183_ VGND VGND VPWR VPWR _0544_ sky130_fd_sc_hd__clkbuf_1
X_4301_ _1572_ _1573_ _1575_ _1580_ VGND VGND VPWR VPWR _1581_ sky130_fd_sc_hd__o2bb2a_1
X_5281_ _1457_ net985 _2132_ VGND VGND VPWR VPWR _2147_ sky130_fd_sc_hd__mux2_1
X_7020_ u_input_buffer.fifo_mem\[6\]\[5\] _3035_ _3037_ u_input_buffer.fifo_mem\[28\]\[5\]
+ _3266_ VGND VGND VPWR VPWR _3267_ sky130_fd_sc_hd__a221o_1
X_4232_ net238 _1519_ VGND VGND VPWR VPWR _0090_ sky130_fd_sc_hd__xnor2_1
Xclkbuf_leaf_4_clk clknet_3_1__leaf_clk VGND VGND VPWR VPWR clknet_leaf_4_clk sky130_fd_sc_hd__clkbuf_16
X_4163_ _1474_ net243 VGND VGND VPWR VPWR _0066_ sky130_fd_sc_hd__xor2_1
X_8971_ clknet_leaf_25_clk _1060_ VGND VGND VPWR VPWR u_input_buffer.fifo_mem\[2\]\[1\]
+ sky130_fd_sc_hd__dfxtp_1
X_4094_ u_sensor_interface.sensor_array\[0\]\[6\] u_sensor_interface.sensor_array\[1\]\[6\]
+ _1318_ VGND VGND VPWR VPWR _1416_ sky130_fd_sc_hd__mux2_1
X_7922_ clknet_leaf_32_clk _0012_ VGND VGND VPWR VPWR u_sensor_interface.sensor_array\[2\]\[10\]
+ sky130_fd_sc_hd__dfxtp_2
XFILLER_0_81_30 VGND VGND VPWR VPWR sky130_fd_sc_hd__decap_4
X_7853_ net22 u_register_bank.sensor_enable\[19\] _3916_ VGND VGND VPWR VPWR _3926_
+ sky130_fd_sc_hd__mux2_1
XFILLER_0_92_205 VGND VGND VPWR VPWR sky130_fd_sc_hd__fill_2
XFILLER_0_77_268 VGND VGND VPWR VPWR sky130_fd_sc_hd__fill_2
X_6804_ _3055_ VGND VGND VPWR VPWR _3056_ sky130_fd_sc_hd__clkbuf_4
X_7784_ _3889_ VGND VGND VPWR VPWR _1272_ sky130_fd_sc_hd__clkbuf_1
X_4996_ _1987_ VGND VGND VPWR VPWR _0386_ sky130_fd_sc_hd__clkbuf_1
X_6735_ u_input_buffer.fifo_mem\[2\]\[0\] _2984_ _2986_ u_input_buffer.fifo_mem\[32\]\[0\]
+ VGND VGND VPWR VPWR _2987_ sky130_fd_sc_hd__a22o_1
X_3947_ _1322_ VGND VGND VPWR VPWR _1323_ sky130_fd_sc_hd__buf_8
XFILLER_0_45_110 VGND VGND VPWR VPWR sky130_fd_sc_hd__fill_2
XFILLER_0_45_143 VGND VGND VPWR VPWR sky130_fd_sc_hd__decap_4
XFILLER_0_61_614 VGND VGND VPWR VPWR sky130_fd_sc_hd__fill_2
X_6666_ _2917_ _2911_ VGND VGND VPWR VPWR _2918_ sky130_fd_sc_hd__and2_2
X_5617_ _2335_ VGND VGND VPWR VPWR _0659_ sky130_fd_sc_hd__clkbuf_1
X_6597_ net1293 _2862_ _2865_ VGND VGND VPWR VPWR _1109_ sky130_fd_sc_hd__o21a_1
XFILLER_0_5_251 VGND VGND VPWR VPWR sky130_fd_sc_hd__fill_1
X_8405_ clknet_leaf_92_clk _0494_ VGND VGND VPWR VPWR u_input_buffer.fifo_mem\[38\]\[11\]
+ sky130_fd_sc_hd__dfxtp_1
X_8336_ clknet_leaf_31_clk _0425_ VGND VGND VPWR VPWR u_input_buffer.fifo_mem\[42\]\[6\]
+ sky130_fd_sc_hd__dfxtp_1
X_5548_ _2298_ VGND VGND VPWR VPWR _0627_ sky130_fd_sc_hd__clkbuf_1
XFILLER_0_41_360 VGND VGND VPWR VPWR sky130_fd_sc_hd__fill_2
X_8267_ clknet_leaf_36_clk _0356_ VGND VGND VPWR VPWR u_input_buffer.fifo_mem\[46\]\[1\]
+ sky130_fd_sc_hd__dfxtp_1
XFILLER_0_41_393 VGND VGND VPWR VPWR sky130_fd_sc_hd__fill_1
XFILLER_0_111_281 VGND VGND VPWR VPWR sky130_fd_sc_hd__fill_2
X_5479_ _1414_ VGND VGND VPWR VPWR _2256_ sky130_fd_sc_hd__clkbuf_4
X_7218_ u_input_buffer.fifo_mem\[23\]\[10\] _3045_ _3047_ u_input_buffer.fifo_mem\[20\]\[10\]
+ _3459_ VGND VGND VPWR VPWR _3460_ sky130_fd_sc_hd__a221o_1
X_8198_ clknet_leaf_98_clk _0287_ VGND VGND VPWR VPWR u_input_buffer.fifo_mem\[51\]\[12\]
+ sky130_fd_sc_hd__dfxtp_1
X_7149_ net250 _3086_ _3088_ VGND VGND VPWR VPWR _3393_ sky130_fd_sc_hd__o21a_1
XTAP_290 VGND VPWR sky130_fd_sc_hd__tapvpwrvgnd_1
XTAP_1423 VGND VPWR sky130_fd_sc_hd__tapvpwrvgnd_1
XTAP_1412 VGND VPWR sky130_fd_sc_hd__tapvpwrvgnd_1
XTAP_1401 VGND VPWR sky130_fd_sc_hd__tapvpwrvgnd_1
XTAP_1456 VGND VPWR sky130_fd_sc_hd__tapvpwrvgnd_1
XTAP_1434 VGND VPWR sky130_fd_sc_hd__tapvpwrvgnd_1
XTAP_1445 VGND VPWR sky130_fd_sc_hd__tapvpwrvgnd_1
XTAP_1489 VGND VPWR sky130_fd_sc_hd__tapvpwrvgnd_1
XTAP_1478 VGND VPWR sky130_fd_sc_hd__tapvpwrvgnd_1
XTAP_1467 VGND VPWR sky130_fd_sc_hd__tapvpwrvgnd_1
XFILLER_0_36_110 VGND VGND VPWR VPWR sky130_fd_sc_hd__fill_2
XFILLER_0_76_290 VPWR VGND VPWR VGND sky130_ef_sc_hd__decap_12
XFILLER_0_107_587 VGND VGND VPWR VPWR sky130_fd_sc_hd__decap_3
XFILLER_0_101_39 VPWR VGND VPWR VGND sky130_ef_sc_hd__decap_12
XFILLER_0_10_15 VPWR VGND VPWR VGND sky130_ef_sc_hd__decap_12
XFILLER_0_10_59 VGND VGND VPWR VPWR sky130_fd_sc_hd__fill_1
XFILLER_0_20_533 VGND VGND VPWR VPWR sky130_fd_sc_hd__decap_6
XFILLER_0_102_281 VGND VGND VPWR VPWR sky130_fd_sc_hd__decap_8
XFILLER_0_19_57 VGND VGND VPWR VPWR sky130_fd_sc_hd__decap_6
Xclkbuf_3_7__f_clk clknet_0_clk VGND VGND VPWR VPWR clknet_3_7__leaf_clk sky130_fd_sc_hd__clkbuf_16
XFILLER_0_59_279 VGND VGND VPWR VPWR sky130_fd_sc_hd__fill_1
XFILLER_0_28_600 VGND VGND VPWR VPWR sky130_fd_sc_hd__fill_2
X_4850_ _1907_ VGND VGND VPWR VPWR _0320_ sky130_fd_sc_hd__clkbuf_1
XFILLER_0_7_505 VPWR VGND VPWR VGND sky130_ef_sc_hd__decap_12
X_4781_ net734 _1732_ _1854_ VGND VGND VPWR VPWR _1870_ sky130_fd_sc_hd__mux2_1
X_6520_ _2823_ VGND VGND VPWR VPWR _1074_ sky130_fd_sc_hd__clkbuf_1
XFILLER_0_51_55 VGND VGND VPWR VPWR sky130_fd_sc_hd__fill_1
XFILLER_0_15_316 VGND VGND VPWR VPWR sky130_fd_sc_hd__fill_2
XFILLER_0_113_513 VGND VGND VPWR VPWR sky130_fd_sc_hd__fill_2
X_6451_ net772 _1468_ _2770_ VGND VGND VPWR VPWR _2787_ sky130_fd_sc_hd__mux2_1
XFILLER_0_113_546 VPWR VGND VPWR VGND sky130_ef_sc_hd__decap_12
X_9170_ net181 _1258_ VGND VGND VPWR VPWR net126 sky130_fd_sc_hd__dfxtp_1
X_5402_ _2211_ VGND VGND VPWR VPWR _0568_ sky130_fd_sc_hd__clkbuf_1
X_6382_ _2750_ VGND VGND VPWR VPWR _1009_ sky130_fd_sc_hd__clkbuf_1
XFILLER_0_42_179 VGND VGND VPWR VPWR sky130_fd_sc_hd__fill_2
X_5333_ net642 _2000_ _2169_ VGND VGND VPWR VPWR _2175_ sky130_fd_sc_hd__mux2_1
XFILLER_0_23_393 VGND VGND VPWR VPWR sky130_fd_sc_hd__decap_3
X_8121_ clknet_leaf_74_clk _0210_ VGND VGND VPWR VPWR u_input_buffer.fifo_mem\[56\]\[15\]
+ sky130_fd_sc_hd__dfxtp_1
XFILLER_0_100_218 VGND VGND VPWR VPWR sky130_fd_sc_hd__decap_3
X_5264_ _2138_ VGND VGND VPWR VPWR _0503_ sky130_fd_sc_hd__clkbuf_1
X_8052_ clknet_leaf_88_clk _0141_ VGND VGND VPWR VPWR u_input_buffer.fifo_mem\[60\]\[10\]
+ sky130_fd_sc_hd__dfxtp_1
X_7003_ u_input_buffer.fifo_mem\[14\]\[5\] _2958_ _2961_ u_input_buffer.fifo_mem\[42\]\[5\]
+ VGND VGND VPWR VPWR _3250_ sky130_fd_sc_hd__a22o_1
X_5195_ net852 _1998_ _2097_ VGND VGND VPWR VPWR _2102_ sky130_fd_sc_hd__mux2_1
X_4215_ _1507_ _1508_ VGND VGND VPWR VPWR _0084_ sky130_fd_sc_hd__nor2_1
X_4146_ _1457_ _1460_ _1320_ VGND VGND VPWR VPWR _1461_ sky130_fd_sc_hd__mux2_1
XFILLER_0_97_319 VGND VGND VPWR VPWR sky130_fd_sc_hd__fill_1
X_8954_ clknet_leaf_40_clk _1043_ VGND VGND VPWR VPWR u_input_buffer.fifo_mem\[3\]\[0\]
+ sky130_fd_sc_hd__dfxtp_1
X_4077_ _1401_ VGND VGND VPWR VPWR _0053_ sky130_fd_sc_hd__clkbuf_1
XFILLER_0_92_73 VGND VGND VPWR VPWR sky130_fd_sc_hd__decap_3
X_7905_ clknet_leaf_62_clk net213 net195 VGND VGND VPWR VPWR u_register_bank.status_flags\[25\]
+ sky130_fd_sc_hd__dfrtp_1
X_8885_ clknet_leaf_75_clk _0974_ VGND VGND VPWR VPWR u_input_buffer.fifo_mem\[8\]\[11\]
+ sky130_fd_sc_hd__dfxtp_1
X_7836_ _3917_ VGND VGND VPWR VPWR _1296_ sky130_fd_sc_hd__clkbuf_1
XFILLER_0_65_216 VGND VGND VPWR VPWR sky130_fd_sc_hd__decap_3
XFILLER_0_93_569 VGND VGND VPWR VPWR sky130_fd_sc_hd__decap_3
X_7767_ u_register_bank.status_flags\[29\] _3849_ _3777_ u_register_bank.sensor_enable\[29\]
+ VGND VGND VPWR VPWR _3878_ sky130_fd_sc_hd__a22o_1
X_4979_ _1421_ net1120 _1971_ VGND VGND VPWR VPWR _1979_ sky130_fd_sc_hd__mux2_1
XFILLER_0_18_165 VGND VGND VPWR VPWR sky130_fd_sc_hd__fill_2
XFILLER_0_19_677 VGND VGND VPWR VPWR sky130_fd_sc_hd__fill_1
X_7698_ u_register_bank.status_flags\[13\] _3814_ _3808_ u_register_bank.sensor_enable\[13\]
+ VGND VGND VPWR VPWR _3825_ sky130_fd_sc_hd__a22o_1
XFILLER_0_34_614 VGND VGND VPWR VPWR sky130_fd_sc_hd__decap_3
X_6718_ _2905_ _2967_ VGND VGND VPWR VPWR _2970_ sky130_fd_sc_hd__nor2_2
X_6649_ _2877_ u_input_buffer.rd_ptr\[2\] VGND VGND VPWR VPWR _2901_ sky130_fd_sc_hd__nand2_1
XFILLER_0_46_496 VGND VGND VPWR VPWR sky130_fd_sc_hd__fill_2
X_8319_ clknet_leaf_33_clk _0408_ VGND VGND VPWR VPWR u_input_buffer.fifo_mem\[43\]\[5\]
+ sky130_fd_sc_hd__dfxtp_1
XTAP_1231 VGND VPWR sky130_fd_sc_hd__tapvpwrvgnd_1
XTAP_1220 VGND VPWR sky130_fd_sc_hd__tapvpwrvgnd_1
XTAP_1275 VGND VPWR sky130_fd_sc_hd__tapvpwrvgnd_1
XTAP_1264 VGND VPWR sky130_fd_sc_hd__tapvpwrvgnd_1
XTAP_1253 VGND VPWR sky130_fd_sc_hd__tapvpwrvgnd_1
XTAP_1242 VGND VPWR sky130_fd_sc_hd__tapvpwrvgnd_1
XTAP_1297 VGND VPWR sky130_fd_sc_hd__tapvpwrvgnd_1
XTAP_1286 VGND VPWR sky130_fd_sc_hd__tapvpwrvgnd_1
XFILLER_0_37_441 VGND VGND VPWR VPWR sky130_fd_sc_hd__decap_6
XFILLER_0_112_27 VGND VGND VPWR VPWR sky130_fd_sc_hd__fill_1
XFILLER_0_21_36 VGND VGND VPWR VPWR sky130_fd_sc_hd__fill_2
XFILLER_0_37_463 VGND VGND VPWR VPWR sky130_fd_sc_hd__fill_2
XFILLER_0_107_340 VGND VGND VPWR VPWR sky130_fd_sc_hd__decap_4
XFILLER_0_52_477 VGND VGND VPWR VPWR sky130_fd_sc_hd__decap_3
XFILLER_0_20_385 VGND VGND VPWR VPWR sky130_fd_sc_hd__fill_1
X_4000_ u_sensor_interface.sensor_array\[1\]\[9\] net63 _1345_ VGND VGND VPWR VPWR
+ _1351_ sky130_fd_sc_hd__mux2_1
X_5951_ net677 _2516_ _2498_ VGND VGND VPWR VPWR _2517_ sky130_fd_sc_hd__mux2_1
X_4902_ net515 _1710_ _1934_ VGND VGND VPWR VPWR _1938_ sky130_fd_sc_hd__mux2_1
XFILLER_0_1_57 VPWR VGND VPWR VGND sky130_ef_sc_hd__decap_12
X_8670_ clknet_leaf_4_clk _0759_ VGND VGND VPWR VPWR u_input_buffer.fifo_mem\[21\]\[4\]
+ sky130_fd_sc_hd__dfxtp_1
X_5882_ _2475_ VGND VGND VPWR VPWR _0784_ sky130_fd_sc_hd__clkbuf_1
X_4833_ _1409_ net1311 _1893_ VGND VGND VPWR VPWR _1899_ sky130_fd_sc_hd__mux2_1
XFILLER_0_75_558 VGND VGND VPWR VPWR sky130_fd_sc_hd__fill_2
X_7621_ _3766_ VGND VGND VPWR VPWR _1232_ sky130_fd_sc_hd__clkbuf_1
X_4764_ _1861_ VGND VGND VPWR VPWR _0280_ sky130_fd_sc_hd__clkbuf_1
XFILLER_0_16_625 VGND VGND VPWR VPWR sky130_fd_sc_hd__decap_4
X_7552_ _3729_ VGND VGND VPWR VPWR _1200_ sky130_fd_sc_hd__clkbuf_1
X_6503_ net894 _1420_ _2807_ VGND VGND VPWR VPWR _2815_ sky130_fd_sc_hd__mux2_1
XFILLER_0_15_113 VGND VGND VPWR VPWR sky130_fd_sc_hd__fill_1
X_7483_ net487 _1450_ _3677_ VGND VGND VPWR VPWR _3691_ sky130_fd_sc_hd__mux2_1
XFILLER_0_113_310 VGND VGND VPWR VPWR sky130_fd_sc_hd__fill_2
X_6434_ _2778_ VGND VGND VPWR VPWR _1033_ sky130_fd_sc_hd__clkbuf_1
X_9222_ net176 _1309_ net208 VGND VGND VPWR VPWR u_register_bank.sensor_enable\[23\]
+ sky130_fd_sc_hd__dfrtp_1
X_4695_ _1415_ net1221 _1817_ VGND VGND VPWR VPWR _1824_ sky130_fd_sc_hd__mux2_1
XFILLER_0_113_343 VGND VGND VPWR VPWR sky130_fd_sc_hd__fill_1
XFILLER_0_3_541 VPWR VGND VPWR VGND sky130_ef_sc_hd__decap_12
X_6365_ net710 _2510_ _2735_ VGND VGND VPWR VPWR _2742_ sky130_fd_sc_hd__mux2_1
XFILLER_0_3_585 VPWR VGND VPWR VGND sky130_ef_sc_hd__decap_12
X_9153_ net172 _1241_ VGND VGND VPWR VPWR net139 sky130_fd_sc_hd__dfxtp_2
XFILLER_0_87_73 VGND VGND VPWR VPWR sky130_fd_sc_hd__fill_1
X_6296_ net607 _2510_ _2698_ VGND VGND VPWR VPWR _2705_ sky130_fd_sc_hd__mux2_1
X_9084_ clknet_leaf_88_clk _1172_ VGND VGND VPWR VPWR u_input_buffer.fifo_mem\[63\]\[14\]
+ sky130_fd_sc_hd__dfxtp_1
X_8104_ clknet_leaf_102_clk _0193_ VGND VGND VPWR VPWR u_input_buffer.fifo_mem\[57\]\[14\]
+ sky130_fd_sc_hd__dfxtp_1
X_5316_ _2165_ VGND VGND VPWR VPWR _0528_ sky130_fd_sc_hd__clkbuf_1
X_8035_ clknet_leaf_20_clk _0124_ VGND VGND VPWR VPWR u_input_buffer.fifo_mem\[61\]\[9\]
+ sky130_fd_sc_hd__dfxtp_1
XFILLER_0_11_396 VGND VGND VPWR VPWR sky130_fd_sc_hd__fill_2
X_5247_ net782 _2016_ _2114_ VGND VGND VPWR VPWR _2129_ sky130_fd_sc_hd__mux2_1
Xhold37 u_input_buffer.fifo_mem\[0\]\[7\] VGND VGND VPWR VPWR net249 sky130_fd_sc_hd__dlygate4sd3_1
Xhold15 u_sample_counter.sample_count\[1\] VGND VGND VPWR VPWR net227 sky130_fd_sc_hd__dlygate4sd3_1
Xhold26 u_sample_counter.sample_count\[24\] VGND VGND VPWR VPWR net238 sky130_fd_sc_hd__dlygate4sd3_1
Xhold48 u_sample_counter.sample_count\[4\] VGND VGND VPWR VPWR net260 sky130_fd_sc_hd__dlygate4sd3_1
X_5178_ net522 _2016_ _2077_ VGND VGND VPWR VPWR _2092_ sky130_fd_sc_hd__mux2_1
Xhold59 u_input_buffer.fifo_mem\[19\]\[13\] VGND VGND VPWR VPWR net271 sky130_fd_sc_hd__dlygate4sd3_1
X_4129_ u_sensor_interface.sensor_array\[0\]\[11\] u_sensor_interface.sensor_array\[1\]\[11\]
+ net111 VGND VGND VPWR VPWR _1446_ sky130_fd_sc_hd__mux2_1
X_8937_ clknet_leaf_104_clk _1026_ VGND VGND VPWR VPWR u_input_buffer.fifo_mem\[5\]\[15\]
+ sky130_fd_sc_hd__dfxtp_1
XFILLER_0_78_363 VGND VGND VPWR VPWR sky130_fd_sc_hd__fill_1
XFILLER_0_78_374 VGND VGND VPWR VPWR sky130_fd_sc_hd__fill_2
X_8868_ clknet_leaf_106_clk _0957_ VGND VGND VPWR VPWR u_input_buffer.fifo_mem\[9\]\[10\]
+ sky130_fd_sc_hd__dfxtp_1
X_7819_ _3908_ VGND VGND VPWR VPWR _1288_ sky130_fd_sc_hd__clkbuf_1
X_8799_ clknet_leaf_2_clk _0888_ VGND VGND VPWR VPWR u_input_buffer.fifo_mem\[13\]\[5\]
+ sky130_fd_sc_hd__dfxtp_1
XFILLER_0_34_477 VPWR VGND VPWR VGND sky130_ef_sc_hd__decap_12
XFILLER_0_61_296 VGND VGND VPWR VPWR sky130_fd_sc_hd__fill_1
XFILLER_0_107_27 VPWR VGND VPWR VGND sky130_ef_sc_hd__decap_12
XFILLER_0_57_503 VGND VGND VPWR VPWR sky130_fd_sc_hd__fill_1
XFILLER_0_29_216 VGND VGND VPWR VPWR sky130_fd_sc_hd__decap_8
XFILLER_0_84_344 VGND VGND VPWR VPWR sky130_fd_sc_hd__decap_4
XTAP_1083 VGND VPWR sky130_fd_sc_hd__tapvpwrvgnd_1
XTAP_1072 VGND VPWR sky130_fd_sc_hd__tapvpwrvgnd_1
XTAP_1061 VGND VPWR sky130_fd_sc_hd__tapvpwrvgnd_1
XTAP_1050 VGND VPWR sky130_fd_sc_hd__tapvpwrvgnd_1
XFILLER_0_57_558 VGND VGND VPWR VPWR sky130_fd_sc_hd__fill_2
XFILLER_0_84_377 VGND VGND VPWR VPWR sky130_fd_sc_hd__fill_2
XTAP_1094 VGND VPWR sky130_fd_sc_hd__tapvpwrvgnd_1
Xhold507 u_input_buffer.fifo_mem\[58\]\[1\] VGND VGND VPWR VPWR net719 sky130_fd_sc_hd__dlygate4sd3_1
X_4480_ _1697_ VGND VGND VPWR VPWR _0160_ sky130_fd_sc_hd__clkbuf_1
Xhold518 u_input_buffer.fifo_mem\[42\]\[14\] VGND VGND VPWR VPWR net730 sky130_fd_sc_hd__dlygate4sd3_1
Xhold529 u_input_buffer.fifo_mem\[52\]\[6\] VGND VGND VPWR VPWR net741 sky130_fd_sc_hd__dlygate4sd3_1
X_6150_ _2627_ VGND VGND VPWR VPWR _0900_ sky130_fd_sc_hd__clkbuf_1
XFILLER_0_57_10 VGND VGND VPWR VPWR sky130_fd_sc_hd__decap_8
XFILLER_0_0_533 VGND VGND VPWR VPWR sky130_fd_sc_hd__fill_2
XFILLER_0_0_555 VGND VGND VPWR VPWR sky130_fd_sc_hd__fill_1
XTAP_801 VGND VPWR sky130_fd_sc_hd__tapvpwrvgnd_1
XFILLER_0_110_379 VGND VGND VPWR VPWR sky130_fd_sc_hd__fill_2
X_5101_ _2051_ VGND VGND VPWR VPWR _0427_ sky130_fd_sc_hd__clkbuf_1
XFILLER_0_57_21 VGND VGND VPWR VPWR sky130_fd_sc_hd__decap_6
XTAP_812 VGND VPWR sky130_fd_sc_hd__tapvpwrvgnd_1
XTAP_823 VGND VPWR sky130_fd_sc_hd__tapvpwrvgnd_1
XTAP_834 VGND VPWR sky130_fd_sc_hd__tapvpwrvgnd_1
X_6081_ net934 _2502_ _2587_ VGND VGND VPWR VPWR _2590_ sky130_fd_sc_hd__mux2_1
XTAP_845 VGND VPWR sky130_fd_sc_hd__tapvpwrvgnd_1
XTAP_856 VGND VPWR sky130_fd_sc_hd__tapvpwrvgnd_1
XTAP_867 VGND VPWR sky130_fd_sc_hd__tapvpwrvgnd_1
XFILLER_0_32_7 VGND VGND VPWR VPWR sky130_fd_sc_hd__fill_1
X_5032_ _1444_ VGND VGND VPWR VPWR _2012_ sky130_fd_sc_hd__clkbuf_4
XTAP_889 VGND VPWR sky130_fd_sc_hd__tapvpwrvgnd_1
XTAP_878 VGND VPWR sky130_fd_sc_hd__tapvpwrvgnd_1
XFILLER_0_73_42 VGND VGND VPWR VPWR sky130_fd_sc_hd__fill_1
X_6983_ u_input_buffer.fifo_mem\[39\]\[4\] _3050_ _3052_ u_input_buffer.fifo_mem\[40\]\[4\]
+ VGND VGND VPWR VPWR _3231_ sky130_fd_sc_hd__a22o_1
XFILLER_0_75_311 VGND VGND VPWR VPWR sky130_fd_sc_hd__fill_1
X_8722_ clknet_leaf_16_clk _0811_ VGND VGND VPWR VPWR u_input_buffer.fifo_mem\[18\]\[8\]
+ sky130_fd_sc_hd__dfxtp_1
X_5934_ _2505_ VGND VGND VPWR VPWR _0806_ sky130_fd_sc_hd__clkbuf_1
XFILLER_0_48_525 VGND VGND VPWR VPWR sky130_fd_sc_hd__fill_1
X_5865_ net595 _2254_ _2461_ VGND VGND VPWR VPWR _2467_ sky130_fd_sc_hd__mux2_1
X_8653_ clknet_leaf_66_clk _0742_ VGND VGND VPWR VPWR u_input_buffer.fifo_mem\[22\]\[3\]
+ sky130_fd_sc_hd__dfxtp_1
X_7604_ _3757_ VGND VGND VPWR VPWR _1224_ sky130_fd_sc_hd__clkbuf_1
X_4816_ net598 _1732_ _1873_ VGND VGND VPWR VPWR _1889_ sky130_fd_sc_hd__mux2_1
X_5796_ _2430_ VGND VGND VPWR VPWR _0743_ sky130_fd_sc_hd__clkbuf_1
X_8584_ clknet_leaf_91_clk _0673_ VGND VGND VPWR VPWR u_input_buffer.fifo_mem\[27\]\[14\]
+ sky130_fd_sc_hd__dfxtp_1
X_7535_ _3720_ VGND VGND VPWR VPWR _1192_ sky130_fd_sc_hd__clkbuf_1
X_4747_ _1851_ VGND VGND VPWR VPWR _0273_ sky130_fd_sc_hd__clkbuf_1
X_7466_ _3682_ VGND VGND VPWR VPWR _1161_ sky130_fd_sc_hd__clkbuf_1
X_4678_ net365 _1734_ _1797_ VGND VGND VPWR VPWR _1814_ sky130_fd_sc_hd__mux2_1
XFILLER_0_16_488 VGND VGND VPWR VPWR sky130_fd_sc_hd__decap_4
XFILLER_0_98_94 VGND VGND VPWR VPWR sky130_fd_sc_hd__decap_3
XFILLER_0_98_83 VGND VGND VPWR VPWR sky130_fd_sc_hd__fill_1
X_9205_ net180 _1292_ net211 VGND VGND VPWR VPWR u_register_bank.sensor_enable\[6\]
+ sky130_fd_sc_hd__dfrtp_1
X_6417_ _1632_ net969 _2752_ VGND VGND VPWR VPWR _2769_ sky130_fd_sc_hd__mux2_1
XFILLER_0_31_447 VGND VGND VPWR VPWR sky130_fd_sc_hd__fill_1
X_7397_ u_input_buffer.fifo_mem\[2\]\[15\] _2983_ _2985_ u_input_buffer.fifo_mem\[32\]\[15\]
+ VGND VGND VPWR VPWR _3634_ sky130_fd_sc_hd__a22o_1
X_9136_ net169 _1224_ net201 VGND VGND VPWR VPWR u_register_bank.threshold_cfg\[18\]
+ sky130_fd_sc_hd__dfrtp_1
X_6348_ _2732_ VGND VGND VPWR VPWR _0993_ sky130_fd_sc_hd__clkbuf_1
X_9067_ clknet_leaf_102_clk _1156_ VGND VGND VPWR VPWR u_sensor_interface.sensor_array\[3\]\[14\]
+ sky130_fd_sc_hd__dfxtp_1
Xinput105 sensor_data_in[63] VGND VGND VPWR VPWR net105 sky130_fd_sc_hd__clkbuf_1
X_6279_ _2695_ VGND VGND VPWR VPWR _0961_ sky130_fd_sc_hd__clkbuf_1
X_8018_ clknet_leaf_70_clk _0107_ VGND VGND VPWR VPWR u_input_buffer.fifo_mem\[62\]\[8\]
+ sky130_fd_sc_hd__dfxtp_1
XPHY_100 VGND VGND VPWR VPWR sky130_fd_sc_hd__decap_3
XPHY_133 VGND VGND VPWR VPWR sky130_fd_sc_hd__decap_3
XPHY_122 VGND VGND VPWR VPWR sky130_fd_sc_hd__decap_3
XPHY_111 VGND VGND VPWR VPWR sky130_fd_sc_hd__decap_3
XPHY_166 VGND VGND VPWR VPWR sky130_fd_sc_hd__decap_3
XPHY_155 VGND VGND VPWR VPWR sky130_fd_sc_hd__decap_3
XPHY_144 VGND VGND VPWR VPWR sky130_fd_sc_hd__decap_3
XFILLER_0_19_260 VGND VGND VPWR VPWR sky130_fd_sc_hd__fill_1
XPHY_199 VGND VGND VPWR VPWR sky130_fd_sc_hd__decap_3
XPHY_188 VGND VGND VPWR VPWR sky130_fd_sc_hd__decap_3
XPHY_177 VGND VGND VPWR VPWR sky130_fd_sc_hd__decap_3
XFILLER_0_54_539 VGND VGND VPWR VPWR sky130_fd_sc_hd__fill_1
XFILLER_0_105_685 VGND VGND VPWR VPWR sky130_fd_sc_hd__fill_1
X_3980_ _1340_ VGND VGND VPWR VPWR _0017_ sky130_fd_sc_hd__clkbuf_1
XPHY_2 VGND VGND VPWR VPWR sky130_fd_sc_hd__decap_3
X_5650_ net688 _2240_ _2352_ VGND VGND VPWR VPWR _2353_ sky130_fd_sc_hd__mux2_1
Xclkbuf_0_clk clk VGND VGND VPWR VPWR clknet_0_clk sky130_fd_sc_hd__clkbuf_16
XFILLER_0_17_219 VGND VGND VPWR VPWR sky130_fd_sc_hd__decap_4
X_4601_ net484 _1730_ _1756_ VGND VGND VPWR VPWR _1771_ sky130_fd_sc_hd__mux2_1
X_5581_ net1006 _2240_ _2315_ VGND VGND VPWR VPWR _2316_ sky130_fd_sc_hd__mux2_1
XFILLER_0_94_9 VGND VGND VPWR VPWR sky130_fd_sc_hd__fill_2
XFILLER_0_60_509 VGND VGND VPWR VPWR sky130_fd_sc_hd__decap_3
XFILLER_0_4_135 VGND VGND VPWR VPWR sky130_fd_sc_hd__fill_2
X_4532_ net954 _1732_ _1703_ VGND VGND VPWR VPWR _1733_ sky130_fd_sc_hd__mux2_1
X_7320_ u_input_buffer.fifo_mem\[12\]\[13\] _2979_ _2981_ u_input_buffer.fifo_mem\[18\]\[13\]
+ _3558_ VGND VGND VPWR VPWR _3559_ sky130_fd_sc_hd__a221o_1
X_4463_ net1324 _1612_ _1683_ VGND VGND VPWR VPWR _1689_ sky130_fd_sc_hd__mux2_1
Xhold326 u_input_buffer.fifo_mem\[8\]\[8\] VGND VGND VPWR VPWR net538 sky130_fd_sc_hd__dlygate4sd3_1
XFILLER_0_13_447 VGND VGND VPWR VPWR sky130_fd_sc_hd__fill_1
X_7251_ u_input_buffer.fifo_mem\[30\]\[11\] _3028_ _3030_ u_input_buffer.fifo_mem\[58\]\[11\]
+ VGND VGND VPWR VPWR _3492_ sky130_fd_sc_hd__a22o_1
Xhold315 u_input_buffer.fifo_mem\[31\]\[14\] VGND VGND VPWR VPWR net527 sky130_fd_sc_hd__dlygate4sd3_1
Xhold304 u_input_buffer.fifo_mem\[24\]\[8\] VGND VGND VPWR VPWR net516 sky130_fd_sc_hd__dlygate4sd3_1
Xhold348 u_input_buffer.fifo_mem\[30\]\[6\] VGND VGND VPWR VPWR net560 sky130_fd_sc_hd__dlygate4sd3_1
Xhold359 u_input_buffer.fifo_mem\[60\]\[0\] VGND VGND VPWR VPWR net571 sky130_fd_sc_hd__dlygate4sd3_1
Xhold337 u_input_buffer.fifo_mem\[3\]\[4\] VGND VGND VPWR VPWR net549 sky130_fd_sc_hd__dlygate4sd3_1
X_6202_ net818 _2518_ _2643_ VGND VGND VPWR VPWR _2655_ sky130_fd_sc_hd__mux2_1
XFILLER_0_7_78 VGND VGND VPWR VPWR sky130_fd_sc_hd__decap_4
X_7182_ u_input_buffer.fifo_mem\[3\]\[9\] _3070_ _3072_ u_input_buffer.fifo_mem\[60\]\[9\]
+ VGND VGND VPWR VPWR _3425_ sky130_fd_sc_hd__a22o_1
X_4394_ _1649_ VGND VGND VPWR VPWR _0122_ sky130_fd_sc_hd__clkbuf_1
X_6133_ _1622_ net937 _2606_ VGND VGND VPWR VPWR _2618_ sky130_fd_sc_hd__mux2_1
XTAP_620 VGND VPWR sky130_fd_sc_hd__tapvpwrvgnd_1
XTAP_631 VGND VPWR sky130_fd_sc_hd__tapvpwrvgnd_1
XTAP_642 VGND VPWR sky130_fd_sc_hd__tapvpwrvgnd_1
XFILLER_0_84_41 VPWR VGND VPWR VGND sky130_ef_sc_hd__decap_12
Xhold1015 u_input_buffer.fifo_mem\[38\]\[7\] VGND VGND VPWR VPWR net1227 sky130_fd_sc_hd__dlygate4sd3_1
X_6064_ _2580_ VGND VGND VPWR VPWR _0861_ sky130_fd_sc_hd__clkbuf_1
Xhold1004 u_input_buffer.fifo_mem\[53\]\[11\] VGND VGND VPWR VPWR net1216 sky130_fd_sc_hd__dlygate4sd3_1
XTAP_653 VGND VPWR sky130_fd_sc_hd__tapvpwrvgnd_1
XTAP_664 VGND VPWR sky130_fd_sc_hd__tapvpwrvgnd_1
XTAP_675 VGND VPWR sky130_fd_sc_hd__tapvpwrvgnd_1
XTAP_686 VGND VPWR sky130_fd_sc_hd__tapvpwrvgnd_1
X_5015_ net957 _2000_ _1990_ VGND VGND VPWR VPWR _2001_ sky130_fd_sc_hd__mux2_1
Xhold1026 u_input_buffer.fifo_mem\[9\]\[13\] VGND VGND VPWR VPWR net1238 sky130_fd_sc_hd__dlygate4sd3_1
XTAP_697 VGND VPWR sky130_fd_sc_hd__tapvpwrvgnd_1
Xhold1048 u_input_buffer.fifo_mem\[21\]\[9\] VGND VGND VPWR VPWR net1260 sky130_fd_sc_hd__dlygate4sd3_1
Xhold1037 u_input_buffer.fifo_mem\[61\]\[7\] VGND VGND VPWR VPWR net1249 sky130_fd_sc_hd__dlygate4sd3_1
XFILLER_0_23_3 VGND VGND VPWR VPWR sky130_fd_sc_hd__decap_8
Xhold1059 u_input_buffer.fifo_mem\[57\]\[3\] VGND VGND VPWR VPWR net1271 sky130_fd_sc_hd__dlygate4sd3_1
X_6966_ u_input_buffer.fifo_mem\[16\]\[4\] _2971_ _2973_ u_input_buffer.fifo_mem\[49\]\[4\]
+ _2975_ VGND VGND VPWR VPWR _3214_ sky130_fd_sc_hd__a221o_1
X_8705_ clknet_leaf_66_clk _0794_ VGND VGND VPWR VPWR u_input_buffer.fifo_mem\[19\]\[7\]
+ sky130_fd_sc_hd__dfxtp_1
XFILLER_0_76_653 VGND VGND VPWR VPWR sky130_fd_sc_hd__fill_2
X_5917_ net1116 _2272_ _2478_ VGND VGND VPWR VPWR _2494_ sky130_fd_sc_hd__mux2_1
X_6897_ u_input_buffer.fifo_mem\[8\]\[2\] _3004_ _3006_ u_input_buffer.fifo_mem\[19\]\[2\]
+ _3146_ VGND VGND VPWR VPWR _3147_ sky130_fd_sc_hd__a221o_1
X_8636_ clknet_leaf_53_clk _0725_ VGND VGND VPWR VPWR u_input_buffer.fifo_mem\[23\]\[2\]
+ sky130_fd_sc_hd__dfxtp_1
XFILLER_0_75_196 VGND VGND VPWR VPWR sky130_fd_sc_hd__fill_1
X_5848_ _2457_ VGND VGND VPWR VPWR _0768_ sky130_fd_sc_hd__clkbuf_1
X_5779_ net662 _2270_ _2406_ VGND VGND VPWR VPWR _2421_ sky130_fd_sc_hd__mux2_1
X_8567_ clknet_leaf_73_clk _0656_ VGND VGND VPWR VPWR u_input_buffer.fifo_mem\[28\]\[13\]
+ sky130_fd_sc_hd__dfxtp_1
X_7518_ net13 u_register_bank.window_cfg\[10\] _3711_ VGND VGND VPWR VPWR _3712_ sky130_fd_sc_hd__mux2_1
X_8498_ clknet_leaf_16_clk _0587_ VGND VGND VPWR VPWR u_input_buffer.fifo_mem\[32\]\[8\]
+ sky130_fd_sc_hd__dfxtp_1
X_7449_ net580 net102 _1322_ VGND VGND VPWR VPWR _3673_ sky130_fd_sc_hd__mux2_1
XFILLER_0_102_677 VGND VGND VPWR VPWR sky130_fd_sc_hd__decap_6
Xhold871 u_input_buffer.fifo_mem\[45\]\[9\] VGND VGND VPWR VPWR net1083 sky130_fd_sc_hd__dlygate4sd3_1
Xhold860 u_input_buffer.fifo_mem\[61\]\[9\] VGND VGND VPWR VPWR net1072 sky130_fd_sc_hd__dlygate4sd3_1
Xhold882 u_input_buffer.fifo_mem\[21\]\[6\] VGND VGND VPWR VPWR net1094 sky130_fd_sc_hd__dlygate4sd3_1
X_9119_ net177 _1207_ net209 VGND VGND VPWR VPWR u_analytics_engine.threshold\[1\]
+ sky130_fd_sc_hd__dfrtp_2
Xhold893 u_input_buffer.fifo_mem\[17\]\[12\] VGND VGND VPWR VPWR net1105 sky130_fd_sc_hd__dlygate4sd3_1
XFILLER_0_98_222 VGND VGND VPWR VPWR sky130_fd_sc_hd__decap_3
XFILLER_0_98_266 VGND VGND VPWR VPWR sky130_fd_sc_hd__fill_2
XFILLER_0_86_417 VGND VGND VPWR VPWR sky130_fd_sc_hd__decap_3
XFILLER_0_13_15 VPWR VGND VPWR VGND sky130_ef_sc_hd__decap_12
XFILLER_0_82_645 VGND VGND VPWR VPWR sky130_fd_sc_hd__decap_4
XFILLER_0_50_553 VGND VGND VPWR VPWR sky130_fd_sc_hd__fill_1
XFILLER_0_38_78 VGND VGND VPWR VPWR sky130_fd_sc_hd__decap_3
XFILLER_0_89_222 VGND VGND VPWR VPWR sky130_fd_sc_hd__fill_2
XFILLER_0_54_22 VGND VGND VPWR VPWR sky130_fd_sc_hd__decap_6
X_6820_ _3071_ VGND VGND VPWR VPWR _3072_ sky130_fd_sc_hd__clkbuf_4
X_3963_ _1331_ VGND VGND VPWR VPWR _0009_ sky130_fd_sc_hd__clkbuf_1
XFILLER_0_70_21 VGND VGND VPWR VPWR sky130_fd_sc_hd__decap_4
XFILLER_0_58_664 VGND VGND VPWR VPWR sky130_fd_sc_hd__fill_2
XFILLER_0_18_517 VGND VGND VPWR VPWR sky130_fd_sc_hd__fill_2
X_6751_ _2930_ _3002_ VGND VGND VPWR VPWR _3003_ sky130_fd_sc_hd__nor2_4
XFILLER_0_73_645 VGND VGND VPWR VPWR sky130_fd_sc_hd__fill_2
X_6682_ _2933_ VGND VGND VPWR VPWR _2934_ sky130_fd_sc_hd__clkbuf_4
X_5702_ _1620_ net993 _2370_ VGND VGND VPWR VPWR _2380_ sky130_fd_sc_hd__mux2_1
X_5633_ _2343_ VGND VGND VPWR VPWR _0667_ sky130_fd_sc_hd__clkbuf_1
XFILLER_0_5_400 VGND VGND VPWR VPWR sky130_fd_sc_hd__decap_3
X_8421_ clknet_leaf_0_clk _0510_ VGND VGND VPWR VPWR u_input_buffer.fifo_mem\[37\]\[11\]
+ sky130_fd_sc_hd__dfxtp_1
XFILLER_0_45_347 VGND VGND VPWR VPWR sky130_fd_sc_hd__decap_4
XFILLER_0_115_246 VGND VGND VPWR VPWR sky130_fd_sc_hd__fill_2
X_8352_ clknet_leaf_18_clk _0441_ VGND VGND VPWR VPWR u_input_buffer.fifo_mem\[41\]\[6\]
+ sky130_fd_sc_hd__dfxtp_1
XFILLER_0_60_306 VGND VGND VPWR VPWR sky130_fd_sc_hd__fill_2
X_5564_ _2306_ VGND VGND VPWR VPWR _0635_ sky130_fd_sc_hd__clkbuf_1
X_4515_ _1721_ VGND VGND VPWR VPWR _0171_ sky130_fd_sc_hd__clkbuf_1
X_7303_ _3536_ _3538_ _3540_ _3542_ VGND VGND VPWR VPWR _3543_ sky130_fd_sc_hd__or4_1
XFILLER_0_41_531 VGND VGND VPWR VPWR sky130_fd_sc_hd__fill_1
Xhold101 u_input_buffer.fifo_mem\[8\]\[10\] VGND VGND VPWR VPWR net313 sky130_fd_sc_hd__dlygate4sd3_1
Xhold134 u_input_buffer.fifo_mem\[3\]\[0\] VGND VGND VPWR VPWR net346 sky130_fd_sc_hd__dlygate4sd3_1
X_8283_ clknet_leaf_21_clk _0372_ VGND VGND VPWR VPWR u_input_buffer.fifo_mem\[45\]\[1\]
+ sky130_fd_sc_hd__dfxtp_1
X_5495_ net417 _2266_ _2243_ VGND VGND VPWR VPWR _2267_ sky130_fd_sc_hd__mux2_1
Xhold112 u_input_buffer.fifo_mem\[34\]\[12\] VGND VGND VPWR VPWR net324 sky130_fd_sc_hd__dlygate4sd3_1
Xhold123 u_input_buffer.fifo_mem\[56\]\[15\] VGND VGND VPWR VPWR net335 sky130_fd_sc_hd__dlygate4sd3_1
X_7234_ u_input_buffer.fifo_mem\[17\]\[11\] _2942_ _2944_ u_input_buffer.fifo_mem\[5\]\[11\]
+ VGND VGND VPWR VPWR _3475_ sky130_fd_sc_hd__a22o_1
X_4446_ _1677_ VGND VGND VPWR VPWR _0146_ sky130_fd_sc_hd__clkbuf_1
Xhold156 u_input_buffer.fifo_mem\[55\]\[14\] VGND VGND VPWR VPWR net368 sky130_fd_sc_hd__dlygate4sd3_1
Xhold167 u_input_buffer.fifo_mem\[51\]\[11\] VGND VGND VPWR VPWR net379 sky130_fd_sc_hd__dlygate4sd3_1
Xhold145 u_input_buffer.fifo_mem\[48\]\[13\] VGND VGND VPWR VPWR net357 sky130_fd_sc_hd__dlygate4sd3_1
Xhold178 u_input_buffer.fifo_mem\[15\]\[8\] VGND VGND VPWR VPWR net390 sky130_fd_sc_hd__dlygate4sd3_1
Xhold189 u_input_buffer.fifo_mem\[63\]\[9\] VGND VGND VPWR VPWR net401 sky130_fd_sc_hd__dlygate4sd3_1
X_7165_ u_input_buffer.fifo_mem\[50\]\[9\] _2995_ _2997_ u_input_buffer.fifo_mem\[4\]\[9\]
+ VGND VGND VPWR VPWR _3408_ sky130_fd_sc_hd__a22o_1
X_4377_ _1634_ _1639_ VGND VGND VPWR VPWR _1640_ sky130_fd_sc_hd__nand2_4
XFILLER_0_95_51 VGND VGND VPWR VPWR sky130_fd_sc_hd__decap_4
XTAP_450 VGND VPWR sky130_fd_sc_hd__tapvpwrvgnd_1
X_6116_ _2609_ VGND VGND VPWR VPWR _0884_ sky130_fd_sc_hd__clkbuf_1
X_7096_ u_input_buffer.fifo_mem\[7\]\[7\] _3025_ _3027_ u_input_buffer.fifo_mem\[22\]\[7\]
+ _3340_ VGND VGND VPWR VPWR _3341_ sky130_fd_sc_hd__a221o_1
XTAP_461 VGND VPWR sky130_fd_sc_hd__tapvpwrvgnd_1
XTAP_472 VGND VPWR sky130_fd_sc_hd__tapvpwrvgnd_1
XTAP_494 VGND VPWR sky130_fd_sc_hd__tapvpwrvgnd_1
XTAP_483 VGND VPWR sky130_fd_sc_hd__tapvpwrvgnd_1
X_6047_ net328 _2502_ _2569_ VGND VGND VPWR VPWR _2572_ sky130_fd_sc_hd__mux2_1
XTAP_1605 VGND VPWR sky130_fd_sc_hd__tapvpwrvgnd_1
XTAP_1638 VGND VPWR sky130_fd_sc_hd__tapvpwrvgnd_1
XTAP_1627 VGND VPWR sky130_fd_sc_hd__tapvpwrvgnd_1
XTAP_1616 VGND VPWR sky130_fd_sc_hd__tapvpwrvgnd_1
XFILLER_0_95_225 VGND VGND VPWR VPWR sky130_fd_sc_hd__fill_1
X_7998_ clknet_leaf_62_clk _0087_ net195 VGND VGND VPWR VPWR u_sample_counter.sample_count\[21\]
+ sky130_fd_sc_hd__dfrtp_1
X_6949_ u_input_buffer.fifo_mem\[26\]\[3\] _3066_ _3068_ u_input_buffer.fifo_mem\[62\]\[3\]
+ _3197_ VGND VGND VPWR VPWR _3198_ sky130_fd_sc_hd__a221o_1
XFILLER_0_64_601 VGND VGND VPWR VPWR sky130_fd_sc_hd__decap_4
XFILLER_0_63_111 VGND VGND VPWR VPWR sky130_fd_sc_hd__fill_1
XFILLER_0_91_442 VGND VGND VPWR VPWR sky130_fd_sc_hd__decap_6
X_8619_ clknet_leaf_60_clk _0708_ VGND VGND VPWR VPWR u_input_buffer.fifo_mem\[24\]\[1\]
+ sky130_fd_sc_hd__dfxtp_1
XFILLER_0_106_224 VGND VGND VPWR VPWR sky130_fd_sc_hd__decap_4
XFILLER_0_91_475 VGND VGND VPWR VPWR sky130_fd_sc_hd__decap_4
Xhold690 u_input_buffer.fifo_mem\[36\]\[11\] VGND VGND VPWR VPWR net902 sky130_fd_sc_hd__dlygate4sd3_1
XFILLER_0_115_27 VGND VGND VPWR VPWR sky130_fd_sc_hd__fill_1
XFILLER_0_115_49 VGND VGND VPWR VPWR sky130_fd_sc_hd__decap_6
XFILLER_0_86_258 VGND VGND VPWR VPWR sky130_fd_sc_hd__decap_4
XFILLER_0_67_461 VGND VGND VPWR VPWR sky130_fd_sc_hd__fill_1
XFILLER_0_55_601 VPWR VGND VPWR VGND sky130_ef_sc_hd__decap_12
XFILLER_0_27_358 VGND VGND VPWR VPWR sky130_fd_sc_hd__decap_3
XFILLER_0_27_369 VGND VGND VPWR VPWR sky130_fd_sc_hd__fill_1
XFILLER_0_39_196 VGND VGND VPWR VPWR sky130_fd_sc_hd__decap_4
XFILLER_0_82_486 VGND VGND VPWR VPWR sky130_fd_sc_hd__fill_1
XFILLER_0_112_205 VGND VGND VPWR VPWR sky130_fd_sc_hd__fill_1
XFILLER_0_49_11 VGND VGND VPWR VPWR sky130_fd_sc_hd__decap_3
X_4300_ u_analytics_engine.threshold\[1\] _1576_ _1579_ VGND VGND VPWR VPWR _1580_
+ sky130_fd_sc_hd__o21a_1
X_5280_ _2146_ VGND VGND VPWR VPWR _0511_ sky130_fd_sc_hd__clkbuf_1
XFILLER_0_23_597 VPWR VGND VPWR VGND sky130_ef_sc_hd__decap_12
XFILLER_0_49_55 VGND VGND VPWR VPWR sky130_fd_sc_hd__fill_1
X_4231_ net215 _1517_ _1519_ VGND VGND VPWR VPWR _0089_ sky130_fd_sc_hd__o21a_1
XFILLER_0_49_66 VGND VGND VPWR VPWR sky130_fd_sc_hd__decap_4
X_4162_ u_analytics_engine.data_valid VGND VGND VPWR VPWR _1474_ sky130_fd_sc_hd__buf_6
X_8970_ clknet_leaf_26_clk _1059_ VGND VGND VPWR VPWR u_input_buffer.fifo_mem\[2\]\[0\]
+ sky130_fd_sc_hd__dfxtp_1
X_4093_ _1414_ VGND VGND VPWR VPWR _1415_ sky130_fd_sc_hd__buf_2
X_7921_ clknet_leaf_83_clk _0011_ VGND VGND VPWR VPWR u_sensor_interface.sensor_array\[2\]\[9\]
+ sky130_fd_sc_hd__dfxtp_2
X_7852_ _3925_ VGND VGND VPWR VPWR _1304_ sky130_fd_sc_hd__clkbuf_1
X_7783_ net156 u_analytics_engine.data_in\[2\] _1474_ VGND VGND VPWR VPWR _3889_ sky130_fd_sc_hd__mux2_1
X_4995_ _1469_ net1059 _1970_ VGND VGND VPWR VPWR _1987_ sky130_fd_sc_hd__mux2_1
X_6803_ _2930_ _2959_ VGND VGND VPWR VPWR _3055_ sky130_fd_sc_hd__nor2_2
XFILLER_0_105_82 VPWR VGND VPWR VGND sky130_ef_sc_hd__decap_12
X_6734_ _2985_ VGND VGND VPWR VPWR _2986_ sky130_fd_sc_hd__buf_4
XFILLER_0_14_80 VGND VGND VPWR VPWR sky130_fd_sc_hd__decap_4
X_3946_ net184 VGND VGND VPWR VPWR _1322_ sky130_fd_sc_hd__buf_4
XFILLER_0_45_100 VGND VGND VPWR VPWR sky130_fd_sc_hd__fill_1
XFILLER_0_73_431 VGND VGND VPWR VPWR sky130_fd_sc_hd__decap_8
XFILLER_0_18_358 VGND VGND VPWR VPWR sky130_fd_sc_hd__decap_6
XFILLER_0_90_3 VPWR VGND VPWR VGND sky130_ef_sc_hd__decap_12
XFILLER_0_73_475 VGND VGND VPWR VPWR sky130_fd_sc_hd__decap_6
X_6665_ _2916_ VGND VGND VPWR VPWR _2917_ sky130_fd_sc_hd__clkbuf_4
X_8404_ clknet_leaf_72_clk _0493_ VGND VGND VPWR VPWR u_input_buffer.fifo_mem\[38\]\[10\]
+ sky130_fd_sc_hd__dfxtp_1
X_5616_ net822 _2240_ _2334_ VGND VGND VPWR VPWR _2335_ sky130_fd_sc_hd__mux2_1
X_6596_ _2864_ _2861_ _2862_ VGND VGND VPWR VPWR _2865_ sky130_fd_sc_hd__a21bo_1
XFILLER_0_14_531 VGND VGND VPWR VPWR sky130_fd_sc_hd__fill_1
X_8335_ clknet_leaf_32_clk _0424_ VGND VGND VPWR VPWR u_input_buffer.fifo_mem\[42\]\[5\]
+ sky130_fd_sc_hd__dfxtp_1
X_5547_ _1377_ net883 _2297_ VGND VGND VPWR VPWR _2298_ sky130_fd_sc_hd__mux2_1
X_8266_ clknet_leaf_35_clk _0355_ VGND VGND VPWR VPWR u_input_buffer.fifo_mem\[46\]\[0\]
+ sky130_fd_sc_hd__dfxtp_1
X_5478_ _2255_ VGND VGND VPWR VPWR _0600_ sky130_fd_sc_hd__clkbuf_1
X_4429_ net765 _1616_ _1661_ VGND VGND VPWR VPWR _1669_ sky130_fd_sc_hd__mux2_1
X_7217_ u_input_buffer.fifo_mem\[39\]\[10\] _3049_ _3051_ u_input_buffer.fifo_mem\[40\]\[10\]
+ VGND VGND VPWR VPWR _3459_ sky130_fd_sc_hd__a22o_1
X_8197_ clknet_leaf_9_clk _0286_ VGND VGND VPWR VPWR u_input_buffer.fifo_mem\[51\]\[11\]
+ sky130_fd_sc_hd__dfxtp_1
X_7148_ _3373_ _3382_ _3391_ VGND VGND VPWR VPWR _3392_ sky130_fd_sc_hd__or3_1
XTAP_291 VGND VPWR sky130_fd_sc_hd__tapvpwrvgnd_1
XTAP_280 VGND VPWR sky130_fd_sc_hd__tapvpwrvgnd_1
X_7079_ u_input_buffer.fifo_mem\[29\]\[7\] _2939_ _2941_ u_input_buffer.fifo_mem\[13\]\[7\]
+ _3323_ VGND VGND VPWR VPWR _3324_ sky130_fd_sc_hd__a221o_1
XTAP_1424 VGND VPWR sky130_fd_sc_hd__tapvpwrvgnd_1
XTAP_1413 VGND VPWR sky130_fd_sc_hd__tapvpwrvgnd_1
XTAP_1402 VGND VPWR sky130_fd_sc_hd__tapvpwrvgnd_1
XFILLER_0_68_247 VGND VGND VPWR VPWR sky130_fd_sc_hd__fill_2
XTAP_1457 VGND VPWR sky130_fd_sc_hd__tapvpwrvgnd_1
XTAP_1435 VGND VPWR sky130_fd_sc_hd__tapvpwrvgnd_1
XTAP_1446 VGND VPWR sky130_fd_sc_hd__tapvpwrvgnd_1
XFILLER_0_96_589 VGND VGND VPWR VPWR sky130_fd_sc_hd__decap_4
XTAP_1479 VGND VPWR sky130_fd_sc_hd__tapvpwrvgnd_1
XTAP_1468 VGND VPWR sky130_fd_sc_hd__tapvpwrvgnd_1
XFILLER_0_64_453 VGND VGND VPWR VPWR sky130_fd_sc_hd__fill_1
XFILLER_0_10_27 VGND VGND VPWR VPWR sky130_fd_sc_hd__fill_1
XFILLER_0_20_523 VGND VGND VPWR VPWR sky130_fd_sc_hd__decap_8
XFILLER_0_19_47 VGND VGND VPWR VPWR sky130_fd_sc_hd__fill_1
XFILLER_0_35_57 VGND VGND VPWR VPWR sky130_fd_sc_hd__fill_2
X_4780_ _1869_ VGND VGND VPWR VPWR _0288_ sky130_fd_sc_hd__clkbuf_1
XFILLER_0_7_517 VPWR VGND VPWR VGND sky130_ef_sc_hd__decap_12
XFILLER_0_113_503 VGND VGND VPWR VPWR sky130_fd_sc_hd__fill_1
X_6450_ _2786_ VGND VGND VPWR VPWR _1041_ sky130_fd_sc_hd__clkbuf_1
X_5401_ _1409_ net1139 _2205_ VGND VGND VPWR VPWR _2211_ sky130_fd_sc_hd__mux2_1
X_6381_ net891 _2526_ _2734_ VGND VGND VPWR VPWR _2750_ sky130_fd_sc_hd__mux2_1
XFILLER_0_113_558 VGND VGND VPWR VPWR sky130_fd_sc_hd__fill_2
X_5332_ _2174_ VGND VGND VPWR VPWR _0535_ sky130_fd_sc_hd__clkbuf_1
X_8120_ clknet_leaf_73_clk _0209_ VGND VGND VPWR VPWR u_input_buffer.fifo_mem\[56\]\[14\]
+ sky130_fd_sc_hd__dfxtp_1
XFILLER_0_51_681 VGND VGND VPWR VPWR sky130_fd_sc_hd__decap_4
X_8051_ clknet_leaf_42_clk _0140_ VGND VGND VPWR VPWR u_input_buffer.fifo_mem\[60\]\[9\]
+ sky130_fd_sc_hd__dfxtp_1
X_5263_ _1403_ net1119 _2133_ VGND VGND VPWR VPWR _2138_ sky130_fd_sc_hd__mux2_1
X_5194_ _2101_ VGND VGND VPWR VPWR _0470_ sky130_fd_sc_hd__clkbuf_1
X_4214_ _1501_ _1504_ u_sample_counter.sample_count\[18\] VGND VGND VPWR VPWR _1508_
+ sky130_fd_sc_hd__o21ba_1
X_7002_ u_input_buffer.fifo_mem\[1\]\[5\] _2932_ _3246_ _3248_ VGND VGND VPWR VPWR
+ _3249_ sky130_fd_sc_hd__a211o_1
X_4145_ _1459_ u_sensor_interface.sensor_array\[3\]\[13\] net113 VGND VGND VPWR VPWR
+ _1460_ sky130_fd_sc_hd__mux2_1
XFILLER_0_92_41 VPWR VGND VPWR VGND sky130_ef_sc_hd__decap_12
X_4076_ _1397_ _1400_ _0000_ VGND VGND VPWR VPWR _1401_ sky130_fd_sc_hd__mux2_1
X_8953_ clknet_leaf_98_clk _1042_ VGND VGND VPWR VPWR u_input_buffer.fifo_mem\[4\]\[15\]
+ sky130_fd_sc_hd__dfxtp_1
XFILLER_0_92_85 VGND VGND VPWR VPWR sky130_fd_sc_hd__decap_3
X_7904_ clknet_leaf_78_clk net238 net190 VGND VGND VPWR VPWR u_register_bank.status_flags\[24\]
+ sky130_fd_sc_hd__dfrtp_1
X_8884_ clknet_leaf_73_clk _0973_ VGND VGND VPWR VPWR u_input_buffer.fifo_mem\[8\]\[10\]
+ sky130_fd_sc_hd__dfxtp_1
X_7835_ net13 u_register_bank.sensor_enable\[10\] _3916_ VGND VGND VPWR VPWR _3917_
+ sky130_fd_sc_hd__mux2_1
XFILLER_0_93_548 VGND VGND VPWR VPWR sky130_fd_sc_hd__fill_2
XFILLER_0_93_559 VGND VGND VPWR VPWR sky130_fd_sc_hd__fill_1
X_7766_ _3877_ VGND VGND VPWR VPWR _1266_ sky130_fd_sc_hd__clkbuf_1
X_4978_ _1978_ VGND VGND VPWR VPWR _0377_ sky130_fd_sc_hd__clkbuf_1
XFILLER_0_73_250 VGND VGND VPWR VPWR sky130_fd_sc_hd__decap_3
X_6717_ _2968_ VGND VGND VPWR VPWR _2969_ sky130_fd_sc_hd__clkbuf_4
X_7697_ _3824_ VGND VGND VPWR VPWR _1250_ sky130_fd_sc_hd__clkbuf_1
X_6648_ _2899_ VGND VGND VPWR VPWR _2900_ sky130_fd_sc_hd__buf_8
XFILLER_0_33_169 VGND VGND VPWR VPWR sky130_fd_sc_hd__fill_2
X_8318_ clknet_leaf_37_clk _0407_ VGND VGND VPWR VPWR u_input_buffer.fifo_mem\[43\]\[4\]
+ sky130_fd_sc_hd__dfxtp_1
X_6579_ net532 _1444_ _2842_ VGND VGND VPWR VPWR _2855_ sky130_fd_sc_hd__mux2_1
X_8249_ clknet_leaf_98_clk _0338_ VGND VGND VPWR VPWR u_input_buffer.fifo_mem\[48\]\[15\]
+ sky130_fd_sc_hd__dfxtp_1
XTAP_1232 VGND VPWR sky130_fd_sc_hd__tapvpwrvgnd_1
XTAP_1221 VGND VPWR sky130_fd_sc_hd__tapvpwrvgnd_1
XTAP_1210 VGND VPWR sky130_fd_sc_hd__tapvpwrvgnd_1
XTAP_1265 VGND VPWR sky130_fd_sc_hd__tapvpwrvgnd_1
XTAP_1254 VGND VPWR sky130_fd_sc_hd__tapvpwrvgnd_1
XTAP_1243 VGND VPWR sky130_fd_sc_hd__tapvpwrvgnd_1
XTAP_1298 VGND VPWR sky130_fd_sc_hd__tapvpwrvgnd_1
XTAP_1287 VGND VPWR sky130_fd_sc_hd__tapvpwrvgnd_1
XTAP_1276 VGND VPWR sky130_fd_sc_hd__tapvpwrvgnd_1
XFILLER_0_46_78 VGND VGND VPWR VPWR sky130_fd_sc_hd__decap_6
X_5950_ _1432_ VGND VGND VPWR VPWR _2516_ sky130_fd_sc_hd__buf_4
X_4901_ _1937_ VGND VGND VPWR VPWR _0341_ sky130_fd_sc_hd__clkbuf_1
XFILLER_0_1_69 VGND VGND VPWR VPWR sky130_fd_sc_hd__fill_2
X_5881_ net1015 _2270_ _2460_ VGND VGND VPWR VPWR _2475_ sky130_fd_sc_hd__mux2_1
X_7620_ net30 u_register_bank.threshold_cfg\[26\] _3759_ VGND VGND VPWR VPWR _3766_
+ sky130_fd_sc_hd__mux2_1
X_4832_ _1898_ VGND VGND VPWR VPWR _0311_ sky130_fd_sc_hd__clkbuf_1
X_4763_ net1002 _1714_ _1855_ VGND VGND VPWR VPWR _1861_ sky130_fd_sc_hd__mux2_1
X_7551_ net30 u_register_bank.window_cfg\[26\] _3722_ VGND VGND VPWR VPWR _3729_ sky130_fd_sc_hd__mux2_1
XFILLER_0_55_250 VGND VGND VPWR VPWR sky130_fd_sc_hd__fill_1
X_6502_ _2814_ VGND VGND VPWR VPWR _1065_ sky130_fd_sc_hd__clkbuf_1
X_7482_ _3690_ VGND VGND VPWR VPWR _1169_ sky130_fd_sc_hd__clkbuf_1
X_4694_ _1823_ VGND VGND VPWR VPWR _0248_ sky130_fd_sc_hd__clkbuf_1
XFILLER_0_113_322 VGND VGND VPWR VPWR sky130_fd_sc_hd__fill_2
X_6433_ net848 _1414_ _2771_ VGND VGND VPWR VPWR _2778_ sky130_fd_sc_hd__mux2_1
XFILLER_0_70_253 VGND VGND VPWR VPWR sky130_fd_sc_hd__fill_2
X_9221_ net178 _1308_ net207 VGND VGND VPWR VPWR u_register_bank.sensor_enable\[22\]
+ sky130_fd_sc_hd__dfrtp_1
XFILLER_0_15_169 VGND VGND VPWR VPWR sky130_fd_sc_hd__fill_2
XFILLER_0_102_83 VGND VGND VPWR VPWR sky130_fd_sc_hd__fill_1
XFILLER_0_3_553 VGND VGND VPWR VPWR sky130_fd_sc_hd__decap_6
X_6364_ _2741_ VGND VGND VPWR VPWR _1000_ sky130_fd_sc_hd__clkbuf_1
X_9152_ net175 _1240_ VGND VGND VPWR VPWR net136 sky130_fd_sc_hd__dfxtp_1
XFILLER_0_3_597 VPWR VGND VPWR VGND sky130_ef_sc_hd__decap_12
X_6295_ _2704_ VGND VGND VPWR VPWR _0968_ sky130_fd_sc_hd__clkbuf_1
X_8103_ clknet_leaf_109_clk _0192_ VGND VGND VPWR VPWR u_input_buffer.fifo_mem\[57\]\[13\]
+ sky130_fd_sc_hd__dfxtp_1
X_9083_ clknet_leaf_90_clk _1171_ VGND VGND VPWR VPWR u_input_buffer.fifo_mem\[63\]\[13\]
+ sky130_fd_sc_hd__dfxtp_1
X_5315_ net509 _2016_ _2150_ VGND VGND VPWR VPWR _2165_ sky130_fd_sc_hd__mux2_1
XFILLER_0_87_96 VGND VGND VPWR VPWR sky130_fd_sc_hd__fill_1
XFILLER_0_11_386 VGND VGND VPWR VPWR sky130_fd_sc_hd__decap_6
X_5246_ _2128_ VGND VGND VPWR VPWR _0495_ sky130_fd_sc_hd__clkbuf_1
X_8034_ clknet_leaf_6_clk _0123_ VGND VGND VPWR VPWR u_input_buffer.fifo_mem\[61\]\[8\]
+ sky130_fd_sc_hd__dfxtp_1
Xhold27 u_sample_counter.sample_count\[4\] VGND VGND VPWR VPWR net239 sky130_fd_sc_hd__dlygate4sd3_1
Xhold38 u_input_buffer.fifo_mem\[0\]\[8\] VGND VGND VPWR VPWR net250 sky130_fd_sc_hd__dlygate4sd3_1
Xhold16 u_sample_counter.sample_count\[26\] VGND VGND VPWR VPWR net228 sky130_fd_sc_hd__dlygate4sd3_1
Xhold49 u_input_buffer.wr_ptr\[0\] VGND VGND VPWR VPWR net261 sky130_fd_sc_hd__dlygate4sd3_1
X_5177_ _2091_ VGND VGND VPWR VPWR _0463_ sky130_fd_sc_hd__clkbuf_1
X_4128_ _1444_ VGND VGND VPWR VPWR _1445_ sky130_fd_sc_hd__buf_2
X_4059_ u_sensor_interface.sensor_array\[0\]\[1\] u_sensor_interface.sensor_array\[1\]\[1\]
+ _1318_ VGND VGND VPWR VPWR _1386_ sky130_fd_sc_hd__mux2_1
X_8936_ clknet_leaf_103_clk _1025_ VGND VGND VPWR VPWR u_input_buffer.fifo_mem\[5\]\[14\]
+ sky130_fd_sc_hd__dfxtp_1
X_8867_ clknet_leaf_20_clk _0956_ VGND VGND VPWR VPWR u_input_buffer.fifo_mem\[9\]\[9\]
+ sky130_fd_sc_hd__dfxtp_1
X_7818_ net34 u_register_bank.sensor_enable\[2\] _3905_ VGND VGND VPWR VPWR _3908_
+ sky130_fd_sc_hd__mux2_1
X_8798_ clknet_leaf_111_clk _0887_ VGND VGND VPWR VPWR u_input_buffer.fifo_mem\[13\]\[4\]
+ sky130_fd_sc_hd__dfxtp_1
XFILLER_0_93_378 VGND VGND VPWR VPWR sky130_fd_sc_hd__decap_4
X_7749_ _3864_ net130 _3852_ VGND VGND VPWR VPWR _3865_ sky130_fd_sc_hd__mux2_1
XFILLER_0_74_592 VGND VGND VPWR VPWR sky130_fd_sc_hd__decap_8
XFILLER_0_19_486 VGND VGND VPWR VPWR sky130_fd_sc_hd__fill_2
XFILLER_0_34_445 VGND VGND VPWR VPWR sky130_fd_sc_hd__decap_4
XFILLER_0_34_489 VPWR VGND VPWR VGND sky130_ef_sc_hd__decap_12
XFILLER_0_107_39 VPWR VGND VPWR VGND sky130_ef_sc_hd__decap_12
XFILLER_0_16_15 VPWR VGND VPWR VGND sky130_ef_sc_hd__decap_12
XFILLER_0_97_673 VGND VGND VPWR VPWR sky130_fd_sc_hd__fill_1
XTAP_1040 VGND VPWR sky130_fd_sc_hd__tapvpwrvgnd_1
XTAP_1073 VGND VPWR sky130_fd_sc_hd__tapvpwrvgnd_1
XTAP_1062 VGND VPWR sky130_fd_sc_hd__tapvpwrvgnd_1
XTAP_1051 VGND VPWR sky130_fd_sc_hd__tapvpwrvgnd_1
XTAP_1095 VGND VPWR sky130_fd_sc_hd__tapvpwrvgnd_1
XTAP_1084 VGND VPWR sky130_fd_sc_hd__tapvpwrvgnd_1
XFILLER_0_108_683 VGND VGND VPWR VPWR sky130_fd_sc_hd__decap_3
Xhold508 u_input_buffer.fifo_mem\[44\]\[1\] VGND VGND VPWR VPWR net720 sky130_fd_sc_hd__dlygate4sd3_1
XFILLER_0_12_117 VGND VGND VPWR VPWR sky130_fd_sc_hd__decap_4
XFILLER_0_0_501 VGND VGND VPWR VPWR sky130_fd_sc_hd__decap_3
Xhold519 u_input_buffer.fifo_mem\[57\]\[6\] VGND VGND VPWR VPWR net731 sky130_fd_sc_hd__dlygate4sd3_1
X_6080_ _2589_ VGND VGND VPWR VPWR _0868_ sky130_fd_sc_hd__clkbuf_1
X_5100_ net438 _2006_ _2042_ VGND VGND VPWR VPWR _2051_ sky130_fd_sc_hd__mux2_1
XFILLER_0_0_589 VGND VGND VPWR VPWR sky130_fd_sc_hd__fill_2
XTAP_813 VGND VPWR sky130_fd_sc_hd__tapvpwrvgnd_1
XTAP_802 VGND VPWR sky130_fd_sc_hd__tapvpwrvgnd_1
XTAP_824 VGND VPWR sky130_fd_sc_hd__tapvpwrvgnd_1
XTAP_835 VGND VPWR sky130_fd_sc_hd__tapvpwrvgnd_1
X_5031_ _2011_ VGND VGND VPWR VPWR _0397_ sky130_fd_sc_hd__clkbuf_1
XTAP_846 VGND VPWR sky130_fd_sc_hd__tapvpwrvgnd_1
XTAP_857 VGND VPWR sky130_fd_sc_hd__tapvpwrvgnd_1
XTAP_868 VGND VPWR sky130_fd_sc_hd__tapvpwrvgnd_1
XTAP_879 VGND VPWR sky130_fd_sc_hd__tapvpwrvgnd_1
X_8721_ clknet_leaf_30_clk _0810_ VGND VGND VPWR VPWR u_input_buffer.fifo_mem\[18\]\[7\]
+ sky130_fd_sc_hd__dfxtp_1
X_6982_ _3223_ _3225_ _3227_ _3229_ VGND VGND VPWR VPWR _3230_ sky130_fd_sc_hd__or4_1
X_5933_ net1151 _2504_ _2498_ VGND VGND VPWR VPWR _2505_ sky130_fd_sc_hd__mux2_1
X_5864_ _2466_ VGND VGND VPWR VPWR _0775_ sky130_fd_sc_hd__clkbuf_1
X_8652_ clknet_leaf_54_clk _0741_ VGND VGND VPWR VPWR u_input_buffer.fifo_mem\[22\]\[2\]
+ sky130_fd_sc_hd__dfxtp_1
XFILLER_0_8_601 VPWR VGND VPWR VGND sky130_ef_sc_hd__decap_12
XFILLER_0_8_645 VPWR VGND VPWR VGND sky130_ef_sc_hd__decap_12
X_7603_ net21 u_register_bank.threshold_cfg\[18\] _3748_ VGND VGND VPWR VPWR _3757_
+ sky130_fd_sc_hd__mux2_1
X_8583_ clknet_leaf_92_clk _0672_ VGND VGND VPWR VPWR u_input_buffer.fifo_mem\[27\]\[13\]
+ sky130_fd_sc_hd__dfxtp_1
X_4815_ _1888_ VGND VGND VPWR VPWR _0304_ sky130_fd_sc_hd__clkbuf_1
X_5795_ net1075 _2252_ _2425_ VGND VGND VPWR VPWR _2430_ sky130_fd_sc_hd__mux2_1
X_7534_ net21 u_register_bank.window_cfg\[18\] _3711_ VGND VGND VPWR VPWR _3720_ sky130_fd_sc_hd__mux2_1
X_4746_ net367 _1732_ _1835_ VGND VGND VPWR VPWR _1851_ sky130_fd_sc_hd__mux2_1
X_7465_ net463 _1396_ _3678_ VGND VGND VPWR VPWR _3682_ sky130_fd_sc_hd__mux2_1
X_4677_ _1813_ VGND VGND VPWR VPWR _0241_ sky130_fd_sc_hd__clkbuf_1
X_9204_ net181 _1291_ net210 VGND VGND VPWR VPWR u_register_bank.sensor_enable\[5\]
+ sky130_fd_sc_hd__dfrtp_1
X_6416_ _2768_ VGND VGND VPWR VPWR _1025_ sky130_fd_sc_hd__clkbuf_1
X_7396_ u_input_buffer.fifo_mem\[34\]\[15\] _2965_ _2968_ u_input_buffer.fifo_mem\[48\]\[15\]
+ _3632_ VGND VGND VPWR VPWR _3633_ sky130_fd_sc_hd__a221o_1
X_9135_ net168 _1223_ net201 VGND VGND VPWR VPWR u_register_bank.threshold_cfg\[17\]
+ sky130_fd_sc_hd__dfrtp_1
X_6347_ net309 _2526_ _2716_ VGND VGND VPWR VPWR _2732_ sky130_fd_sc_hd__mux2_1
Xinput106 sensor_data_in[6] VGND VGND VPWR VPWR net106 sky130_fd_sc_hd__clkbuf_1
X_9066_ clknet_leaf_109_clk _1155_ VGND VGND VPWR VPWR u_sensor_interface.sensor_array\[3\]\[13\]
+ sky130_fd_sc_hd__dfxtp_1
X_6278_ _1630_ net946 _2679_ VGND VGND VPWR VPWR _2695_ sky130_fd_sc_hd__mux2_1
X_8017_ clknet_leaf_43_clk _0106_ VGND VGND VPWR VPWR u_input_buffer.fifo_mem\[62\]\[7\]
+ sky130_fd_sc_hd__dfxtp_1
X_5229_ net1098 _1998_ _2115_ VGND VGND VPWR VPWR _2120_ sky130_fd_sc_hd__mux2_1
XFILLER_0_98_404 VGND VGND VPWR VPWR sky130_fd_sc_hd__decap_4
XFILLER_0_98_437 VGND VGND VPWR VPWR sky130_fd_sc_hd__fill_2
X_8919_ clknet_leaf_76_clk _1008_ VGND VGND VPWR VPWR u_input_buffer.fifo_mem\[6\]\[13\]
+ sky130_fd_sc_hd__dfxtp_1
XFILLER_0_94_643 VGND VGND VPWR VPWR sky130_fd_sc_hd__fill_1
XPHY_134 VGND VGND VPWR VPWR sky130_fd_sc_hd__decap_3
XPHY_123 VGND VGND VPWR VPWR sky130_fd_sc_hd__decap_3
XPHY_112 VGND VGND VPWR VPWR sky130_fd_sc_hd__decap_3
XPHY_101 VGND VGND VPWR VPWR sky130_fd_sc_hd__decap_3
XFILLER_0_109_425 VGND VGND VPWR VPWR sky130_fd_sc_hd__decap_6
XPHY_167 VGND VGND VPWR VPWR sky130_fd_sc_hd__decap_3
XPHY_156 VGND VGND VPWR VPWR sky130_fd_sc_hd__decap_3
XPHY_145 VGND VGND VPWR VPWR sky130_fd_sc_hd__decap_3
XPHY_189 VGND VGND VPWR VPWR sky130_fd_sc_hd__decap_3
XPHY_178 VGND VGND VPWR VPWR sky130_fd_sc_hd__decap_3
XFILLER_0_81_337 VGND VGND VPWR VPWR sky130_fd_sc_hd__decap_3
XFILLER_0_34_231 VGND VGND VPWR VPWR sky130_fd_sc_hd__decap_3
XFILLER_0_105_653 VGND VGND VPWR VPWR sky130_fd_sc_hd__fill_1
XPHY_3 VGND VGND VPWR VPWR sky130_fd_sc_hd__decap_3
XFILLER_0_69_194 VGND VGND VPWR VPWR sky130_fd_sc_hd__decap_3
XFILLER_0_57_334 VGND VGND VPWR VPWR sky130_fd_sc_hd__fill_2
XFILLER_0_85_665 VGND VGND VPWR VPWR sky130_fd_sc_hd__decap_6
XFILLER_0_84_175 VGND VGND VPWR VPWR sky130_fd_sc_hd__decap_4
X_4600_ _1770_ VGND VGND VPWR VPWR _0207_ sky130_fd_sc_hd__clkbuf_1
XFILLER_0_111_3 VPWR VGND VPWR VGND sky130_ef_sc_hd__decap_12
XFILLER_0_5_615 VGND VGND VPWR VPWR sky130_fd_sc_hd__fill_1
X_5580_ _2314_ VGND VGND VPWR VPWR _2315_ sky130_fd_sc_hd__buf_4
XFILLER_0_87_9 VGND VGND VPWR VPWR sky130_fd_sc_hd__fill_2
X_4531_ _1462_ VGND VGND VPWR VPWR _1732_ sky130_fd_sc_hd__clkbuf_4
XFILLER_0_53_595 VGND VGND VPWR VPWR sky130_fd_sc_hd__decap_6
X_4462_ _1688_ VGND VGND VPWR VPWR _0151_ sky130_fd_sc_hd__clkbuf_1
X_7250_ u_input_buffer.fifo_mem\[27\]\[11\] _3012_ _3014_ u_input_buffer.fifo_mem\[59\]\[11\]
+ _3490_ VGND VGND VPWR VPWR _3491_ sky130_fd_sc_hd__a221o_1
Xhold316 u_input_buffer.fifo_mem\[34\]\[11\] VGND VGND VPWR VPWR net528 sky130_fd_sc_hd__dlygate4sd3_1
Xhold305 u_input_buffer.fifo_mem\[18\]\[13\] VGND VGND VPWR VPWR net517 sky130_fd_sc_hd__dlygate4sd3_1
Xhold349 u_input_buffer.fifo_mem\[4\]\[1\] VGND VGND VPWR VPWR net561 sky130_fd_sc_hd__dlygate4sd3_1
XFILLER_0_68_21 VGND VGND VPWR VPWR sky130_fd_sc_hd__decap_6
Xhold338 u_input_buffer.fifo_mem\[46\]\[8\] VGND VGND VPWR VPWR net550 sky130_fd_sc_hd__dlygate4sd3_1
X_6201_ _2654_ VGND VGND VPWR VPWR _0924_ sky130_fd_sc_hd__clkbuf_1
XFILLER_0_7_57 VGND VGND VPWR VPWR sky130_fd_sc_hd__fill_2
Xhold327 u_input_buffer.fifo_mem\[4\]\[14\] VGND VGND VPWR VPWR net539 sky130_fd_sc_hd__dlygate4sd3_1
X_7181_ u_input_buffer.fifo_mem\[10\]\[9\] _3056_ _3058_ u_input_buffer.fifo_mem\[44\]\[9\]
+ _3423_ VGND VGND VPWR VPWR _3424_ sky130_fd_sc_hd__a221o_1
XFILLER_0_21_492 VGND VGND VPWR VPWR sky130_fd_sc_hd__fill_2
X_4393_ _1421_ net1249 _1641_ VGND VGND VPWR VPWR _1649_ sky130_fd_sc_hd__mux2_1
XFILLER_0_110_166 VGND VGND VPWR VPWR sky130_fd_sc_hd__decap_3
X_6132_ _2617_ VGND VGND VPWR VPWR _0892_ sky130_fd_sc_hd__clkbuf_1
XTAP_610 VGND VPWR sky130_fd_sc_hd__tapvpwrvgnd_1
XTAP_621 VGND VPWR sky130_fd_sc_hd__tapvpwrvgnd_1
XTAP_632 VGND VPWR sky130_fd_sc_hd__tapvpwrvgnd_1
XTAP_643 VGND VPWR sky130_fd_sc_hd__tapvpwrvgnd_1
X_6063_ net1228 _2518_ _2568_ VGND VGND VPWR VPWR _2580_ sky130_fd_sc_hd__mux2_1
Xhold1005 u_input_buffer.fifo_mem\[17\]\[5\] VGND VGND VPWR VPWR net1217 sky130_fd_sc_hd__dlygate4sd3_1
XTAP_654 VGND VPWR sky130_fd_sc_hd__tapvpwrvgnd_1
XTAP_665 VGND VPWR sky130_fd_sc_hd__tapvpwrvgnd_1
XTAP_676 VGND VPWR sky130_fd_sc_hd__tapvpwrvgnd_1
X_5014_ _1408_ VGND VGND VPWR VPWR _2000_ sky130_fd_sc_hd__buf_4
XFILLER_0_84_53 VGND VGND VPWR VPWR sky130_fd_sc_hd__decap_6
Xhold1027 u_input_buffer.fifo_mem\[41\]\[6\] VGND VGND VPWR VPWR net1239 sky130_fd_sc_hd__dlygate4sd3_1
Xhold1016 u_input_buffer.fifo_mem\[15\]\[10\] VGND VGND VPWR VPWR net1228 sky130_fd_sc_hd__dlygate4sd3_1
Xhold1049 u_input_buffer.fifo_mem\[37\]\[11\] VGND VGND VPWR VPWR net1261 sky130_fd_sc_hd__dlygate4sd3_1
XTAP_687 VGND VPWR sky130_fd_sc_hd__tapvpwrvgnd_1
XTAP_698 VGND VPWR sky130_fd_sc_hd__tapvpwrvgnd_1
Xhold1038 u_input_buffer.fifo_mem\[21\]\[5\] VGND VGND VPWR VPWR net1250 sky130_fd_sc_hd__dlygate4sd3_1
XFILLER_0_16_3 VPWR VGND VPWR VGND sky130_ef_sc_hd__decap_12
X_6965_ u_input_buffer.fifo_mem\[36\]\[4\] _2951_ _2955_ u_input_buffer.fifo_mem\[35\]\[4\]
+ _3212_ VGND VGND VPWR VPWR _3213_ sky130_fd_sc_hd__a221o_1
X_8704_ clknet_leaf_67_clk _0793_ VGND VGND VPWR VPWR u_input_buffer.fifo_mem\[19\]\[6\]
+ sky130_fd_sc_hd__dfxtp_1
X_5916_ _2493_ VGND VGND VPWR VPWR _0800_ sky130_fd_sc_hd__clkbuf_1
X_8635_ clknet_leaf_49_clk _0724_ VGND VGND VPWR VPWR u_input_buffer.fifo_mem\[23\]\[1\]
+ sky130_fd_sc_hd__dfxtp_1
X_6896_ u_input_buffer.fifo_mem\[47\]\[2\] _2880_ _3007_ _3009_ u_input_buffer.fifo_mem\[24\]\[2\]
+ VGND VGND VPWR VPWR _3146_ sky130_fd_sc_hd__a32o_1
X_5847_ _1628_ net1296 _2442_ VGND VGND VPWR VPWR _2457_ sky130_fd_sc_hd__mux2_1
XFILLER_0_29_592 VGND VGND VPWR VPWR sky130_fd_sc_hd__decap_4
XFILLER_0_8_497 VPWR VGND VPWR VGND sky130_ef_sc_hd__decap_12
XFILLER_0_16_242 VGND VGND VPWR VPWR sky130_fd_sc_hd__fill_1
X_5778_ _2420_ VGND VGND VPWR VPWR _0735_ sky130_fd_sc_hd__clkbuf_1
X_8566_ clknet_leaf_92_clk _0655_ VGND VGND VPWR VPWR u_input_buffer.fifo_mem\[28\]\[12\]
+ sky130_fd_sc_hd__dfxtp_1
X_4729_ _1842_ VGND VGND VPWR VPWR _0264_ sky130_fd_sc_hd__clkbuf_1
X_8497_ clknet_leaf_29_clk _0586_ VGND VGND VPWR VPWR u_input_buffer.fifo_mem\[32\]\[7\]
+ sky130_fd_sc_hd__dfxtp_1
XFILLER_0_16_253 VGND VGND VPWR VPWR sky130_fd_sc_hd__fill_1
X_7517_ _3699_ VGND VGND VPWR VPWR _3711_ sky130_fd_sc_hd__buf_4
XFILLER_0_44_573 VGND VGND VPWR VPWR sky130_fd_sc_hd__decap_4
X_7448_ _3672_ VGND VGND VPWR VPWR _1153_ sky130_fd_sc_hd__clkbuf_1
Xclkbuf_leaf_110_clk clknet_3_0__leaf_clk VGND VGND VPWR VPWR clknet_leaf_110_clk
+ sky130_fd_sc_hd__clkbuf_16
XFILLER_0_4_681 VGND VGND VPWR VPWR sky130_fd_sc_hd__fill_1
Xhold850 u_input_buffer.fifo_mem\[25\]\[11\] VGND VGND VPWR VPWR net1062 sky130_fd_sc_hd__dlygate4sd3_1
X_7379_ u_input_buffer.fifo_mem\[54\]\[14\] _3077_ _3079_ u_input_buffer.fifo_mem\[46\]\[14\]
+ VGND VGND VPWR VPWR _3617_ sky130_fd_sc_hd__a22o_1
Xhold872 u_input_buffer.fifo_mem\[17\]\[6\] VGND VGND VPWR VPWR net1084 sky130_fd_sc_hd__dlygate4sd3_1
Xhold861 u_input_buffer.fifo_mem\[43\]\[12\] VGND VGND VPWR VPWR net1073 sky130_fd_sc_hd__dlygate4sd3_1
X_9118_ net177 _1206_ net209 VGND VGND VPWR VPWR u_analytics_engine.threshold\[0\]
+ sky130_fd_sc_hd__dfrtp_1
Xhold894 u_input_buffer.fifo_mem\[41\]\[0\] VGND VGND VPWR VPWR net1106 sky130_fd_sc_hd__dlygate4sd3_1
XFILLER_0_7_6 VPWR VGND VPWR VGND sky130_ef_sc_hd__decap_12
Xhold883 u_input_buffer.fifo_mem\[25\]\[8\] VGND VGND VPWR VPWR net1095 sky130_fd_sc_hd__dlygate4sd3_1
X_9049_ clknet_leaf_74_clk _1138_ VGND VGND VPWR VPWR u_analytics_engine.data_in\[12\]
+ sky130_fd_sc_hd__dfxtp_2
XFILLER_0_39_334 VGND VGND VPWR VPWR sky130_fd_sc_hd__fill_2
XFILLER_0_104_29 VPWR VGND VPWR VGND sky130_ef_sc_hd__decap_12
XFILLER_0_94_462 VGND VGND VPWR VPWR sky130_fd_sc_hd__fill_1
XFILLER_0_94_440 VGND VGND VPWR VPWR sky130_fd_sc_hd__fill_2
XFILLER_0_13_27 VPWR VGND VPWR VGND sky130_ef_sc_hd__decap_12
XFILLER_0_66_197 VGND VGND VPWR VPWR sky130_fd_sc_hd__fill_2
Xclkbuf_leaf_101_clk clknet_3_0__leaf_clk VGND VGND VPWR VPWR clknet_leaf_101_clk
+ sky130_fd_sc_hd__clkbuf_16
XFILLER_0_50_587 VGND VGND VPWR VPWR sky130_fd_sc_hd__fill_1
XFILLER_0_89_212 VGND VGND VPWR VPWR sky130_fd_sc_hd__decap_4
XFILLER_0_54_67 VGND VGND VPWR VPWR sky130_fd_sc_hd__fill_1
XFILLER_0_58_643 VGND VGND VPWR VPWR sky130_fd_sc_hd__fill_1
X_6750_ _2872_ _2873_ _2876_ _2877_ VGND VGND VPWR VPWR _3002_ sky130_fd_sc_hd__or4b_4
X_3962_ u_sensor_interface.sensor_array\[2\]\[7\] net78 _1323_ VGND VGND VPWR VPWR
+ _1331_ sky130_fd_sc_hd__mux2_1
XFILLER_0_58_654 VGND VGND VPWR VPWR sky130_fd_sc_hd__fill_2
X_5701_ _2379_ VGND VGND VPWR VPWR _0699_ sky130_fd_sc_hd__clkbuf_1
XFILLER_0_85_473 VGND VGND VPWR VPWR sky130_fd_sc_hd__fill_1
XFILLER_0_73_624 VGND VGND VPWR VPWR sky130_fd_sc_hd__decap_4
XFILLER_0_70_66 VGND VGND VPWR VPWR sky130_fd_sc_hd__fill_1
X_6681_ _2900_ _2907_ VGND VGND VPWR VPWR _2933_ sky130_fd_sc_hd__nor2_4
XFILLER_0_115_203 VPWR VGND VPWR VGND sky130_ef_sc_hd__decap_12
X_5632_ net800 _2260_ _2334_ VGND VGND VPWR VPWR _2343_ sky130_fd_sc_hd__mux2_1
X_8420_ clknet_leaf_106_clk _0509_ VGND VGND VPWR VPWR u_input_buffer.fifo_mem\[37\]\[10\]
+ sky130_fd_sc_hd__dfxtp_1
X_8351_ clknet_leaf_20_clk _0440_ VGND VGND VPWR VPWR u_input_buffer.fifo_mem\[41\]\[5\]
+ sky130_fd_sc_hd__dfxtp_1
X_5563_ _1427_ net880 _2297_ VGND VGND VPWR VPWR _2306_ sky130_fd_sc_hd__mux2_1
XFILLER_0_85_6 VPWR VGND VPWR VGND sky130_ef_sc_hd__decap_12
X_4514_ net638 _1720_ _1704_ VGND VGND VPWR VPWR _1721_ sky130_fd_sc_hd__mux2_1
X_7302_ u_input_buffer.fifo_mem\[63\]\[12\] _2886_ _3075_ u_input_buffer.fifo_mem\[55\]\[12\]
+ _3541_ VGND VGND VPWR VPWR _3542_ sky130_fd_sc_hd__a221o_1
Xhold102 u_input_buffer.fifo_mem\[36\]\[2\] VGND VGND VPWR VPWR net314 sky130_fd_sc_hd__dlygate4sd3_1
Xhold135 u_input_buffer.fifo_mem\[62\]\[4\] VGND VGND VPWR VPWR net347 sky130_fd_sc_hd__dlygate4sd3_1
X_8282_ clknet_leaf_22_clk _0371_ VGND VGND VPWR VPWR u_input_buffer.fifo_mem\[45\]\[0\]
+ sky130_fd_sc_hd__dfxtp_1
X_5494_ _1444_ VGND VGND VPWR VPWR _2266_ sky130_fd_sc_hd__clkbuf_4
Xhold113 u_input_buffer.fifo_mem\[39\]\[11\] VGND VGND VPWR VPWR net325 sky130_fd_sc_hd__dlygate4sd3_1
Xhold124 u_input_buffer.fifo_mem\[34\]\[10\] VGND VGND VPWR VPWR net336 sky130_fd_sc_hd__dlygate4sd3_1
Xhold146 u_sensor_interface.sensor_array\[0\]\[0\] VGND VGND VPWR VPWR net358 sky130_fd_sc_hd__dlygate4sd3_1
XFILLER_0_110_83 VGND VGND VPWR VPWR sky130_fd_sc_hd__fill_1
Xhold168 u_input_buffer.fifo_mem\[36\]\[0\] VGND VGND VPWR VPWR net380 sky130_fd_sc_hd__dlygate4sd3_1
XFILLER_0_13_278 VGND VGND VPWR VPWR sky130_fd_sc_hd__fill_2
X_7233_ u_input_buffer.fifo_mem\[53\]\[11\] _2933_ _2935_ u_input_buffer.fifo_mem\[57\]\[11\]
+ VGND VGND VPWR VPWR _3474_ sky130_fd_sc_hd__a22o_1
X_4445_ net1076 _1632_ _1660_ VGND VGND VPWR VPWR _1677_ sky130_fd_sc_hd__mux2_1
Xhold157 u_input_buffer.fifo_mem\[31\]\[10\] VGND VGND VPWR VPWR net369 sky130_fd_sc_hd__dlygate4sd3_1
X_7164_ u_input_buffer.fifo_mem\[12\]\[9\] _2980_ _2982_ u_input_buffer.fifo_mem\[18\]\[9\]
+ _3406_ VGND VGND VPWR VPWR _3407_ sky130_fd_sc_hd__a221o_1
XFILLER_0_1_673 VGND VGND VPWR VPWR sky130_fd_sc_hd__decap_6
X_4376_ _1635_ _1638_ VGND VGND VPWR VPWR _1639_ sky130_fd_sc_hd__nor2_4
Xhold179 u_input_buffer.fifo_mem\[39\]\[12\] VGND VGND VPWR VPWR net391 sky130_fd_sc_hd__dlygate4sd3_1
XTAP_440 VGND VPWR sky130_fd_sc_hd__tapvpwrvgnd_1
XTAP_451 VGND VPWR sky130_fd_sc_hd__tapvpwrvgnd_1
X_6115_ _1604_ net1063 _2607_ VGND VGND VPWR VPWR _2609_ sky130_fd_sc_hd__mux2_1
X_7095_ u_input_buffer.fifo_mem\[30\]\[7\] _3029_ _3031_ u_input_buffer.fifo_mem\[58\]\[7\]
+ VGND VGND VPWR VPWR _3340_ sky130_fd_sc_hd__a22o_1
XTAP_462 VGND VPWR sky130_fd_sc_hd__tapvpwrvgnd_1
XTAP_484 VGND VPWR sky130_fd_sc_hd__tapvpwrvgnd_1
XTAP_473 VGND VPWR sky130_fd_sc_hd__tapvpwrvgnd_1
X_6046_ _2571_ VGND VGND VPWR VPWR _0852_ sky130_fd_sc_hd__clkbuf_1
XTAP_495 VGND VPWR sky130_fd_sc_hd__tapvpwrvgnd_1
XTAP_1606 VGND VPWR sky130_fd_sc_hd__tapvpwrvgnd_1
XTAP_1639 VGND VPWR sky130_fd_sc_hd__tapvpwrvgnd_1
XTAP_1628 VGND VPWR sky130_fd_sc_hd__tapvpwrvgnd_1
XTAP_1617 VGND VPWR sky130_fd_sc_hd__tapvpwrvgnd_1
X_7997_ clknet_leaf_63_clk _0086_ net195 VGND VGND VPWR VPWR u_sample_counter.sample_count\[20\]
+ sky130_fd_sc_hd__dfrtp_1
X_6948_ u_input_buffer.fifo_mem\[3\]\[3\] _3070_ _3072_ u_input_buffer.fifo_mem\[60\]\[3\]
+ VGND VGND VPWR VPWR _3197_ sky130_fd_sc_hd__a22o_1
X_6879_ u_input_buffer.fifo_mem\[33\]\[2\] _2898_ _2904_ u_input_buffer.fifo_mem\[61\]\[2\]
+ _3128_ VGND VGND VPWR VPWR _3129_ sky130_fd_sc_hd__a221o_1
X_8618_ clknet_leaf_60_clk _0707_ VGND VGND VPWR VPWR u_input_buffer.fifo_mem\[24\]\[0\]
+ sky130_fd_sc_hd__dfxtp_1
XFILLER_0_64_668 VGND VGND VPWR VPWR sky130_fd_sc_hd__fill_2
XFILLER_0_63_123 VGND VGND VPWR VPWR sky130_fd_sc_hd__decap_4
X_8549_ clknet_leaf_108_clk _0638_ VGND VGND VPWR VPWR u_input_buffer.fifo_mem\[29\]\[11\]
+ sky130_fd_sc_hd__dfxtp_1
XFILLER_0_51_318 VGND VGND VPWR VPWR sky130_fd_sc_hd__fill_2
XFILLER_0_32_587 VGND VGND VPWR VPWR sky130_fd_sc_hd__fill_1
Xhold680 u_input_buffer.fifo_mem\[8\]\[12\] VGND VGND VPWR VPWR net892 sky130_fd_sc_hd__dlygate4sd3_1
Xhold691 u_input_buffer.fifo_mem\[40\]\[10\] VGND VGND VPWR VPWR net903 sky130_fd_sc_hd__dlygate4sd3_1
XFILLER_0_99_521 VGND VGND VPWR VPWR sky130_fd_sc_hd__decap_6
XFILLER_0_67_473 VPWR VGND VPWR VGND sky130_ef_sc_hd__decap_12
XFILLER_0_27_315 VGND VGND VPWR VPWR sky130_fd_sc_hd__fill_1
XFILLER_0_70_638 VGND VGND VPWR VPWR sky130_fd_sc_hd__fill_1
XFILLER_0_112_217 VPWR VGND VPWR VGND sky130_ef_sc_hd__decap_12
XFILLER_0_50_373 VGND VGND VPWR VPWR sky130_fd_sc_hd__fill_1
X_4230_ u_sample_counter.sample_count\[19\] _1507_ _1512_ _1518_ VGND VGND VPWR VPWR
+ _1519_ sky130_fd_sc_hd__nand4_4
X_4161_ _1473_ VGND VGND VPWR VPWR _0065_ sky130_fd_sc_hd__clkbuf_1
X_4092_ u_input_buffer.data_in\[6\] VGND VGND VPWR VPWR _1414_ sky130_fd_sc_hd__clkbuf_4
X_7920_ clknet_leaf_58_clk _0010_ VGND VGND VPWR VPWR u_sensor_interface.sensor_array\[2\]\[8\]
+ sky130_fd_sc_hd__dfxtp_2
X_7851_ net21 u_register_bank.sensor_enable\[18\] _3916_ VGND VGND VPWR VPWR _3925_
+ sky130_fd_sc_hd__mux2_1
X_6802_ u_input_buffer.fifo_mem\[23\]\[0\] _3046_ _3048_ u_input_buffer.fifo_mem\[20\]\[0\]
+ _3053_ VGND VGND VPWR VPWR _3054_ sky130_fd_sc_hd__a221o_1
XFILLER_0_81_54 VGND VGND VPWR VPWR sky130_fd_sc_hd__fill_2
X_7782_ _3888_ VGND VGND VPWR VPWR _1271_ sky130_fd_sc_hd__clkbuf_1
X_4994_ _1986_ VGND VGND VPWR VPWR _0385_ sky130_fd_sc_hd__clkbuf_1
XFILLER_0_105_94 VGND VGND VPWR VPWR sky130_fd_sc_hd__fill_1
XFILLER_0_73_421 VGND VGND VPWR VPWR sky130_fd_sc_hd__fill_1
X_3945_ _1321_ VGND VGND VPWR VPWR _0001_ sky130_fd_sc_hd__clkbuf_1
X_6733_ _2896_ _2967_ VGND VGND VPWR VPWR _2985_ sky130_fd_sc_hd__nor2_2
XFILLER_0_85_281 VGND VGND VPWR VPWR sky130_fd_sc_hd__decap_8
X_6664_ _2882_ _2885_ VGND VGND VPWR VPWR _2916_ sky130_fd_sc_hd__and2b_1
X_8403_ clknet_leaf_69_clk _0492_ VGND VGND VPWR VPWR u_input_buffer.fifo_mem\[38\]\[9\]
+ sky130_fd_sc_hd__dfxtp_1
XFILLER_0_60_104 VGND VGND VPWR VPWR sky130_fd_sc_hd__fill_2
X_5615_ _2333_ VGND VGND VPWR VPWR _2334_ sky130_fd_sc_hd__clkbuf_4
XFILLER_0_33_318 VGND VGND VPWR VPWR sky130_fd_sc_hd__fill_1
XFILLER_0_45_156 VGND VGND VPWR VPWR sky130_fd_sc_hd__fill_2
XFILLER_0_83_3 VPWR VGND VPWR VGND sky130_ef_sc_hd__decap_12
X_6595_ u_input_buffer.count\[2\] VGND VGND VPWR VPWR _2864_ sky130_fd_sc_hd__inv_2
XFILLER_0_103_239 VGND VGND VPWR VPWR sky130_fd_sc_hd__fill_2
X_8334_ clknet_leaf_29_clk _0423_ VGND VGND VPWR VPWR u_input_buffer.fifo_mem\[42\]\[4\]
+ sky130_fd_sc_hd__dfxtp_1
X_5546_ _2296_ VGND VGND VPWR VPWR _2297_ sky130_fd_sc_hd__clkbuf_4
X_5477_ net1090 _2254_ _2244_ VGND VGND VPWR VPWR _2255_ sky130_fd_sc_hd__mux2_1
X_8265_ clknet_leaf_74_clk _0354_ VGND VGND VPWR VPWR u_input_buffer.fifo_mem\[47\]\[15\]
+ sky130_fd_sc_hd__dfxtp_1
X_4428_ _1668_ VGND VGND VPWR VPWR _0137_ sky130_fd_sc_hd__clkbuf_1
X_7216_ _3451_ _3453_ _3455_ _3457_ VGND VGND VPWR VPWR _3458_ sky130_fd_sc_hd__or4_1
X_8196_ clknet_leaf_14_clk _0285_ VGND VGND VPWR VPWR u_input_buffer.fifo_mem\[51\]\[10\]
+ sky130_fd_sc_hd__dfxtp_1
X_7147_ _3384_ _3386_ _3388_ _3390_ VGND VGND VPWR VPWR _3391_ sky130_fd_sc_hd__or4_1
X_4359_ u_input_buffer.data_in\[12\] VGND VGND VPWR VPWR _1626_ sky130_fd_sc_hd__clkbuf_4
XTAP_292 VGND VPWR sky130_fd_sc_hd__tapvpwrvgnd_1
XTAP_281 VGND VPWR sky130_fd_sc_hd__tapvpwrvgnd_1
XTAP_270 VGND VPWR sky130_fd_sc_hd__tapvpwrvgnd_1
X_7078_ u_input_buffer.fifo_mem\[17\]\[7\] _2943_ _2945_ u_input_buffer.fifo_mem\[5\]\[7\]
+ VGND VGND VPWR VPWR _3323_ sky130_fd_sc_hd__a22o_1
X_6029_ net418 _2520_ _2548_ VGND VGND VPWR VPWR _2561_ sky130_fd_sc_hd__mux2_1
XTAP_1414 VGND VPWR sky130_fd_sc_hd__tapvpwrvgnd_1
XTAP_1403 VGND VPWR sky130_fd_sc_hd__tapvpwrvgnd_1
XTAP_1436 VGND VPWR sky130_fd_sc_hd__tapvpwrvgnd_1
XTAP_1447 VGND VPWR sky130_fd_sc_hd__tapvpwrvgnd_1
XTAP_1425 VGND VPWR sky130_fd_sc_hd__tapvpwrvgnd_1
XTAP_1469 VGND VPWR sky130_fd_sc_hd__tapvpwrvgnd_1
XTAP_1458 VGND VPWR sky130_fd_sc_hd__tapvpwrvgnd_1
XFILLER_0_91_262 VGND VGND VPWR VPWR sky130_fd_sc_hd__decap_4
XFILLER_0_91_240 VGND VGND VPWR VPWR sky130_fd_sc_hd__fill_2
XFILLER_0_52_605 VGND VGND VPWR VPWR sky130_fd_sc_hd__decap_3
XFILLER_0_32_362 VGND VGND VPWR VPWR sky130_fd_sc_hd__fill_2
XFILLER_0_102_250 VGND VGND VPWR VPWR sky130_fd_sc_hd__fill_2
XFILLER_0_19_15 VPWR VGND VPWR VGND sky130_ef_sc_hd__decap_12
XFILLER_0_51_13 VGND VGND VPWR VPWR sky130_fd_sc_hd__fill_1
XFILLER_0_67_281 VGND VGND VPWR VPWR sky130_fd_sc_hd__decap_6
XFILLER_0_7_529 VPWR VGND VPWR VGND sky130_ef_sc_hd__decap_12
XFILLER_0_51_57 VGND VGND VPWR VPWR sky130_fd_sc_hd__fill_2
XFILLER_0_82_251 VGND VGND VPWR VPWR sky130_fd_sc_hd__fill_1
XFILLER_0_55_476 VGND VGND VPWR VPWR sky130_fd_sc_hd__decap_4
X_5400_ _2210_ VGND VGND VPWR VPWR _0567_ sky130_fd_sc_hd__clkbuf_1
X_6380_ _2749_ VGND VGND VPWR VPWR _1008_ sky130_fd_sc_hd__clkbuf_1
X_5331_ net704 _1998_ _2169_ VGND VGND VPWR VPWR _2174_ sky130_fd_sc_hd__mux2_1
XFILLER_0_23_373 VGND VGND VPWR VPWR sky130_fd_sc_hd__fill_1
X_8050_ clknet_leaf_42_clk _0139_ VGND VGND VPWR VPWR u_input_buffer.fifo_mem\[60\]\[8\]
+ sky130_fd_sc_hd__dfxtp_1
X_5262_ _2137_ VGND VGND VPWR VPWR _0502_ sky130_fd_sc_hd__clkbuf_1
X_7001_ u_input_buffer.fifo_mem\[29\]\[5\] _2939_ _2941_ u_input_buffer.fifo_mem\[13\]\[5\]
+ _3247_ VGND VGND VPWR VPWR _3248_ sky130_fd_sc_hd__a221o_1
X_5193_ net455 _1996_ _2097_ VGND VGND VPWR VPWR _2101_ sky130_fd_sc_hd__mux2_1
X_4213_ u_sample_counter.sample_count\[18\] _1494_ _1500_ _1506_ VGND VGND VPWR VPWR
+ _1507_ sky130_fd_sc_hd__and4_4
X_4144_ _1458_ u_sensor_interface.sensor_array\[2\]\[13\] net112 VGND VGND VPWR VPWR
+ _1459_ sky130_fd_sc_hd__mux2_1
XFILLER_0_92_53 VPWR VGND VPWR VGND sky130_ef_sc_hd__decap_12
X_4075_ _1399_ u_sensor_interface.sensor_array\[3\]\[3\] _1381_ VGND VGND VPWR VPWR
+ _1400_ sky130_fd_sc_hd__mux2_1
X_8952_ clknet_leaf_98_clk _1041_ VGND VGND VPWR VPWR u_input_buffer.fifo_mem\[4\]\[14\]
+ sky130_fd_sc_hd__dfxtp_1
X_7903_ clknet_leaf_64_clk net215 net196 VGND VGND VPWR VPWR u_register_bank.status_flags\[23\]
+ sky130_fd_sc_hd__dfrtp_1
X_8883_ clknet_leaf_65_clk _0972_ VGND VGND VPWR VPWR u_input_buffer.fifo_mem\[8\]\[9\]
+ sky130_fd_sc_hd__dfxtp_1
Xclkbuf_leaf_90_clk clknet_3_2__leaf_clk VGND VGND VPWR VPWR clknet_leaf_90_clk sky130_fd_sc_hd__clkbuf_16
X_7834_ _3904_ VGND VGND VPWR VPWR _3916_ sky130_fd_sc_hd__buf_4
X_7765_ _3876_ net134 _3852_ VGND VGND VPWR VPWR _3877_ sky130_fd_sc_hd__mux2_1
XFILLER_0_19_613 VGND VGND VPWR VPWR sky130_fd_sc_hd__decap_3
XFILLER_0_25_91 VGND VGND VPWR VPWR sky130_fd_sc_hd__fill_1
X_4977_ _1415_ net1313 _1971_ VGND VGND VPWR VPWR _1978_ sky130_fd_sc_hd__mux2_1
XFILLER_0_58_281 VGND VGND VPWR VPWR sky130_fd_sc_hd__fill_2
X_6716_ _2900_ _2967_ VGND VGND VPWR VPWR _2968_ sky130_fd_sc_hd__nor2_4
XFILLER_0_19_668 VGND VGND VPWR VPWR sky130_fd_sc_hd__fill_1
X_7696_ _3823_ net117 _3817_ VGND VGND VPWR VPWR _3824_ sky130_fd_sc_hd__mux2_1
X_6647_ _2885_ u_input_buffer.rd_ptr\[4\] VGND VGND VPWR VPWR _2899_ sky130_fd_sc_hd__nand2_1
X_6578_ _2854_ VGND VGND VPWR VPWR _1101_ sky130_fd_sc_hd__clkbuf_1
X_8317_ clknet_leaf_41_clk _0406_ VGND VGND VPWR VPWR u_input_buffer.fifo_mem\[43\]\[3\]
+ sky130_fd_sc_hd__dfxtp_1
X_5529_ net673 _2262_ _2277_ VGND VGND VPWR VPWR _2287_ sky130_fd_sc_hd__mux2_1
X_8248_ clknet_leaf_98_clk _0337_ VGND VGND VPWR VPWR u_input_buffer.fifo_mem\[48\]\[14\]
+ sky130_fd_sc_hd__dfxtp_1
X_8179_ clknet_leaf_69_clk _0268_ VGND VGND VPWR VPWR u_input_buffer.fifo_mem\[52\]\[9\]
+ sky130_fd_sc_hd__dfxtp_1
XFILLER_0_69_535 VGND VGND VPWR VPWR sky130_fd_sc_hd__decap_6
XFILLER_0_69_513 VGND VGND VPWR VPWR sky130_fd_sc_hd__decap_4
XTAP_1222 VGND VPWR sky130_fd_sc_hd__tapvpwrvgnd_1
XTAP_1200 VGND VPWR sky130_fd_sc_hd__tapvpwrvgnd_1
XTAP_1211 VGND VPWR sky130_fd_sc_hd__tapvpwrvgnd_1
XTAP_1266 VGND VPWR sky130_fd_sc_hd__tapvpwrvgnd_1
XTAP_1255 VGND VPWR sky130_fd_sc_hd__tapvpwrvgnd_1
XTAP_1244 VGND VPWR sky130_fd_sc_hd__tapvpwrvgnd_1
XTAP_1233 VGND VPWR sky130_fd_sc_hd__tapvpwrvgnd_1
Xclkbuf_leaf_81_clk clknet_3_2__leaf_clk VGND VGND VPWR VPWR clknet_leaf_81_clk sky130_fd_sc_hd__clkbuf_16
XTAP_1299 VGND VPWR sky130_fd_sc_hd__tapvpwrvgnd_1
XTAP_1288 VGND VPWR sky130_fd_sc_hd__tapvpwrvgnd_1
XTAP_1277 VGND VPWR sky130_fd_sc_hd__tapvpwrvgnd_1
XFILLER_0_49_281 VGND VGND VPWR VPWR sky130_fd_sc_hd__decap_3
XFILLER_0_112_29 VPWR VGND VPWR VGND sky130_ef_sc_hd__decap_12
XFILLER_0_64_262 VGND VGND VPWR VPWR sky130_fd_sc_hd__fill_1
XFILLER_0_107_353 VGND VGND VPWR VPWR sky130_fd_sc_hd__fill_1
XFILLER_0_64_284 VGND VGND VPWR VPWR sky130_fd_sc_hd__fill_1
XFILLER_0_33_682 VGND VGND VPWR VPWR sky130_fd_sc_hd__decap_4
X_4900_ net912 _1708_ _1934_ VGND VGND VPWR VPWR _1937_ sky130_fd_sc_hd__mux2_1
XFILLER_0_75_505 VGND VGND VPWR VPWR sky130_fd_sc_hd__fill_2
XFILLER_0_62_23 VGND VGND VPWR VPWR sky130_fd_sc_hd__decap_4
X_5880_ _2474_ VGND VGND VPWR VPWR _0783_ sky130_fd_sc_hd__clkbuf_1
X_4831_ _1403_ net1305 _1893_ VGND VGND VPWR VPWR _1898_ sky130_fd_sc_hd__mux2_1
Xclkbuf_leaf_72_clk clknet_3_3__leaf_clk VGND VGND VPWR VPWR clknet_leaf_72_clk sky130_fd_sc_hd__clkbuf_16
X_7550_ _3728_ VGND VGND VPWR VPWR _1199_ sky130_fd_sc_hd__clkbuf_1
X_4762_ _1860_ VGND VGND VPWR VPWR _0279_ sky130_fd_sc_hd__clkbuf_1
XFILLER_0_28_465 VGND VGND VPWR VPWR sky130_fd_sc_hd__fill_2
X_6501_ net486 _1414_ _2807_ VGND VGND VPWR VPWR _2814_ sky130_fd_sc_hd__mux2_1
X_7481_ net352 _1444_ _3677_ VGND VGND VPWR VPWR _3690_ sky130_fd_sc_hd__mux2_1
X_4693_ _1409_ net1248 _1817_ VGND VGND VPWR VPWR _1823_ sky130_fd_sc_hd__mux2_1
XFILLER_0_43_424 VGND VGND VPWR VPWR sky130_fd_sc_hd__fill_1
X_6432_ _2777_ VGND VGND VPWR VPWR _1032_ sky130_fd_sc_hd__clkbuf_1
X_9220_ net176 _1307_ net208 VGND VGND VPWR VPWR u_register_bank.sensor_enable\[21\]
+ sky130_fd_sc_hd__dfrtp_1
XFILLER_0_70_243 VGND VGND VPWR VPWR sky130_fd_sc_hd__fill_2
XFILLER_0_15_137 VGND VGND VPWR VPWR sky130_fd_sc_hd__fill_2
X_9151_ net181 _1239_ VGND VGND VPWR VPWR net125 sky130_fd_sc_hd__dfxtp_1
XFILLER_0_11_93 VGND VGND VPWR VPWR sky130_fd_sc_hd__fill_1
XFILLER_0_113_389 VGND VGND VPWR VPWR sky130_fd_sc_hd__decap_3
XFILLER_0_113_367 VGND VGND VPWR VPWR sky130_fd_sc_hd__fill_2
X_6363_ net489 _2508_ _2735_ VGND VGND VPWR VPWR _2741_ sky130_fd_sc_hd__mux2_1
X_8102_ clknet_leaf_108_clk _0191_ VGND VGND VPWR VPWR u_input_buffer.fifo_mem\[57\]\[12\]
+ sky130_fd_sc_hd__dfxtp_1
XFILLER_0_30_129 VGND VGND VPWR VPWR sky130_fd_sc_hd__fill_2
X_6294_ net300 _2508_ _2698_ VGND VGND VPWR VPWR _2704_ sky130_fd_sc_hd__mux2_1
X_9082_ clknet_leaf_89_clk _1170_ VGND VGND VPWR VPWR u_input_buffer.fifo_mem\[63\]\[12\]
+ sky130_fd_sc_hd__dfxtp_1
X_5314_ _2164_ VGND VGND VPWR VPWR _0527_ sky130_fd_sc_hd__clkbuf_1
X_5245_ net506 _2014_ _2114_ VGND VGND VPWR VPWR _2128_ sky130_fd_sc_hd__mux2_1
X_8033_ clknet_leaf_6_clk _0122_ VGND VGND VPWR VPWR u_input_buffer.fifo_mem\[61\]\[7\]
+ sky130_fd_sc_hd__dfxtp_1
Xhold17 u_sample_counter.sample_count\[6\] VGND VGND VPWR VPWR net229 sky130_fd_sc_hd__dlygate4sd3_1
Xhold28 u_sample_counter.sample_count\[13\] VGND VGND VPWR VPWR net240 sky130_fd_sc_hd__dlygate4sd3_1
Xhold39 _1134_ VGND VGND VPWR VPWR net251 sky130_fd_sc_hd__dlygate4sd3_1
X_5176_ net374 _2014_ _2077_ VGND VGND VPWR VPWR _2091_ sky130_fd_sc_hd__mux2_1
XFILLER_0_98_608 VGND VGND VPWR VPWR sky130_fd_sc_hd__decap_3
X_4127_ u_input_buffer.data_in\[11\] VGND VGND VPWR VPWR _1444_ sky130_fd_sc_hd__clkbuf_4
X_4058_ _1384_ VGND VGND VPWR VPWR _1385_ sky130_fd_sc_hd__buf_2
X_8935_ clknet_leaf_109_clk _1024_ VGND VGND VPWR VPWR u_input_buffer.fifo_mem\[5\]\[13\]
+ sky130_fd_sc_hd__dfxtp_1
Xclkbuf_leaf_63_clk clknet_3_6__leaf_clk VGND VGND VPWR VPWR clknet_leaf_63_clk sky130_fd_sc_hd__clkbuf_16
X_8866_ clknet_leaf_20_clk _0955_ VGND VGND VPWR VPWR u_input_buffer.fifo_mem\[9\]\[8\]
+ sky130_fd_sc_hd__dfxtp_1
XFILLER_0_93_335 VGND VGND VPWR VPWR sky130_fd_sc_hd__fill_1
X_7817_ _3907_ VGND VGND VPWR VPWR _1287_ sky130_fd_sc_hd__clkbuf_1
X_8797_ clknet_leaf_3_clk _0886_ VGND VGND VPWR VPWR u_input_buffer.fifo_mem\[13\]\[3\]
+ sky130_fd_sc_hd__dfxtp_1
XFILLER_0_19_476 VGND VGND VPWR VPWR sky130_fd_sc_hd__fill_1
X_7748_ u_register_bank.window_cfg\[24\] _3847_ _3848_ u_register_bank.threshold_cfg\[24\]
+ _3863_ VGND VGND VPWR VPWR _3864_ sky130_fd_sc_hd__a221o_1
X_7679_ u_register_bank.window_cfg\[9\] _3772_ _3773_ u_analytics_engine.threshold\[9\]
+ _3809_ VGND VGND VPWR VPWR _3810_ sky130_fd_sc_hd__a221o_1
XFILLER_0_46_262 VGND VGND VPWR VPWR sky130_fd_sc_hd__fill_1
XFILLER_0_22_608 VGND VGND VPWR VPWR sky130_fd_sc_hd__decap_8
XFILLER_0_34_468 VGND VGND VPWR VPWR sky130_fd_sc_hd__decap_8
XFILLER_0_30_663 VGND VGND VPWR VPWR sky130_fd_sc_hd__decap_3
XFILLER_0_16_27 VGND VGND VPWR VPWR sky130_fd_sc_hd__fill_1
Xclkbuf_leaf_54_clk clknet_3_7__leaf_clk VGND VGND VPWR VPWR clknet_leaf_54_clk sky130_fd_sc_hd__clkbuf_16
XTAP_1030 VGND VPWR sky130_fd_sc_hd__tapvpwrvgnd_1
XTAP_1074 VGND VPWR sky130_fd_sc_hd__tapvpwrvgnd_1
XTAP_1063 VGND VPWR sky130_fd_sc_hd__tapvpwrvgnd_1
XTAP_1041 VGND VPWR sky130_fd_sc_hd__tapvpwrvgnd_1
XTAP_1052 VGND VPWR sky130_fd_sc_hd__tapvpwrvgnd_1
XFILLER_0_29_229 VGND VGND VPWR VPWR sky130_fd_sc_hd__fill_2
XFILLER_0_72_508 VGND VGND VPWR VPWR sky130_fd_sc_hd__fill_1
XTAP_1096 VGND VPWR sky130_fd_sc_hd__tapvpwrvgnd_1
XTAP_1085 VGND VPWR sky130_fd_sc_hd__tapvpwrvgnd_1
XFILLER_0_108_651 VGND VGND VPWR VPWR sky130_fd_sc_hd__fill_1
XFILLER_0_4_329 VPWR VGND VPWR VGND sky130_ef_sc_hd__decap_12
XFILLER_0_4_318 VGND VGND VPWR VPWR sky130_fd_sc_hd__decap_4
Xhold509 u_input_buffer.fifo_mem\[54\]\[4\] VGND VGND VPWR VPWR net721 sky130_fd_sc_hd__dlygate4sd3_1
XFILLER_0_40_449 VGND VGND VPWR VPWR sky130_fd_sc_hd__fill_2
XFILLER_0_110_348 VGND VGND VPWR VPWR sky130_fd_sc_hd__fill_2
XFILLER_0_110_326 VGND VGND VPWR VPWR sky130_fd_sc_hd__decap_6
XFILLER_0_110_359 VGND VGND VPWR VPWR sky130_fd_sc_hd__fill_2
XFILLER_0_0_568 VGND VGND VPWR VPWR sky130_fd_sc_hd__fill_2
XFILLER_0_21_685 VGND VGND VPWR VPWR sky130_fd_sc_hd__fill_1
XTAP_814 VGND VPWR sky130_fd_sc_hd__tapvpwrvgnd_1
XTAP_803 VGND VPWR sky130_fd_sc_hd__tapvpwrvgnd_1
XTAP_825 VGND VPWR sky130_fd_sc_hd__tapvpwrvgnd_1
X_5030_ net729 _2010_ _1989_ VGND VGND VPWR VPWR _2011_ sky130_fd_sc_hd__mux2_1
XTAP_836 VGND VPWR sky130_fd_sc_hd__tapvpwrvgnd_1
XTAP_847 VGND VPWR sky130_fd_sc_hd__tapvpwrvgnd_1
XTAP_858 VGND VPWR sky130_fd_sc_hd__tapvpwrvgnd_1
XTAP_869 VGND VPWR sky130_fd_sc_hd__tapvpwrvgnd_1
X_6981_ u_input_buffer.fifo_mem\[6\]\[4\] _3035_ _3037_ u_input_buffer.fifo_mem\[28\]\[4\]
+ _3228_ VGND VGND VPWR VPWR _3229_ sky130_fd_sc_hd__a221o_1
XFILLER_0_73_55 VGND VGND VPWR VPWR sky130_fd_sc_hd__fill_1
X_8720_ clknet_leaf_30_clk _0809_ VGND VGND VPWR VPWR u_input_buffer.fifo_mem\[18\]\[6\]
+ sky130_fd_sc_hd__dfxtp_1
XFILLER_0_88_641 VGND VGND VPWR VPWR sky130_fd_sc_hd__decap_3
XFILLER_0_73_66 VGND VGND VPWR VPWR sky130_fd_sc_hd__fill_2
X_5932_ _1396_ VGND VGND VPWR VPWR _2504_ sky130_fd_sc_hd__clkbuf_4
Xclkbuf_leaf_45_clk clknet_3_6__leaf_clk VGND VGND VPWR VPWR clknet_leaf_45_clk sky130_fd_sc_hd__clkbuf_16
X_5863_ net1158 _2252_ _2461_ VGND VGND VPWR VPWR _2466_ sky130_fd_sc_hd__mux2_1
X_8651_ clknet_leaf_53_clk _0740_ VGND VGND VPWR VPWR u_input_buffer.fifo_mem\[22\]\[1\]
+ sky130_fd_sc_hd__dfxtp_1
XFILLER_0_75_346 VGND VGND VPWR VPWR sky130_fd_sc_hd__fill_1
XFILLER_0_8_613 VPWR VGND VPWR VGND sky130_ef_sc_hd__decap_12
X_5794_ _2429_ VGND VGND VPWR VPWR _0742_ sky130_fd_sc_hd__clkbuf_1
X_8582_ clknet_leaf_85_clk _0671_ VGND VGND VPWR VPWR u_input_buffer.fifo_mem\[27\]\[12\]
+ sky130_fd_sc_hd__dfxtp_1
X_7602_ _3756_ VGND VGND VPWR VPWR _1223_ sky130_fd_sc_hd__clkbuf_1
X_4814_ net585 _1730_ _1873_ VGND VGND VPWR VPWR _1888_ sky130_fd_sc_hd__mux2_1
XFILLER_0_90_327 VGND VGND VPWR VPWR sky130_fd_sc_hd__fill_1
XFILLER_0_8_657 VPWR VGND VPWR VGND sky130_ef_sc_hd__decap_12
X_7533_ _3719_ VGND VGND VPWR VPWR _1191_ sky130_fd_sc_hd__clkbuf_1
X_4745_ _1850_ VGND VGND VPWR VPWR _0272_ sky130_fd_sc_hd__clkbuf_1
XFILLER_0_83_390 VGND VGND VPWR VPWR sky130_fd_sc_hd__fill_2
XFILLER_0_114_643 VGND VGND VPWR VPWR sky130_fd_sc_hd__fill_1
X_7464_ _3681_ VGND VGND VPWR VPWR _1160_ sky130_fd_sc_hd__clkbuf_1
XFILLER_0_98_41 VPWR VGND VPWR VGND sky130_ef_sc_hd__decap_12
XFILLER_0_71_585 VGND VGND VPWR VPWR sky130_fd_sc_hd__fill_2
X_4676_ net330 _1732_ _1797_ VGND VGND VPWR VPWR _1813_ sky130_fd_sc_hd__mux2_1
X_9203_ net181 _1290_ net211 VGND VGND VPWR VPWR u_register_bank.sensor_enable\[4\]
+ sky130_fd_sc_hd__dfrtp_1
XFILLER_0_12_630 VPWR VGND VPWR VGND sky130_ef_sc_hd__decap_12
X_6415_ _1630_ net1192 _2752_ VGND VGND VPWR VPWR _2768_ sky130_fd_sc_hd__mux2_1
X_7395_ u_input_buffer.fifo_mem\[16\]\[15\] _2970_ _2972_ u_input_buffer.fifo_mem\[49\]\[15\]
+ _2974_ VGND VGND VPWR VPWR _3632_ sky130_fd_sc_hd__a221o_1
XFILLER_0_31_449 VGND VGND VPWR VPWR sky130_fd_sc_hd__fill_2
XFILLER_0_101_337 VGND VGND VPWR VPWR sky130_fd_sc_hd__decap_4
XFILLER_0_12_674 VGND VGND VPWR VPWR sky130_fd_sc_hd__decap_8
X_9134_ net169 _1222_ net201 VGND VGND VPWR VPWR u_register_bank.threshold_cfg\[16\]
+ sky130_fd_sc_hd__dfrtp_1
X_6346_ _2731_ VGND VGND VPWR VPWR _0992_ sky130_fd_sc_hd__clkbuf_1
XFILLER_0_11_151 VGND VGND VPWR VPWR sky130_fd_sc_hd__decap_6
X_9065_ clknet_leaf_105_clk _1154_ VGND VGND VPWR VPWR u_sensor_interface.sensor_array\[3\]\[12\]
+ sky130_fd_sc_hd__dfxtp_1
Xinput107 sensor_data_in[7] VGND VGND VPWR VPWR net107 sky130_fd_sc_hd__clkbuf_1
X_8016_ clknet_leaf_43_clk _0105_ VGND VGND VPWR VPWR u_input_buffer.fifo_mem\[62\]\[6\]
+ sky130_fd_sc_hd__dfxtp_1
X_6277_ _2694_ VGND VGND VPWR VPWR _0960_ sky130_fd_sc_hd__clkbuf_1
X_5228_ _2119_ VGND VGND VPWR VPWR _0486_ sky130_fd_sc_hd__clkbuf_1
X_5159_ _2082_ VGND VGND VPWR VPWR _0454_ sky130_fd_sc_hd__clkbuf_1
Xclkbuf_leaf_36_clk clknet_3_5__leaf_clk VGND VGND VPWR VPWR clknet_leaf_36_clk sky130_fd_sc_hd__clkbuf_16
X_8918_ clknet_leaf_75_clk _1007_ VGND VGND VPWR VPWR u_input_buffer.fifo_mem\[6\]\[12\]
+ sky130_fd_sc_hd__dfxtp_1
X_8849_ clknet_leaf_50_clk _0938_ VGND VGND VPWR VPWR u_input_buffer.fifo_mem\[10\]\[7\]
+ sky130_fd_sc_hd__dfxtp_1
XFILLER_0_93_110 VGND VGND VPWR VPWR sky130_fd_sc_hd__fill_2
XPHY_124 VGND VGND VPWR VPWR sky130_fd_sc_hd__decap_3
XPHY_113 VGND VGND VPWR VPWR sky130_fd_sc_hd__decap_3
XPHY_102 VGND VGND VPWR VPWR sky130_fd_sc_hd__decap_3
XPHY_157 VGND VGND VPWR VPWR sky130_fd_sc_hd__decap_3
XPHY_146 VGND VGND VPWR VPWR sky130_fd_sc_hd__decap_3
XPHY_135 VGND VGND VPWR VPWR sky130_fd_sc_hd__decap_3
XPHY_179 VGND VGND VPWR VPWR sky130_fd_sc_hd__decap_3
XPHY_168 VGND VGND VPWR VPWR sky130_fd_sc_hd__decap_3
XFILLER_0_81_327 VGND VGND VPWR VPWR sky130_fd_sc_hd__fill_1
XFILLER_0_105_621 VGND VGND VPWR VPWR sky130_fd_sc_hd__fill_1
XFILLER_0_22_416 VGND VGND VPWR VPWR sky130_fd_sc_hd__decap_4
XFILLER_0_104_197 VGND VGND VPWR VPWR sky130_fd_sc_hd__decap_4
Xclkbuf_leaf_27_clk clknet_3_5__leaf_clk VGND VGND VPWR VPWR clknet_leaf_27_clk sky130_fd_sc_hd__clkbuf_16
XPHY_4 VGND VGND VPWR VPWR sky130_fd_sc_hd__decap_3
XFILLER_0_72_338 VGND VGND VPWR VPWR sky130_fd_sc_hd__decap_3
X_4530_ _1731_ VGND VGND VPWR VPWR _0176_ sky130_fd_sc_hd__clkbuf_1
X_4461_ net1080 _1610_ _1683_ VGND VGND VPWR VPWR _1688_ sky130_fd_sc_hd__mux2_1
Xhold306 u_input_buffer.fifo_mem\[22\]\[11\] VGND VGND VPWR VPWR net518 sky130_fd_sc_hd__dlygate4sd3_1
Xhold317 u_input_buffer.fifo_mem\[48\]\[15\] VGND VGND VPWR VPWR net529 sky130_fd_sc_hd__dlygate4sd3_1
XFILLER_0_110_101 VGND VGND VPWR VPWR sky130_fd_sc_hd__fill_1
Xhold328 u_input_buffer.fifo_mem\[19\]\[5\] VGND VGND VPWR VPWR net540 sky130_fd_sc_hd__dlygate4sd3_1
X_7180_ u_input_buffer.fifo_mem\[15\]\[9\] _3060_ _3062_ u_input_buffer.fifo_mem\[43\]\[9\]
+ VGND VGND VPWR VPWR _3423_ sky130_fd_sc_hd__a22o_1
Xhold339 u_input_buffer.fifo_mem\[62\]\[8\] VGND VGND VPWR VPWR net551 sky130_fd_sc_hd__dlygate4sd3_1
X_6200_ net577 _2516_ _2644_ VGND VGND VPWR VPWR _2654_ sky130_fd_sc_hd__mux2_1
XFILLER_0_0_343 VGND VGND VPWR VPWR sky130_fd_sc_hd__decap_3
X_6131_ _1620_ net1112 _2607_ VGND VGND VPWR VPWR _2617_ sky130_fd_sc_hd__mux2_1
XTAP_600 VGND VPWR sky130_fd_sc_hd__tapvpwrvgnd_1
X_4392_ _1648_ VGND VGND VPWR VPWR _0121_ sky130_fd_sc_hd__clkbuf_1
XTAP_611 VGND VPWR sky130_fd_sc_hd__tapvpwrvgnd_1
XTAP_622 VGND VPWR sky130_fd_sc_hd__tapvpwrvgnd_1
XTAP_633 VGND VPWR sky130_fd_sc_hd__tapvpwrvgnd_1
X_6062_ _2579_ VGND VGND VPWR VPWR _0860_ sky130_fd_sc_hd__clkbuf_1
Xhold1006 u_input_buffer.fifo_mem\[4\]\[4\] VGND VGND VPWR VPWR net1218 sky130_fd_sc_hd__dlygate4sd3_1
XTAP_655 VGND VPWR sky130_fd_sc_hd__tapvpwrvgnd_1
XTAP_644 VGND VPWR sky130_fd_sc_hd__tapvpwrvgnd_1
XTAP_666 VGND VPWR sky130_fd_sc_hd__tapvpwrvgnd_1
XTAP_677 VGND VPWR sky130_fd_sc_hd__tapvpwrvgnd_1
Xhold1028 u_input_buffer.fifo_mem\[51\]\[2\] VGND VGND VPWR VPWR net1240 sky130_fd_sc_hd__dlygate4sd3_1
X_5013_ _1999_ VGND VGND VPWR VPWR _0391_ sky130_fd_sc_hd__clkbuf_1
Xhold1017 u_input_buffer.fifo_mem\[41\]\[1\] VGND VGND VPWR VPWR net1229 sky130_fd_sc_hd__dlygate4sd3_1
Xhold1039 u_input_buffer.fifo_mem\[59\]\[9\] VGND VGND VPWR VPWR net1251 sky130_fd_sc_hd__dlygate4sd3_1
XTAP_688 VGND VPWR sky130_fd_sc_hd__tapvpwrvgnd_1
XTAP_699 VGND VPWR sky130_fd_sc_hd__tapvpwrvgnd_1
XFILLER_0_108_83 VGND VGND VPWR VPWR sky130_fd_sc_hd__fill_1
X_6964_ u_input_buffer.fifo_mem\[14\]\[4\] _2958_ _2961_ u_input_buffer.fifo_mem\[42\]\[4\]
+ VGND VGND VPWR VPWR _3212_ sky130_fd_sc_hd__a22o_1
Xclkbuf_leaf_18_clk clknet_3_4__leaf_clk VGND VGND VPWR VPWR clknet_leaf_18_clk sky130_fd_sc_hd__clkbuf_16
XFILLER_0_48_302 VGND VGND VPWR VPWR sky130_fd_sc_hd__decap_6
X_8703_ clknet_leaf_46_clk _0792_ VGND VGND VPWR VPWR u_input_buffer.fifo_mem\[19\]\[5\]
+ sky130_fd_sc_hd__dfxtp_1
XFILLER_0_76_622 VGND VGND VPWR VPWR sky130_fd_sc_hd__decap_8
X_6895_ _3129_ _3131_ _3135_ _3144_ VGND VGND VPWR VPWR _3145_ sky130_fd_sc_hd__or4_4
X_5915_ net271 _2270_ _2478_ VGND VGND VPWR VPWR _2493_ sky130_fd_sc_hd__mux2_1
XFILLER_0_48_335 VGND VGND VPWR VPWR sky130_fd_sc_hd__decap_4
X_8634_ clknet_leaf_49_clk _0723_ VGND VGND VPWR VPWR u_input_buffer.fifo_mem\[23\]\[0\]
+ sky130_fd_sc_hd__dfxtp_1
X_5846_ _2456_ VGND VGND VPWR VPWR _0767_ sky130_fd_sc_hd__clkbuf_1
XFILLER_0_90_102 VGND VGND VPWR VPWR sky130_fd_sc_hd__fill_1
X_5777_ net749 _2268_ _2406_ VGND VGND VPWR VPWR _2420_ sky130_fd_sc_hd__mux2_1
X_8565_ clknet_leaf_74_clk _0654_ VGND VGND VPWR VPWR u_input_buffer.fifo_mem\[28\]\[11\]
+ sky130_fd_sc_hd__dfxtp_1
X_4728_ net651 _1714_ _1836_ VGND VGND VPWR VPWR _1842_ sky130_fd_sc_hd__mux2_1
X_8496_ clknet_leaf_30_clk _0585_ VGND VGND VPWR VPWR u_input_buffer.fifo_mem\[32\]\[6\]
+ sky130_fd_sc_hd__dfxtp_1
X_7516_ _3710_ VGND VGND VPWR VPWR _1183_ sky130_fd_sc_hd__clkbuf_1
XFILLER_0_44_552 VGND VGND VPWR VPWR sky130_fd_sc_hd__decap_4
XFILLER_0_44_585 VGND VGND VPWR VPWR sky130_fd_sc_hd__decap_3
X_4659_ _1804_ VGND VGND VPWR VPWR _0232_ sky130_fd_sc_hd__clkbuf_1
XFILLER_0_71_371 VGND VGND VPWR VPWR sky130_fd_sc_hd__fill_1
X_7447_ net1001 net100 _3662_ VGND VGND VPWR VPWR _3672_ sky130_fd_sc_hd__mux2_1
Xhold840 u_input_buffer.fifo_mem\[41\]\[4\] VGND VGND VPWR VPWR net1052 sky130_fd_sc_hd__dlygate4sd3_1
X_7378_ u_input_buffer.fifo_mem\[26\]\[14\] _3065_ _3067_ u_input_buffer.fifo_mem\[62\]\[14\]
+ _3615_ VGND VGND VPWR VPWR _3616_ sky130_fd_sc_hd__a221o_1
Xhold851 u_input_buffer.fifo_mem\[13\]\[1\] VGND VGND VPWR VPWR net1063 sky130_fd_sc_hd__dlygate4sd3_1
Xhold862 u_input_buffer.fifo_mem\[13\]\[7\] VGND VGND VPWR VPWR net1074 sky130_fd_sc_hd__dlygate4sd3_1
Xhold873 u_input_buffer.fifo_mem\[57\]\[5\] VGND VGND VPWR VPWR net1085 sky130_fd_sc_hd__dlygate4sd3_1
X_6329_ net497 _2508_ _2717_ VGND VGND VPWR VPWR _2723_ sky130_fd_sc_hd__mux2_1
Xhold884 u_input_buffer.fifo_mem\[13\]\[14\] VGND VGND VPWR VPWR net1096 sky130_fd_sc_hd__dlygate4sd3_1
Xhold895 u_input_buffer.fifo_mem\[57\]\[9\] VGND VGND VPWR VPWR net1107 sky130_fd_sc_hd__dlygate4sd3_1
X_9117_ net172 _1205_ net203 VGND VGND VPWR VPWR u_register_bank.window_cfg\[31\]
+ sky130_fd_sc_hd__dfrtp_1
X_9048_ clknet_leaf_72_clk _1137_ VGND VGND VPWR VPWR u_analytics_engine.data_in\[11\]
+ sky130_fd_sc_hd__dfxtp_2
XFILLER_0_98_246 VGND VGND VPWR VPWR sky130_fd_sc_hd__fill_2
XFILLER_0_98_279 VGND VGND VPWR VPWR sky130_fd_sc_hd__decap_3
XFILLER_0_79_482 VGND VGND VPWR VPWR sky130_fd_sc_hd__fill_1
XFILLER_0_13_39 VPWR VGND VPWR VGND sky130_ef_sc_hd__decap_12
XFILLER_0_94_474 VGND VGND VPWR VPWR sky130_fd_sc_hd__fill_2
XFILLER_0_66_176 VGND VGND VPWR VPWR sky130_fd_sc_hd__decap_8
XFILLER_0_27_519 VGND VGND VPWR VPWR sky130_fd_sc_hd__decap_4
XFILLER_0_81_146 VGND VGND VPWR VPWR sky130_fd_sc_hd__decap_4
XFILLER_0_81_179 VGND VGND VPWR VPWR sky130_fd_sc_hd__decap_4
XFILLER_0_62_371 VGND VGND VPWR VPWR sky130_fd_sc_hd__fill_1
XFILLER_0_105_484 VGND VGND VPWR VPWR sky130_fd_sc_hd__fill_1
XFILLER_0_1_129 VGND VGND VPWR VPWR sky130_fd_sc_hd__fill_1
XFILLER_0_89_279 VGND VGND VPWR VPWR sky130_fd_sc_hd__fill_1
X_3961_ _1330_ VGND VGND VPWR VPWR _0008_ sky130_fd_sc_hd__clkbuf_1
X_5700_ _1618_ net1095 _2370_ VGND VGND VPWR VPWR _2379_ sky130_fd_sc_hd__mux2_1
X_6680_ _2931_ VGND VGND VPWR VPWR _2932_ sky130_fd_sc_hd__clkbuf_4
XFILLER_0_115_215 VGND VGND VPWR VPWR sky130_fd_sc_hd__decap_8
X_5631_ _2342_ VGND VGND VPWR VPWR _0666_ sky130_fd_sc_hd__clkbuf_1
X_8350_ clknet_leaf_21_clk _0439_ VGND VGND VPWR VPWR u_input_buffer.fifo_mem\[41\]\[4\]
+ sky130_fd_sc_hd__dfxtp_1
XFILLER_0_5_424 VGND VGND VPWR VPWR sky130_fd_sc_hd__decap_4
X_5562_ _2305_ VGND VGND VPWR VPWR _0634_ sky130_fd_sc_hd__clkbuf_1
XFILLER_0_53_360 VGND VGND VPWR VPWR sky130_fd_sc_hd__decap_3
X_4513_ _1426_ VGND VGND VPWR VPWR _1720_ sky130_fd_sc_hd__clkbuf_4
X_8281_ clknet_leaf_102_clk _0370_ VGND VGND VPWR VPWR u_input_buffer.fifo_mem\[46\]\[15\]
+ sky130_fd_sc_hd__dfxtp_1
X_7301_ u_input_buffer.fifo_mem\[54\]\[12\] _3077_ _3079_ u_input_buffer.fifo_mem\[46\]\[12\]
+ VGND VGND VPWR VPWR _3541_ sky130_fd_sc_hd__a22o_1
XFILLER_0_53_371 VGND VGND VPWR VPWR sky130_fd_sc_hd__decap_6
XFILLER_0_53_393 VGND VGND VPWR VPWR sky130_fd_sc_hd__decap_6
Xhold125 u_input_buffer.fifo_mem\[52\]\[2\] VGND VGND VPWR VPWR net337 sky130_fd_sc_hd__dlygate4sd3_1
Xhold114 u_sensor_interface.sensor_array\[3\]\[8\] VGND VGND VPWR VPWR net326 sky130_fd_sc_hd__dlygate4sd3_1
Xhold103 u_input_buffer.fifo_mem\[6\]\[3\] VGND VGND VPWR VPWR net315 sky130_fd_sc_hd__dlygate4sd3_1
X_7232_ u_input_buffer.fifo_mem\[41\]\[11\] _2918_ _2920_ u_input_buffer.fifo_mem\[45\]\[11\]
+ _3472_ VGND VGND VPWR VPWR _3473_ sky130_fd_sc_hd__a221o_1
X_5493_ _2265_ VGND VGND VPWR VPWR _0605_ sky130_fd_sc_hd__clkbuf_1
Xhold158 u_input_buffer.fifo_mem\[7\]\[7\] VGND VGND VPWR VPWR net370 sky130_fd_sc_hd__dlygate4sd3_1
Xhold136 u_input_buffer.fifo_mem\[15\]\[9\] VGND VGND VPWR VPWR net348 sky130_fd_sc_hd__dlygate4sd3_1
X_4444_ _1676_ VGND VGND VPWR VPWR _0145_ sky130_fd_sc_hd__clkbuf_1
Xhold147 u_sensor_interface.sensor_array\[1\]\[15\] VGND VGND VPWR VPWR net359 sky130_fd_sc_hd__dlygate4sd3_1
XFILLER_0_1_641 VPWR VGND VPWR VGND sky130_ef_sc_hd__decap_12
XFILLER_0_41_588 VPWR VGND VPWR VGND sky130_ef_sc_hd__decap_12
Xclkbuf_leaf_7_clk clknet_3_1__leaf_clk VGND VGND VPWR VPWR clknet_leaf_7_clk sky130_fd_sc_hd__clkbuf_16
X_7163_ u_input_buffer.fifo_mem\[2\]\[9\] _2984_ _2986_ u_input_buffer.fifo_mem\[32\]\[9\]
+ VGND VGND VPWR VPWR _3406_ sky130_fd_sc_hd__a22o_1
Xhold169 u_input_buffer.fifo_mem\[7\]\[11\] VGND VGND VPWR VPWR net381 sky130_fd_sc_hd__dlygate4sd3_1
X_4375_ u_input_buffer.wr_ptr\[1\] _1637_ VGND VGND VPWR VPWR _1638_ sky130_fd_sc_hd__nand2b_4
X_7094_ u_input_buffer.fifo_mem\[27\]\[7\] _3013_ _3015_ u_input_buffer.fifo_mem\[59\]\[7\]
+ _3338_ VGND VGND VPWR VPWR _3339_ sky130_fd_sc_hd__a221o_1
XTAP_430 VGND VPWR sky130_fd_sc_hd__tapvpwrvgnd_1
XTAP_441 VGND VPWR sky130_fd_sc_hd__tapvpwrvgnd_1
X_6114_ _2608_ VGND VGND VPWR VPWR _0883_ sky130_fd_sc_hd__clkbuf_1
X_6045_ net354 _2500_ _2569_ VGND VGND VPWR VPWR _2571_ sky130_fd_sc_hd__mux2_1
XTAP_452 VGND VPWR sky130_fd_sc_hd__tapvpwrvgnd_1
XTAP_463 VGND VPWR sky130_fd_sc_hd__tapvpwrvgnd_1
XTAP_485 VGND VPWR sky130_fd_sc_hd__tapvpwrvgnd_1
XTAP_474 VGND VPWR sky130_fd_sc_hd__tapvpwrvgnd_1
XTAP_496 VGND VPWR sky130_fd_sc_hd__tapvpwrvgnd_1
XFILLER_0_28_91 VGND VGND VPWR VPWR sky130_fd_sc_hd__fill_1
XTAP_1629 VGND VPWR sky130_fd_sc_hd__tapvpwrvgnd_1
XTAP_1618 VGND VPWR sky130_fd_sc_hd__tapvpwrvgnd_1
XTAP_1607 VGND VPWR sky130_fd_sc_hd__tapvpwrvgnd_1
X_7996_ clknet_leaf_63_clk _0085_ net195 VGND VGND VPWR VPWR u_sample_counter.sample_count\[19\]
+ sky130_fd_sc_hd__dfrtp_4
XFILLER_0_76_430 VGND VGND VPWR VPWR sky130_fd_sc_hd__decap_4
X_6947_ u_input_buffer.fifo_mem\[10\]\[3\] _3056_ _3058_ u_input_buffer.fifo_mem\[44\]\[3\]
+ _3195_ VGND VGND VPWR VPWR _3196_ sky130_fd_sc_hd__a221o_1
XFILLER_0_76_474 VGND VGND VPWR VPWR sky130_fd_sc_hd__fill_2
XFILLER_0_64_614 VGND VGND VPWR VPWR sky130_fd_sc_hd__decap_4
XFILLER_0_63_113 VGND VGND VPWR VPWR sky130_fd_sc_hd__fill_1
X_6878_ u_input_buffer.fifo_mem\[21\]\[2\] _2909_ _2913_ u_input_buffer.fifo_mem\[25\]\[2\]
+ VGND VGND VPWR VPWR _3128_ sky130_fd_sc_hd__a22o_1
X_8617_ clknet_leaf_106_clk _0706_ VGND VGND VPWR VPWR u_input_buffer.fifo_mem\[25\]\[15\]
+ sky130_fd_sc_hd__dfxtp_1
XFILLER_0_8_251 VGND VGND VPWR VPWR sky130_fd_sc_hd__fill_1
X_5829_ _1610_ net1037 _2443_ VGND VGND VPWR VPWR _2448_ sky130_fd_sc_hd__mux2_1
XFILLER_0_8_295 VGND VGND VPWR VPWR sky130_fd_sc_hd__fill_1
X_8548_ clknet_leaf_105_clk _0637_ VGND VGND VPWR VPWR u_input_buffer.fifo_mem\[29\]\[10\]
+ sky130_fd_sc_hd__dfxtp_1
X_8479_ clknet_leaf_20_clk _0568_ VGND VGND VPWR VPWR u_input_buffer.fifo_mem\[33\]\[5\]
+ sky130_fd_sc_hd__dfxtp_1
Xhold670 u_input_buffer.fifo_mem\[52\]\[1\] VGND VGND VPWR VPWR net882 sky130_fd_sc_hd__dlygate4sd3_1
Xhold681 u_input_buffer.fifo_mem\[9\]\[7\] VGND VGND VPWR VPWR net893 sky130_fd_sc_hd__dlygate4sd3_1
Xhold692 u_input_buffer.fifo_mem\[42\]\[11\] VGND VGND VPWR VPWR net904 sky130_fd_sc_hd__dlygate4sd3_1
XFILLER_0_99_511 VGND VGND VPWR VPWR sky130_fd_sc_hd__fill_1
XFILLER_0_115_29 VPWR VGND VPWR VGND sky130_ef_sc_hd__decap_12
XFILLER_0_86_216 VGND VGND VPWR VPWR sky130_fd_sc_hd__fill_1
XFILLER_0_24_38 VGND VGND VPWR VPWR sky130_fd_sc_hd__fill_2
XFILLER_0_39_110 VGND VGND VPWR VPWR sky130_fd_sc_hd__fill_2
XFILLER_0_67_430 VGND VGND VPWR VPWR sky130_fd_sc_hd__decap_4
XFILLER_0_40_26 VGND VGND VPWR VPWR sky130_fd_sc_hd__fill_2
XFILLER_0_63_680 VGND VGND VPWR VPWR sky130_fd_sc_hd__decap_6
XFILLER_0_112_229 VGND VGND VPWR VPWR sky130_fd_sc_hd__fill_2
XFILLER_0_2_427 VGND VGND VPWR VPWR sky130_fd_sc_hd__fill_1
XFILLER_0_105_292 VGND VGND VPWR VPWR sky130_fd_sc_hd__decap_3
XFILLER_0_105_281 VGND VGND VPWR VPWR sky130_fd_sc_hd__fill_2
XFILLER_0_50_363 VGND VGND VPWR VPWR sky130_fd_sc_hd__fill_1
X_4160_ _1469_ _1472_ _1320_ VGND VGND VPWR VPWR _1473_ sky130_fd_sc_hd__mux2_1
XFILLER_0_4_15 VPWR VGND VPWR VGND sky130_ef_sc_hd__decap_12
XFILLER_0_4_37 VGND VGND VPWR VPWR sky130_fd_sc_hd__decap_3
X_4091_ _1413_ VGND VGND VPWR VPWR _0055_ sky130_fd_sc_hd__clkbuf_1
XFILLER_0_4_59 VGND VGND VPWR VPWR sky130_fd_sc_hd__fill_1
X_7850_ _3924_ VGND VGND VPWR VPWR _1303_ sky130_fd_sc_hd__clkbuf_1
X_6801_ u_input_buffer.fifo_mem\[39\]\[0\] _3050_ _3052_ u_input_buffer.fifo_mem\[40\]\[0\]
+ VGND VGND VPWR VPWR _3053_ sky130_fd_sc_hd__a22o_1
XFILLER_0_105_51 VGND VGND VPWR VPWR sky130_fd_sc_hd__decap_4
X_7781_ net155 net1320 _1474_ VGND VGND VPWR VPWR _3888_ sky130_fd_sc_hd__mux2_1
X_4993_ _1463_ net831 _1970_ VGND VGND VPWR VPWR _1986_ sky130_fd_sc_hd__mux2_1
X_6732_ _2983_ VGND VGND VPWR VPWR _2984_ sky130_fd_sc_hd__clkbuf_4
XFILLER_0_58_474 VGND VGND VPWR VPWR sky130_fd_sc_hd__fill_2
XFILLER_0_46_603 VPWR VGND VPWR VGND sky130_ef_sc_hd__decap_12
X_3944_ net146 u_analytics_engine.threshold_cross VGND VGND VPWR VPWR _1321_ sky130_fd_sc_hd__or2_2
XFILLER_0_18_338 VGND VGND VPWR VPWR sky130_fd_sc_hd__decap_3
XFILLER_0_45_124 VGND VGND VPWR VPWR sky130_fd_sc_hd__fill_2
XFILLER_0_46_669 VGND VGND VPWR VPWR sky130_fd_sc_hd__fill_1
X_6663_ u_input_buffer.fifo_mem\[33\]\[0\] _2898_ _2904_ u_input_buffer.fifo_mem\[61\]\[0\]
+ _2914_ VGND VGND VPWR VPWR _2915_ sky130_fd_sc_hd__a221o_1
XFILLER_0_61_617 VGND VGND VPWR VPWR sky130_fd_sc_hd__decap_4
X_8402_ clknet_leaf_69_clk _0491_ VGND VGND VPWR VPWR u_input_buffer.fifo_mem\[38\]\[8\]
+ sky130_fd_sc_hd__dfxtp_1
X_5614_ _2332_ VGND VGND VPWR VPWR _2333_ sky130_fd_sc_hd__clkbuf_4
X_6594_ _2862_ _2863_ _2861_ VGND VGND VPWR VPWR _1108_ sky130_fd_sc_hd__o21a_1
XFILLER_0_103_229 VGND VGND VPWR VPWR sky130_fd_sc_hd__fill_1
XFILLER_0_103_207 VGND VGND VPWR VPWR sky130_fd_sc_hd__decap_6
X_8333_ clknet_leaf_29_clk _0422_ VGND VGND VPWR VPWR u_input_buffer.fifo_mem\[42\]\[3\]
+ sky130_fd_sc_hd__dfxtp_1
X_5545_ _1639_ _2295_ VGND VGND VPWR VPWR _2296_ sky130_fd_sc_hd__nand2_4
X_5476_ _1408_ VGND VGND VPWR VPWR _2254_ sky130_fd_sc_hd__clkbuf_4
X_8264_ clknet_leaf_75_clk _0353_ VGND VGND VPWR VPWR u_input_buffer.fifo_mem\[47\]\[14\]
+ sky130_fd_sc_hd__dfxtp_1
XFILLER_0_41_385 VGND VGND VPWR VPWR sky130_fd_sc_hd__fill_2
XFILLER_0_111_251 VGND VGND VPWR VPWR sky130_fd_sc_hd__decap_8
X_4427_ net825 _1614_ _1661_ VGND VGND VPWR VPWR _1668_ sky130_fd_sc_hd__mux2_1
X_8195_ clknet_leaf_14_clk _0284_ VGND VGND VPWR VPWR u_input_buffer.fifo_mem\[51\]\[9\]
+ sky130_fd_sc_hd__dfxtp_1
X_7215_ u_input_buffer.fifo_mem\[6\]\[10\] _3034_ _3036_ u_input_buffer.fifo_mem\[28\]\[10\]
+ _3456_ VGND VGND VPWR VPWR _3457_ sky130_fd_sc_hd__a221o_1
X_7146_ u_input_buffer.fifo_mem\[63\]\[8\] _2887_ _3076_ u_input_buffer.fifo_mem\[55\]\[8\]
+ _3389_ VGND VGND VPWR VPWR _3390_ sky130_fd_sc_hd__a221o_1
X_4358_ _1625_ VGND VGND VPWR VPWR _0110_ sky130_fd_sc_hd__clkbuf_1
XTAP_260 VGND VPWR sky130_fd_sc_hd__tapvpwrvgnd_1
X_4289_ _1565_ _1568_ VGND VGND VPWR VPWR _1569_ sky130_fd_sc_hd__nand2_1
XTAP_293 VGND VPWR sky130_fd_sc_hd__tapvpwrvgnd_1
XTAP_282 VGND VPWR sky130_fd_sc_hd__tapvpwrvgnd_1
XTAP_271 VGND VPWR sky130_fd_sc_hd__tapvpwrvgnd_1
X_7077_ u_input_buffer.fifo_mem\[53\]\[7\] _2934_ _2936_ u_input_buffer.fifo_mem\[57\]\[7\]
+ VGND VGND VPWR VPWR _3322_ sky130_fd_sc_hd__a22o_1
X_6028_ _2560_ VGND VGND VPWR VPWR _0845_ sky130_fd_sc_hd__clkbuf_1
XFILLER_0_68_205 VGND VGND VPWR VPWR sky130_fd_sc_hd__fill_1
XTAP_1415 VGND VPWR sky130_fd_sc_hd__tapvpwrvgnd_1
XTAP_1404 VGND VPWR sky130_fd_sc_hd__tapvpwrvgnd_1
XTAP_1437 VGND VPWR sky130_fd_sc_hd__tapvpwrvgnd_1
XTAP_1448 VGND VPWR sky130_fd_sc_hd__tapvpwrvgnd_1
XTAP_1426 VGND VPWR sky130_fd_sc_hd__tapvpwrvgnd_1
X_7979_ clknet_leaf_61_clk _0068_ net197 VGND VGND VPWR VPWR u_sample_counter.sample_count\[2\]
+ sky130_fd_sc_hd__dfrtp_1
XFILLER_0_49_452 VGND VGND VPWR VPWR sky130_fd_sc_hd__fill_2
XTAP_1459 VGND VPWR sky130_fd_sc_hd__tapvpwrvgnd_1
XFILLER_0_37_625 VGND VGND VPWR VPWR sky130_fd_sc_hd__fill_2
XFILLER_0_49_463 VGND VGND VPWR VPWR sky130_fd_sc_hd__fill_2
XFILLER_0_49_474 VGND VGND VPWR VPWR sky130_fd_sc_hd__decap_4
XFILLER_0_36_124 VGND VGND VPWR VPWR sky130_fd_sc_hd__fill_1
XFILLER_0_107_546 VGND VGND VPWR VPWR sky130_fd_sc_hd__decap_4
XFILLER_0_17_382 VGND VGND VPWR VPWR sky130_fd_sc_hd__decap_3
XFILLER_0_10_29 VPWR VGND VPWR VGND sky130_ef_sc_hd__decap_12
XFILLER_0_32_341 VGND VGND VPWR VPWR sky130_fd_sc_hd__fill_1
XFILLER_0_19_27 VPWR VGND VPWR VGND sky130_ef_sc_hd__decap_12
XFILLER_0_87_503 VGND VGND VPWR VPWR sky130_fd_sc_hd__fill_1
XFILLER_0_70_436 VGND VGND VPWR VPWR sky130_fd_sc_hd__fill_1
XFILLER_0_43_628 VGND VGND VPWR VPWR sky130_fd_sc_hd__decap_3
XFILLER_0_42_138 VGND VGND VPWR VPWR sky130_fd_sc_hd__fill_2
X_5330_ _2173_ VGND VGND VPWR VPWR _0534_ sky130_fd_sc_hd__clkbuf_1
XFILLER_0_11_503 VGND VGND VPWR VPWR sky130_fd_sc_hd__fill_1
X_5261_ _1397_ net1064 _2133_ VGND VGND VPWR VPWR _2137_ sky130_fd_sc_hd__mux2_1
X_4212_ u_sample_counter.sample_count\[16\] u_sample_counter.sample_count\[17\] VGND
+ VGND VPWR VPWR _1506_ sky130_fd_sc_hd__and2_1
X_7000_ u_input_buffer.fifo_mem\[17\]\[5\] _2943_ _2945_ u_input_buffer.fifo_mem\[5\]\[5\]
+ VGND VGND VPWR VPWR _3247_ sky130_fd_sc_hd__a22o_1
X_5192_ _2100_ VGND VGND VPWR VPWR _0469_ sky130_fd_sc_hd__clkbuf_1
XFILLER_0_76_88 VGND VGND VPWR VPWR sky130_fd_sc_hd__fill_2
XFILLER_0_76_77 VGND VGND VPWR VPWR sky130_fd_sc_hd__fill_1
X_4143_ u_sensor_interface.sensor_array\[0\]\[13\] u_sensor_interface.sensor_array\[1\]\[13\]
+ net111 VGND VGND VPWR VPWR _1458_ sky130_fd_sc_hd__mux2_1
X_4074_ _1398_ u_sensor_interface.sensor_array\[2\]\[3\] _1379_ VGND VGND VPWR VPWR
+ _1399_ sky130_fd_sc_hd__mux2_1
X_8951_ clknet_leaf_8_clk _1040_ VGND VGND VPWR VPWR u_input_buffer.fifo_mem\[4\]\[13\]
+ sky130_fd_sc_hd__dfxtp_1
X_7902_ clknet_leaf_62_clk net230 net195 VGND VGND VPWR VPWR u_register_bank.status_flags\[22\]
+ sky130_fd_sc_hd__dfrtp_1
XFILLER_0_92_65 VGND VGND VPWR VPWR sky130_fd_sc_hd__decap_8
X_8882_ clknet_leaf_77_clk _0971_ VGND VGND VPWR VPWR u_input_buffer.fifo_mem\[8\]\[8\]
+ sky130_fd_sc_hd__dfxtp_1
X_7833_ _3915_ VGND VGND VPWR VPWR _1295_ sky130_fd_sc_hd__clkbuf_1
X_7764_ u_register_bank.window_cfg\[28\] _3847_ _3848_ u_register_bank.threshold_cfg\[28\]
+ _3875_ VGND VGND VPWR VPWR _3876_ sky130_fd_sc_hd__a221o_1
X_4976_ _1977_ VGND VGND VPWR VPWR _0376_ sky130_fd_sc_hd__clkbuf_1
X_6715_ u_input_buffer.rd_ptr\[0\] u_input_buffer.rd_ptr\[1\] u_input_buffer.rd_ptr\[3\]
+ u_input_buffer.rd_ptr\[2\] VGND VGND VPWR VPWR _2967_ sky130_fd_sc_hd__or4_4
XFILLER_0_73_241 VGND VGND VPWR VPWR sky130_fd_sc_hd__decap_6
X_7695_ u_register_bank.window_cfg\[12\] _3812_ _3813_ u_analytics_engine.threshold\[12\]
+ _3822_ VGND VGND VPWR VPWR _3823_ sky130_fd_sc_hd__a221o_1
X_6646_ _2897_ VGND VGND VPWR VPWR _2898_ sky130_fd_sc_hd__clkbuf_4
X_6577_ net775 _1438_ _2842_ VGND VGND VPWR VPWR _2854_ sky130_fd_sc_hd__mux2_1
X_8316_ clknet_leaf_33_clk _0405_ VGND VGND VPWR VPWR u_input_buffer.fifo_mem\[43\]\[2\]
+ sky130_fd_sc_hd__dfxtp_1
X_5528_ _2286_ VGND VGND VPWR VPWR _0619_ sky130_fd_sc_hd__clkbuf_1
XFILLER_0_112_560 VPWR VGND VPWR VGND sky130_ef_sc_hd__decap_12
XFILLER_0_14_396 VGND VGND VPWR VPWR sky130_fd_sc_hd__decap_8
X_8247_ clknet_leaf_9_clk _0336_ VGND VGND VPWR VPWR u_input_buffer.fifo_mem\[48\]\[13\]
+ sky130_fd_sc_hd__dfxtp_1
X_5459_ _2241_ VGND VGND VPWR VPWR _2242_ sky130_fd_sc_hd__buf_8
Xfanout210 net211 VGND VGND VPWR VPWR net210 sky130_fd_sc_hd__clkbuf_4
X_8178_ clknet_leaf_73_clk _0267_ VGND VGND VPWR VPWR u_input_buffer.fifo_mem\[52\]\[8\]
+ sky130_fd_sc_hd__dfxtp_1
X_7129_ _3357_ _3359_ _3363_ _3372_ VGND VGND VPWR VPWR _3373_ sky130_fd_sc_hd__or4_2
XTAP_1223 VGND VPWR sky130_fd_sc_hd__tapvpwrvgnd_1
XTAP_1201 VGND VPWR sky130_fd_sc_hd__tapvpwrvgnd_1
XTAP_1212 VGND VPWR sky130_fd_sc_hd__tapvpwrvgnd_1
XFILLER_0_69_569 VGND VGND VPWR VPWR sky130_fd_sc_hd__decap_3
XFILLER_0_69_558 VGND VGND VPWR VPWR sky130_fd_sc_hd__fill_2
XTAP_1256 VGND VPWR sky130_fd_sc_hd__tapvpwrvgnd_1
XTAP_1245 VGND VPWR sky130_fd_sc_hd__tapvpwrvgnd_1
XTAP_1234 VGND VPWR sky130_fd_sc_hd__tapvpwrvgnd_1
XFILLER_0_56_208 VGND VGND VPWR VPWR sky130_fd_sc_hd__fill_1
XTAP_1289 VGND VPWR sky130_fd_sc_hd__tapvpwrvgnd_1
XTAP_1267 VGND VPWR sky130_fd_sc_hd__tapvpwrvgnd_1
XTAP_1278 VGND VPWR sky130_fd_sc_hd__tapvpwrvgnd_1
XFILLER_0_25_617 VGND VGND VPWR VPWR sky130_fd_sc_hd__decap_6
XFILLER_0_64_296 VGND VGND VPWR VPWR sky130_fd_sc_hd__decap_3
XFILLER_0_9_390 VGND VGND VPWR VPWR sky130_fd_sc_hd__fill_2
XFILLER_0_52_436 VGND VGND VPWR VPWR sky130_fd_sc_hd__fill_2
XFILLER_0_60_480 VGND VGND VPWR VPWR sky130_fd_sc_hd__fill_1
X_4830_ _1897_ VGND VGND VPWR VPWR _0310_ sky130_fd_sc_hd__clkbuf_1
X_4761_ net579 _1712_ _1855_ VGND VGND VPWR VPWR _1860_ sky130_fd_sc_hd__mux2_1
X_6500_ _2813_ VGND VGND VPWR VPWR _1064_ sky130_fd_sc_hd__clkbuf_1
X_7480_ _3689_ VGND VGND VPWR VPWR _1168_ sky130_fd_sc_hd__clkbuf_1
X_4692_ _1822_ VGND VGND VPWR VPWR _0247_ sky130_fd_sc_hd__clkbuf_1
XFILLER_0_102_41 VPWR VGND VPWR VGND sky130_ef_sc_hd__decap_12
X_6431_ net624 _1408_ _2771_ VGND VGND VPWR VPWR _2777_ sky130_fd_sc_hd__mux2_1
X_6362_ _2740_ VGND VGND VPWR VPWR _0999_ sky130_fd_sc_hd__clkbuf_1
XFILLER_0_102_85 VPWR VGND VPWR VGND sky130_ef_sc_hd__decap_12
X_9150_ net179 _1238_ VGND VGND VPWR VPWR net114 sky130_fd_sc_hd__dfxtp_1
X_8101_ clknet_leaf_108_clk _0190_ VGND VGND VPWR VPWR u_input_buffer.fifo_mem\[57\]\[11\]
+ sky130_fd_sc_hd__dfxtp_1
X_5313_ net371 _2014_ _2150_ VGND VGND VPWR VPWR _2164_ sky130_fd_sc_hd__mux2_1
X_6293_ _2703_ VGND VGND VPWR VPWR _0967_ sky130_fd_sc_hd__clkbuf_1
XFILLER_0_60_6 VGND VGND VPWR VPWR sky130_fd_sc_hd__fill_2
X_9081_ clknet_leaf_90_clk _1169_ VGND VGND VPWR VPWR u_input_buffer.fifo_mem\[63\]\[11\]
+ sky130_fd_sc_hd__dfxtp_1
X_5244_ _2127_ VGND VGND VPWR VPWR _0494_ sky130_fd_sc_hd__clkbuf_1
X_8032_ clknet_leaf_7_clk _0121_ VGND VGND VPWR VPWR u_input_buffer.fifo_mem\[61\]\[6\]
+ sky130_fd_sc_hd__dfxtp_1
Xhold18 u_sample_counter.sample_count\[22\] VGND VGND VPWR VPWR net230 sky130_fd_sc_hd__dlygate4sd3_1
X_5175_ _2090_ VGND VGND VPWR VPWR _0462_ sky130_fd_sc_hd__clkbuf_1
Xhold29 u_sample_counter.sample_count\[12\] VGND VGND VPWR VPWR net241 sky130_fd_sc_hd__dlygate4sd3_1
X_4126_ _1443_ VGND VGND VPWR VPWR _0060_ sky130_fd_sc_hd__clkbuf_1
X_4057_ u_input_buffer.data_in\[1\] VGND VGND VPWR VPWR _1384_ sky130_fd_sc_hd__clkbuf_4
X_8934_ clknet_leaf_109_clk _1023_ VGND VGND VPWR VPWR u_input_buffer.fifo_mem\[5\]\[12\]
+ sky130_fd_sc_hd__dfxtp_1
XFILLER_0_36_80 VGND VGND VPWR VPWR sky130_fd_sc_hd__fill_1
X_8865_ clknet_leaf_19_clk _0954_ VGND VGND VPWR VPWR u_input_buffer.fifo_mem\[9\]\[7\]
+ sky130_fd_sc_hd__dfxtp_1
X_7816_ net23 u_register_bank.sensor_enable\[1\] _3905_ VGND VGND VPWR VPWR _3907_
+ sky130_fd_sc_hd__mux2_1
X_8796_ clknet_leaf_3_clk _0885_ VGND VGND VPWR VPWR u_input_buffer.fifo_mem\[13\]\[2\]
+ sky130_fd_sc_hd__dfxtp_1
X_7747_ u_register_bank.status_flags\[24\] _3849_ _3843_ u_register_bank.sensor_enable\[24\]
+ VGND VGND VPWR VPWR _3863_ sky130_fd_sc_hd__a22o_1
X_4959_ _1967_ VGND VGND VPWR VPWR _0369_ sky130_fd_sc_hd__clkbuf_1
X_7678_ u_register_bank.status_flags\[9\] _3775_ _3808_ u_register_bank.sensor_enable\[9\]
+ VGND VGND VPWR VPWR _3809_ sky130_fd_sc_hd__a22o_1
XFILLER_0_104_313 VGND VGND VPWR VPWR sky130_fd_sc_hd__fill_2
X_6629_ _2861_ _2887_ _2883_ _2885_ VGND VGND VPWR VPWR _1119_ sky130_fd_sc_hd__o2bb2a_1
XFILLER_0_100_530 VGND VGND VPWR VPWR sky130_fd_sc_hd__fill_2
XFILLER_0_100_585 VGND VGND VPWR VPWR sky130_fd_sc_hd__decap_3
XFILLER_0_89_609 VGND VGND VPWR VPWR sky130_fd_sc_hd__decap_4
XFILLER_0_97_642 VGND VGND VPWR VPWR sky130_fd_sc_hd__decap_8
XFILLER_0_96_163 VGND VGND VPWR VPWR sky130_fd_sc_hd__fill_1
XFILLER_0_96_141 VGND VGND VPWR VPWR sky130_fd_sc_hd__decap_6
XTAP_1031 VGND VPWR sky130_fd_sc_hd__tapvpwrvgnd_1
XTAP_1020 VGND VPWR sky130_fd_sc_hd__tapvpwrvgnd_1
XTAP_1064 VGND VPWR sky130_fd_sc_hd__tapvpwrvgnd_1
XTAP_1042 VGND VPWR sky130_fd_sc_hd__tapvpwrvgnd_1
XTAP_1053 VGND VPWR sky130_fd_sc_hd__tapvpwrvgnd_1
XTAP_1097 VGND VPWR sky130_fd_sc_hd__tapvpwrvgnd_1
XTAP_1086 VGND VPWR sky130_fd_sc_hd__tapvpwrvgnd_1
XTAP_1075 VGND VPWR sky130_fd_sc_hd__tapvpwrvgnd_1
XFILLER_0_108_630 VPWR VGND VPWR VGND sky130_ef_sc_hd__decap_12
XFILLER_0_25_458 VGND VGND VPWR VPWR sky130_fd_sc_hd__fill_1
XFILLER_0_0_525 VGND VGND VPWR VPWR sky130_fd_sc_hd__decap_6
XFILLER_0_21_642 VPWR VGND VPWR VGND sky130_ef_sc_hd__decap_12
XFILLER_0_0_558 VGND VGND VPWR VPWR sky130_fd_sc_hd__fill_2
XTAP_815 VGND VPWR sky130_fd_sc_hd__tapvpwrvgnd_1
XTAP_804 VGND VPWR sky130_fd_sc_hd__tapvpwrvgnd_1
XTAP_826 VGND VPWR sky130_fd_sc_hd__tapvpwrvgnd_1
XFILLER_0_57_68 VGND VGND VPWR VPWR sky130_fd_sc_hd__decap_4
XFILLER_0_57_57 VGND VGND VPWR VPWR sky130_fd_sc_hd__decap_8
XTAP_837 VGND VPWR sky130_fd_sc_hd__tapvpwrvgnd_1
XTAP_848 VGND VPWR sky130_fd_sc_hd__tapvpwrvgnd_1
XTAP_859 VGND VPWR sky130_fd_sc_hd__tapvpwrvgnd_1
X_6980_ u_input_buffer.fifo_mem\[52\]\[4\] _3039_ _3041_ u_input_buffer.fifo_mem\[56\]\[4\]
+ VGND VGND VPWR VPWR _3228_ sky130_fd_sc_hd__a22o_1
X_5931_ _2503_ VGND VGND VPWR VPWR _0805_ sky130_fd_sc_hd__clkbuf_1
X_8650_ clknet_leaf_53_clk _0739_ VGND VGND VPWR VPWR u_input_buffer.fifo_mem\[22\]\[0\]
+ sky130_fd_sc_hd__dfxtp_1
X_5862_ _2465_ VGND VGND VPWR VPWR _0774_ sky130_fd_sc_hd__clkbuf_1
XFILLER_0_87_196 VGND VGND VPWR VPWR sky130_fd_sc_hd__fill_1
X_5793_ net465 _2250_ _2425_ VGND VGND VPWR VPWR _2429_ sky130_fd_sc_hd__mux2_1
XFILLER_0_8_625 VPWR VGND VPWR VGND sky130_ef_sc_hd__decap_12
X_7601_ net20 u_register_bank.threshold_cfg\[17\] _3748_ VGND VGND VPWR VPWR _3756_
+ sky130_fd_sc_hd__mux2_1
X_8581_ clknet_leaf_91_clk _0670_ VGND VGND VPWR VPWR u_input_buffer.fifo_mem\[27\]\[11\]
+ sky130_fd_sc_hd__dfxtp_1
X_4813_ _1887_ VGND VGND VPWR VPWR _0303_ sky130_fd_sc_hd__clkbuf_1
XFILLER_0_113_51 VGND VGND VPWR VPWR sky130_fd_sc_hd__decap_4
XFILLER_0_8_669 VPWR VGND VPWR VGND sky130_ef_sc_hd__decap_12
X_7532_ net20 u_register_bank.window_cfg\[17\] _3711_ VGND VGND VPWR VPWR _3719_ sky130_fd_sc_hd__mux2_1
XFILLER_0_43_200 VGND VGND VPWR VPWR sky130_fd_sc_hd__fill_1
X_4744_ net531 _1730_ _1835_ VGND VGND VPWR VPWR _1850_ sky130_fd_sc_hd__mux2_1
X_7463_ net898 _1390_ _3678_ VGND VGND VPWR VPWR _3681_ sky130_fd_sc_hd__mux2_1
XFILLER_0_98_53 VPWR VGND VPWR VGND sky130_ef_sc_hd__decap_12
XFILLER_0_71_564 VGND VGND VPWR VPWR sky130_fd_sc_hd__fill_1
X_9202_ net175 _1289_ net207 VGND VGND VPWR VPWR u_register_bank.sensor_enable\[3\]
+ sky130_fd_sc_hd__dfrtp_1
X_4675_ _1812_ VGND VGND VPWR VPWR _0240_ sky130_fd_sc_hd__clkbuf_1
XFILLER_0_114_677 VGND VGND VPWR VPWR sky130_fd_sc_hd__fill_1
X_6414_ _2767_ VGND VGND VPWR VPWR _1024_ sky130_fd_sc_hd__clkbuf_1
X_7394_ u_input_buffer.fifo_mem\[36\]\[15\] _2950_ _2954_ u_input_buffer.fifo_mem\[35\]\[15\]
+ _3630_ VGND VGND VPWR VPWR _3631_ sky130_fd_sc_hd__a221o_1
XFILLER_0_12_642 VGND VGND VPWR VPWR sky130_fd_sc_hd__fill_2
X_9133_ net168 _1221_ net201 VGND VGND VPWR VPWR u_analytics_engine.threshold\[15\]
+ sky130_fd_sc_hd__dfrtp_1
X_6345_ net970 _2524_ _2716_ VGND VGND VPWR VPWR _2731_ sky130_fd_sc_hd__mux2_1
X_9064_ clknet_leaf_110_clk _1153_ VGND VGND VPWR VPWR u_sensor_interface.sensor_array\[3\]\[11\]
+ sky130_fd_sc_hd__dfxtp_1
X_6276_ _1628_ net1238 _2679_ VGND VGND VPWR VPWR _2694_ sky130_fd_sc_hd__mux2_1
Xinput108 sensor_data_in[8] VGND VGND VPWR VPWR net108 sky130_fd_sc_hd__buf_1
X_8015_ clknet_leaf_45_clk _0104_ VGND VGND VPWR VPWR u_input_buffer.fifo_mem\[62\]\[5\]
+ sky130_fd_sc_hd__dfxtp_1
X_5227_ net1254 _1996_ _2115_ VGND VGND VPWR VPWR _2119_ sky130_fd_sc_hd__mux2_1
X_5158_ net859 _1996_ _2078_ VGND VGND VPWR VPWR _2082_ sky130_fd_sc_hd__mux2_1
X_5089_ _2045_ VGND VGND VPWR VPWR _0421_ sky130_fd_sc_hd__clkbuf_1
X_4109_ _1428_ u_sensor_interface.sensor_array\[2\]\[8\] _1379_ VGND VGND VPWR VPWR
+ _1429_ sky130_fd_sc_hd__mux2_1
XFILLER_0_79_653 VPWR VGND VPWR VGND sky130_ef_sc_hd__decap_12
X_8917_ clknet_leaf_75_clk _1006_ VGND VGND VPWR VPWR u_input_buffer.fifo_mem\[6\]\[11\]
+ sky130_fd_sc_hd__dfxtp_1
XFILLER_0_94_601 VGND VGND VPWR VPWR sky130_fd_sc_hd__decap_6
X_8848_ clknet_leaf_35_clk _0937_ VGND VGND VPWR VPWR u_input_buffer.fifo_mem\[10\]\[6\]
+ sky130_fd_sc_hd__dfxtp_1
XPHY_125 VGND VGND VPWR VPWR sky130_fd_sc_hd__decap_3
XPHY_114 VGND VGND VPWR VPWR sky130_fd_sc_hd__decap_3
XPHY_103 VGND VGND VPWR VPWR sky130_fd_sc_hd__decap_3
X_8779_ clknet_leaf_27_clk _0868_ VGND VGND VPWR VPWR u_input_buffer.fifo_mem\[14\]\[1\]
+ sky130_fd_sc_hd__dfxtp_1
XPHY_158 VGND VGND VPWR VPWR sky130_fd_sc_hd__decap_3
XPHY_147 VGND VGND VPWR VPWR sky130_fd_sc_hd__decap_3
XPHY_136 VGND VGND VPWR VPWR sky130_fd_sc_hd__decap_3
XFILLER_0_93_166 VGND VGND VPWR VPWR sky130_fd_sc_hd__fill_2
XPHY_169 VGND VGND VPWR VPWR sky130_fd_sc_hd__decap_3
XFILLER_0_62_531 VGND VGND VPWR VPWR sky130_fd_sc_hd__fill_1
XFILLER_0_69_185 VGND VGND VPWR VPWR sky130_fd_sc_hd__fill_1
XPHY_5 VGND VGND VPWR VPWR sky130_fd_sc_hd__decap_3
XFILLER_0_84_166 VGND VGND VPWR VPWR sky130_fd_sc_hd__fill_1
XFILLER_0_65_391 VGND VGND VPWR VPWR sky130_fd_sc_hd__fill_1
XFILLER_0_5_617 VPWR VGND VPWR VGND sky130_ef_sc_hd__decap_12
XFILLER_0_80_361 VGND VGND VPWR VPWR sky130_fd_sc_hd__decap_3
XFILLER_0_13_417 VGND VGND VPWR VPWR sky130_fd_sc_hd__fill_2
XFILLER_0_53_553 VGND VGND VPWR VPWR sky130_fd_sc_hd__fill_1
XFILLER_0_80_383 VGND VGND VPWR VPWR sky130_fd_sc_hd__decap_6
X_4460_ _1687_ VGND VGND VPWR VPWR _0150_ sky130_fd_sc_hd__clkbuf_1
Xhold307 u_input_buffer.fifo_mem\[20\]\[14\] VGND VGND VPWR VPWR net519 sky130_fd_sc_hd__dlygate4sd3_1
Xhold318 u_input_buffer.fifo_mem\[46\]\[12\] VGND VGND VPWR VPWR net530 sky130_fd_sc_hd__dlygate4sd3_1
Xhold329 u_input_buffer.fifo_mem\[29\]\[7\] VGND VGND VPWR VPWR net541 sky130_fd_sc_hd__dlygate4sd3_1
X_4391_ _1415_ net1175 _1641_ VGND VGND VPWR VPWR _1648_ sky130_fd_sc_hd__mux2_1
XFILLER_0_110_135 VGND VGND VPWR VPWR sky130_fd_sc_hd__decap_4
XFILLER_0_68_78 VGND VGND VPWR VPWR sky130_fd_sc_hd__decap_3
X_6130_ _2616_ VGND VGND VPWR VPWR _0891_ sky130_fd_sc_hd__clkbuf_1
XFILLER_0_0_377 VGND VGND VPWR VPWR sky130_fd_sc_hd__decap_4
XFILLER_0_0_388 VGND VGND VPWR VPWR sky130_fd_sc_hd__decap_4
XTAP_601 VGND VPWR sky130_fd_sc_hd__tapvpwrvgnd_1
XTAP_612 VGND VPWR sky130_fd_sc_hd__tapvpwrvgnd_1
XTAP_623 VGND VPWR sky130_fd_sc_hd__tapvpwrvgnd_1
XTAP_634 VGND VPWR sky130_fd_sc_hd__tapvpwrvgnd_1
X_6061_ net348 _2516_ _2569_ VGND VGND VPWR VPWR _2579_ sky130_fd_sc_hd__mux2_1
XTAP_656 VGND VPWR sky130_fd_sc_hd__tapvpwrvgnd_1
XTAP_645 VGND VPWR sky130_fd_sc_hd__tapvpwrvgnd_1
XTAP_667 VGND VPWR sky130_fd_sc_hd__tapvpwrvgnd_1
X_5012_ net793 _1998_ _1990_ VGND VGND VPWR VPWR _1999_ sky130_fd_sc_hd__mux2_1
Xhold1029 u_input_buffer.fifo_mem\[45\]\[3\] VGND VGND VPWR VPWR net1241 sky130_fd_sc_hd__dlygate4sd3_1
Xhold1007 u_input_buffer.fifo_mem\[20\]\[12\] VGND VGND VPWR VPWR net1219 sky130_fd_sc_hd__dlygate4sd3_1
Xhold1018 u_input_buffer.fifo_mem\[29\]\[5\] VGND VGND VPWR VPWR net1230 sky130_fd_sc_hd__dlygate4sd3_1
XTAP_678 VGND VPWR sky130_fd_sc_hd__tapvpwrvgnd_1
XTAP_689 VGND VPWR sky130_fd_sc_hd__tapvpwrvgnd_1
X_6963_ u_input_buffer.fifo_mem\[1\]\[4\] _2932_ _3208_ _3210_ VGND VGND VPWR VPWR
+ _3211_ sky130_fd_sc_hd__a211o_1
X_6894_ _3137_ _3139_ _3141_ _3143_ VGND VGND VPWR VPWR _3144_ sky130_fd_sc_hd__or4_2
X_8702_ clknet_leaf_66_clk _0791_ VGND VGND VPWR VPWR u_input_buffer.fifo_mem\[19\]\[4\]
+ sky130_fd_sc_hd__dfxtp_1
XFILLER_0_75_111 VGND VGND VPWR VPWR sky130_fd_sc_hd__fill_1
X_5914_ _2492_ VGND VGND VPWR VPWR _0799_ sky130_fd_sc_hd__clkbuf_1
X_5845_ _1626_ net955 _2442_ VGND VGND VPWR VPWR _2456_ sky130_fd_sc_hd__mux2_1
X_8633_ clknet_leaf_74_clk _0722_ VGND VGND VPWR VPWR u_input_buffer.fifo_mem\[24\]\[15\]
+ sky130_fd_sc_hd__dfxtp_1
XFILLER_0_36_509 VGND VGND VPWR VPWR sky130_fd_sc_hd__fill_1
XFILLER_0_75_166 VGND VGND VPWR VPWR sky130_fd_sc_hd__fill_2
XFILLER_0_29_572 VGND VGND VPWR VPWR sky130_fd_sc_hd__fill_2
X_5776_ _2419_ VGND VGND VPWR VPWR _0734_ sky130_fd_sc_hd__clkbuf_1
X_8564_ clknet_leaf_72_clk _0653_ VGND VGND VPWR VPWR u_input_buffer.fifo_mem\[28\]\[10\]
+ sky130_fd_sc_hd__dfxtp_1
X_4727_ _1841_ VGND VGND VPWR VPWR _0263_ sky130_fd_sc_hd__clkbuf_1
X_8495_ clknet_leaf_29_clk _0584_ VGND VGND VPWR VPWR u_input_buffer.fifo_mem\[32\]\[5\]
+ sky130_fd_sc_hd__dfxtp_1
X_7515_ net43 u_register_bank.window_cfg\[9\] _3700_ VGND VGND VPWR VPWR _3710_ sky130_fd_sc_hd__mux2_1
X_4658_ net739 _1714_ _1798_ VGND VGND VPWR VPWR _1804_ sky130_fd_sc_hd__mux2_1
X_7446_ _3671_ VGND VGND VPWR VPWR _1152_ sky130_fd_sc_hd__clkbuf_1
Xinput90 sensor_data_in[4] VGND VGND VPWR VPWR net90 sky130_fd_sc_hd__clkbuf_1
XFILLER_0_114_474 VGND VGND VPWR VPWR sky130_fd_sc_hd__fill_2
Xhold830 u_input_buffer.fifo_mem\[51\]\[1\] VGND VGND VPWR VPWR net1042 sky130_fd_sc_hd__dlygate4sd3_1
X_4589_ net776 _1718_ _1757_ VGND VGND VPWR VPWR _1765_ sky130_fd_sc_hd__mux2_1
Xhold863 u_input_buffer.fifo_mem\[22\]\[4\] VGND VGND VPWR VPWR net1075 sky130_fd_sc_hd__dlygate4sd3_1
Xhold852 u_input_buffer.fifo_mem\[37\]\[3\] VGND VGND VPWR VPWR net1064 sky130_fd_sc_hd__dlygate4sd3_1
Xhold841 u_input_buffer.fifo_mem\[41\]\[7\] VGND VGND VPWR VPWR net1053 sky130_fd_sc_hd__dlygate4sd3_1
X_7377_ u_input_buffer.fifo_mem\[3\]\[14\] _3069_ _3071_ u_input_buffer.fifo_mem\[60\]\[14\]
+ VGND VGND VPWR VPWR _3615_ sky130_fd_sc_hd__a22o_1
X_9116_ net172 _1204_ net203 VGND VGND VPWR VPWR u_register_bank.window_cfg\[30\]
+ sky130_fd_sc_hd__dfrtp_1
X_6328_ _2722_ VGND VGND VPWR VPWR _0983_ sky130_fd_sc_hd__clkbuf_1
Xhold885 u_input_buffer.fifo_mem\[50\]\[2\] VGND VGND VPWR VPWR net1097 sky130_fd_sc_hd__dlygate4sd3_1
Xhold874 u_input_buffer.fifo_mem\[37\]\[0\] VGND VGND VPWR VPWR net1086 sky130_fd_sc_hd__dlygate4sd3_1
Xhold896 u_input_buffer.fifo_mem\[22\]\[15\] VGND VGND VPWR VPWR net1108 sky130_fd_sc_hd__dlygate4sd3_1
X_6259_ _2685_ VGND VGND VPWR VPWR _0951_ sky130_fd_sc_hd__clkbuf_1
X_9047_ clknet_leaf_72_clk _1136_ VGND VGND VPWR VPWR u_analytics_engine.data_in\[10\]
+ sky130_fd_sc_hd__dfxtp_1
XFILLER_0_86_409 VGND VGND VPWR VPWR sky130_fd_sc_hd__fill_1
XFILLER_0_66_155 VGND VGND VPWR VPWR sky130_fd_sc_hd__fill_1
XFILLER_0_109_279 VGND VGND VPWR VPWR sky130_fd_sc_hd__fill_1
XFILLER_0_81_125 VGND VGND VPWR VPWR sky130_fd_sc_hd__decap_4
XFILLER_0_81_169 VGND VGND VPWR VPWR sky130_fd_sc_hd__decap_6
XFILLER_0_1_108 VGND VGND VPWR VPWR sky130_fd_sc_hd__fill_1
XFILLER_0_89_225 VGND VGND VPWR VPWR sky130_fd_sc_hd__fill_1
X_3960_ u_sensor_interface.sensor_array\[2\]\[6\] net77 _1323_ VGND VGND VPWR VPWR
+ _1330_ sky130_fd_sc_hd__mux2_1
XFILLER_0_58_612 VGND VGND VPWR VPWR sky130_fd_sc_hd__fill_2
XFILLER_0_57_111 VGND VGND VPWR VPWR sky130_fd_sc_hd__fill_1
XFILLER_0_85_464 VGND VGND VPWR VPWR sky130_fd_sc_hd__fill_1
XFILLER_0_73_637 VGND VGND VPWR VPWR sky130_fd_sc_hd__fill_1
XFILLER_0_73_615 VGND VGND VPWR VPWR sky130_fd_sc_hd__fill_1
X_5630_ net916 _2258_ _2334_ VGND VGND VPWR VPWR _2342_ sky130_fd_sc_hd__mux2_1
XFILLER_0_57_188 VGND VGND VPWR VPWR sky130_fd_sc_hd__fill_2
XFILLER_0_115_238 VGND VGND VPWR VPWR sky130_fd_sc_hd__decap_8
X_5561_ _1421_ net541 _2297_ VGND VGND VPWR VPWR _2305_ sky130_fd_sc_hd__mux2_1
X_4512_ _1719_ VGND VGND VPWR VPWR _0170_ sky130_fd_sc_hd__clkbuf_1
XFILLER_0_13_225 VGND VGND VPWR VPWR sky130_fd_sc_hd__decap_3
X_7300_ u_input_buffer.fifo_mem\[26\]\[12\] _3065_ _3067_ u_input_buffer.fifo_mem\[62\]\[12\]
+ _3539_ VGND VGND VPWR VPWR _3540_ sky130_fd_sc_hd__a221o_1
XFILLER_0_5_469 VPWR VGND VPWR VGND sky130_ef_sc_hd__decap_12
X_8280_ clknet_leaf_101_clk _0369_ VGND VGND VPWR VPWR u_input_buffer.fifo_mem\[46\]\[14\]
+ sky130_fd_sc_hd__dfxtp_1
X_5492_ net369 _2264_ _2243_ VGND VGND VPWR VPWR _2265_ sky130_fd_sc_hd__mux2_1
XFILLER_0_110_41 VPWR VGND VPWR VGND sky130_ef_sc_hd__decap_12
XFILLER_0_79_66 VGND VGND VPWR VPWR sky130_fd_sc_hd__fill_1
Xhold115 u_input_buffer.fifo_mem\[16\]\[4\] VGND VGND VPWR VPWR net327 sky130_fd_sc_hd__dlygate4sd3_1
Xhold104 u_input_buffer.fifo_mem\[4\]\[8\] VGND VGND VPWR VPWR net316 sky130_fd_sc_hd__dlygate4sd3_1
Xhold126 u_input_buffer.fifo_mem\[54\]\[10\] VGND VGND VPWR VPWR net338 sky130_fd_sc_hd__dlygate4sd3_1
X_7231_ u_input_buffer.fifo_mem\[37\]\[11\] _2922_ _2925_ u_input_buffer.fifo_mem\[9\]\[11\]
+ VGND VGND VPWR VPWR _3472_ sky130_fd_sc_hd__a22o_1
XFILLER_0_41_567 VGND VGND VPWR VPWR sky130_fd_sc_hd__fill_1
XFILLER_0_110_85 VPWR VGND VPWR VGND sky130_ef_sc_hd__decap_12
Xhold137 u_input_buffer.fifo_mem\[14\]\[3\] VGND VGND VPWR VPWR net349 sky130_fd_sc_hd__dlygate4sd3_1
X_4443_ net1263 _1630_ _1660_ VGND VGND VPWR VPWR _1676_ sky130_fd_sc_hd__mux2_1
XFILLER_0_1_653 VPWR VGND VPWR VGND sky130_ef_sc_hd__decap_12
Xhold159 u_input_buffer.fifo_mem\[36\]\[12\] VGND VGND VPWR VPWR net371 sky130_fd_sc_hd__dlygate4sd3_1
Xhold148 u_input_buffer.fifo_mem\[32\]\[14\] VGND VGND VPWR VPWR net360 sky130_fd_sc_hd__dlygate4sd3_1
XFILLER_0_111_466 VGND VGND VPWR VPWR sky130_fd_sc_hd__fill_1
X_7162_ u_input_buffer.fifo_mem\[34\]\[9\] _2966_ _2969_ u_input_buffer.fifo_mem\[48\]\[9\]
+ _3404_ VGND VGND VPWR VPWR _3405_ sky130_fd_sc_hd__a221o_1
XFILLER_0_0_141 VGND VGND VPWR VPWR sky130_fd_sc_hd__fill_1
X_4374_ _1636_ VGND VGND VPWR VPWR _1637_ sky130_fd_sc_hd__buf_2
X_7093_ u_input_buffer.fifo_mem\[31\]\[7\] _3017_ _3020_ u_input_buffer.fifo_mem\[38\]\[7\]
+ VGND VGND VPWR VPWR _3338_ sky130_fd_sc_hd__a22o_1
XTAP_420 VGND VPWR sky130_fd_sc_hd__tapvpwrvgnd_1
XTAP_431 VGND VPWR sky130_fd_sc_hd__tapvpwrvgnd_1
XTAP_442 VGND VPWR sky130_fd_sc_hd__tapvpwrvgnd_1
X_6113_ _1588_ net885 _2607_ VGND VGND VPWR VPWR _2608_ sky130_fd_sc_hd__mux2_1
X_6044_ _2570_ VGND VGND VPWR VPWR _0851_ sky130_fd_sc_hd__clkbuf_1
XTAP_453 VGND VPWR sky130_fd_sc_hd__tapvpwrvgnd_1
XTAP_464 VGND VPWR sky130_fd_sc_hd__tapvpwrvgnd_1
XTAP_475 VGND VPWR sky130_fd_sc_hd__tapvpwrvgnd_1
XTAP_486 VGND VPWR sky130_fd_sc_hd__tapvpwrvgnd_1
XTAP_497 VGND VPWR sky130_fd_sc_hd__tapvpwrvgnd_1
XFILLER_0_21_3 VGND VGND VPWR VPWR sky130_fd_sc_hd__fill_1
X_7995_ clknet_leaf_82_clk _0084_ net188 VGND VGND VPWR VPWR u_sample_counter.sample_count\[18\]
+ sky130_fd_sc_hd__dfrtp_1
XTAP_1619 VGND VPWR sky130_fd_sc_hd__tapvpwrvgnd_1
XTAP_1608 VGND VPWR sky130_fd_sc_hd__tapvpwrvgnd_1
X_6946_ u_input_buffer.fifo_mem\[15\]\[3\] _3060_ _3062_ u_input_buffer.fifo_mem\[43\]\[3\]
+ VGND VGND VPWR VPWR _3195_ sky130_fd_sc_hd__a22o_1
X_6877_ u_analytics_engine.data_in\[1\] _2893_ _3126_ _3127_ VGND VGND VPWR VPWR _1127_
+ sky130_fd_sc_hd__a22o_1
XFILLER_0_36_306 VGND VGND VPWR VPWR sky130_fd_sc_hd__fill_2
X_8616_ clknet_leaf_102_clk _0705_ VGND VGND VPWR VPWR u_input_buffer.fifo_mem\[25\]\[14\]
+ sky130_fd_sc_hd__dfxtp_1
XFILLER_0_29_391 VGND VGND VPWR VPWR sky130_fd_sc_hd__fill_1
X_5828_ _2447_ VGND VGND VPWR VPWR _0758_ sky130_fd_sc_hd__clkbuf_1
X_5759_ net373 _2250_ _2407_ VGND VGND VPWR VPWR _2411_ sky130_fd_sc_hd__mux2_1
X_8547_ clknet_leaf_2_clk _0636_ VGND VGND VPWR VPWR u_input_buffer.fifo_mem\[29\]\[9\]
+ sky130_fd_sc_hd__dfxtp_1
XFILLER_0_106_249 VGND VGND VPWR VPWR sky130_fd_sc_hd__decap_3
XFILLER_0_44_372 VGND VGND VPWR VPWR sky130_fd_sc_hd__fill_2
X_8478_ clknet_leaf_4_clk _0567_ VGND VGND VPWR VPWR u_input_buffer.fifo_mem\[33\]\[4\]
+ sky130_fd_sc_hd__dfxtp_1
X_7429_ net277 net91 _3662_ VGND VGND VPWR VPWR _3663_ sky130_fd_sc_hd__mux2_1
XFILLER_0_8_91 VGND VGND VPWR VPWR sky130_fd_sc_hd__fill_1
Xhold660 u_input_buffer.fifo_mem\[32\]\[4\] VGND VGND VPWR VPWR net872 sky130_fd_sc_hd__dlygate4sd3_1
Xhold671 u_input_buffer.fifo_mem\[29\]\[0\] VGND VGND VPWR VPWR net883 sky130_fd_sc_hd__dlygate4sd3_1
Xhold682 u_input_buffer.fifo_mem\[2\]\[7\] VGND VGND VPWR VPWR net894 sky130_fd_sc_hd__dlygate4sd3_1
Xhold693 u_input_buffer.fifo_mem\[55\]\[1\] VGND VGND VPWR VPWR net905 sky130_fd_sc_hd__dlygate4sd3_1
XFILLER_0_62_180 VGND VGND VPWR VPWR sky130_fd_sc_hd__fill_1
XFILLER_0_4_27 VGND VGND VPWR VPWR sky130_fd_sc_hd__fill_1
X_4090_ _1409_ _1412_ _0000_ VGND VGND VPWR VPWR _1413_ sky130_fd_sc_hd__mux2_1
X_6800_ _3051_ VGND VGND VPWR VPWR _3052_ sky130_fd_sc_hd__clkbuf_4
X_7780_ _3887_ VGND VGND VPWR VPWR _1270_ sky130_fd_sc_hd__clkbuf_1
X_4992_ _1985_ VGND VGND VPWR VPWR _0384_ sky130_fd_sc_hd__clkbuf_1
X_3943_ _1320_ VGND VGND VPWR VPWR _0000_ sky130_fd_sc_hd__buf_4
X_6731_ _2929_ _2964_ VGND VGND VPWR VPWR _2983_ sky130_fd_sc_hd__nor2_4
XFILLER_0_46_615 VGND VGND VPWR VPWR sky130_fd_sc_hd__fill_1
X_6662_ u_input_buffer.fifo_mem\[21\]\[0\] _2909_ _2913_ u_input_buffer.fifo_mem\[25\]\[0\]
+ VGND VGND VPWR VPWR _2914_ sky130_fd_sc_hd__a22o_1
X_8401_ clknet_leaf_45_clk _0490_ VGND VGND VPWR VPWR u_input_buffer.fifo_mem\[38\]\[7\]
+ sky130_fd_sc_hd__dfxtp_1
XFILLER_0_61_607 VGND VGND VPWR VPWR sky130_fd_sc_hd__fill_1
Xclkbuf_3_2__f_clk clknet_0_clk VGND VGND VPWR VPWR clknet_3_2__leaf_clk sky130_fd_sc_hd__clkbuf_16
X_5613_ _1680_ _2295_ VGND VGND VPWR VPWR _2332_ sky130_fd_sc_hd__and2_1
XFILLER_0_45_147 VGND VGND VPWR VPWR sky130_fd_sc_hd__fill_1
X_8332_ clknet_leaf_27_clk _0421_ VGND VGND VPWR VPWR u_input_buffer.fifo_mem\[42\]\[2\]
+ sky130_fd_sc_hd__dfxtp_1
X_6593_ u_input_buffer.count\[0\] u_input_buffer.count\[1\] VGND VGND VPWR VPWR _2863_
+ sky130_fd_sc_hd__and2_1
XFILLER_0_30_71 VGND VGND VPWR VPWR sky130_fd_sc_hd__fill_1
X_5544_ _2294_ VGND VGND VPWR VPWR _2295_ sky130_fd_sc_hd__buf_4
X_5475_ _2253_ VGND VGND VPWR VPWR _0599_ sky130_fd_sc_hd__clkbuf_1
XFILLER_0_14_589 VPWR VGND VPWR VGND sky130_ef_sc_hd__decap_12
X_8263_ clknet_leaf_76_clk _0352_ VGND VGND VPWR VPWR u_input_buffer.fifo_mem\[47\]\[13\]
+ sky130_fd_sc_hd__dfxtp_1
X_4426_ _1667_ VGND VGND VPWR VPWR _0136_ sky130_fd_sc_hd__clkbuf_1
X_8194_ clknet_leaf_14_clk _0283_ VGND VGND VPWR VPWR u_input_buffer.fifo_mem\[51\]\[8\]
+ sky130_fd_sc_hd__dfxtp_1
XFILLER_0_1_461 VPWR VGND VPWR VGND sky130_ef_sc_hd__decap_12
X_7214_ u_input_buffer.fifo_mem\[52\]\[10\] _3038_ _3040_ u_input_buffer.fifo_mem\[56\]\[10\]
+ VGND VGND VPWR VPWR _3456_ sky130_fd_sc_hd__a22o_1
X_7145_ u_input_buffer.fifo_mem\[54\]\[8\] _3078_ _3080_ u_input_buffer.fifo_mem\[46\]\[8\]
+ VGND VGND VPWR VPWR _3389_ sky130_fd_sc_hd__a22o_1
X_4357_ net744 _1624_ _1601_ VGND VGND VPWR VPWR _1625_ sky130_fd_sc_hd__mux2_1
XTAP_250 VGND VPWR sky130_fd_sc_hd__tapvpwrvgnd_1
X_4288_ u_analytics_engine.threshold\[4\] _1564_ _1567_ VGND VGND VPWR VPWR _1568_
+ sky130_fd_sc_hd__a21oi_1
X_7076_ u_input_buffer.fifo_mem\[41\]\[7\] _2919_ _2921_ u_input_buffer.fifo_mem\[45\]\[7\]
+ _3320_ VGND VGND VPWR VPWR _3321_ sky130_fd_sc_hd__a221o_1
XTAP_283 VGND VPWR sky130_fd_sc_hd__tapvpwrvgnd_1
XTAP_261 VGND VPWR sky130_fd_sc_hd__tapvpwrvgnd_1
XTAP_272 VGND VPWR sky130_fd_sc_hd__tapvpwrvgnd_1
XTAP_294 VGND VPWR sky130_fd_sc_hd__tapvpwrvgnd_1
X_6027_ net341 _2518_ _2548_ VGND VGND VPWR VPWR _2560_ sky130_fd_sc_hd__mux2_1
XTAP_1405 VGND VPWR sky130_fd_sc_hd__tapvpwrvgnd_1
XTAP_1438 VGND VPWR sky130_fd_sc_hd__tapvpwrvgnd_1
XTAP_1427 VGND VPWR sky130_fd_sc_hd__tapvpwrvgnd_1
XTAP_1416 VGND VPWR sky130_fd_sc_hd__tapvpwrvgnd_1
X_7978_ clknet_leaf_61_clk _0067_ net197 VGND VGND VPWR VPWR u_sample_counter.sample_count\[1\]
+ sky130_fd_sc_hd__dfrtp_1
XTAP_1449 VGND VPWR sky130_fd_sc_hd__tapvpwrvgnd_1
X_6929_ u_input_buffer.fifo_mem\[2\]\[3\] _2984_ _2986_ u_input_buffer.fifo_mem\[32\]\[3\]
+ VGND VGND VPWR VPWR _3178_ sky130_fd_sc_hd__a22o_1
XFILLER_0_37_615 VGND VGND VPWR VPWR sky130_fd_sc_hd__fill_1
XFILLER_0_9_561 VPWR VGND VPWR VGND sky130_ef_sc_hd__decap_12
XFILLER_0_24_309 VPWR VGND VPWR VGND sky130_ef_sc_hd__decap_12
XFILLER_0_107_569 VGND VGND VPWR VPWR sky130_fd_sc_hd__fill_1
XFILLER_0_115_580 VGND VGND VPWR VPWR sky130_fd_sc_hd__decap_8
XFILLER_0_60_662 VGND VGND VPWR VPWR sky130_fd_sc_hd__decap_8
XFILLER_0_20_548 VPWR VGND VPWR VGND sky130_ef_sc_hd__decap_12
Xhold490 u_input_buffer.fifo_mem\[24\]\[12\] VGND VGND VPWR VPWR net702 sky130_fd_sc_hd__dlygate4sd3_1
XFILLER_0_19_39 VGND VGND VPWR VPWR sky130_fd_sc_hd__decap_8
XFILLER_0_87_548 VGND VGND VPWR VPWR sky130_fd_sc_hd__decap_4
XFILLER_0_28_637 VGND VGND VPWR VPWR sky130_fd_sc_hd__decap_4
XFILLER_0_2_247 VGND VGND VPWR VPWR sky130_fd_sc_hd__fill_2
XFILLER_0_50_150 VGND VGND VPWR VPWR sky130_fd_sc_hd__fill_1
X_5260_ _2136_ VGND VGND VPWR VPWR _0501_ sky130_fd_sc_hd__clkbuf_1
XFILLER_0_2_269 VGND VGND VPWR VPWR sky130_fd_sc_hd__decap_4
XFILLER_0_76_23 VGND VGND VPWR VPWR sky130_fd_sc_hd__decap_4
XFILLER_0_11_559 VGND VGND VPWR VPWR sky130_fd_sc_hd__fill_1
X_4211_ _1501_ _1504_ _1505_ VGND VGND VPWR VPWR _0083_ sky130_fd_sc_hd__o21a_1
X_5191_ net614 _1994_ _2097_ VGND VGND VPWR VPWR _2100_ sky130_fd_sc_hd__mux2_1
X_4142_ _1456_ VGND VGND VPWR VPWR _1457_ sky130_fd_sc_hd__buf_2
X_4073_ u_sensor_interface.sensor_array\[0\]\[3\] u_sensor_interface.sensor_array\[1\]\[3\]
+ _1318_ VGND VGND VPWR VPWR _1398_ sky130_fd_sc_hd__mux2_1
X_8950_ clknet_leaf_9_clk _1039_ VGND VGND VPWR VPWR u_input_buffer.fifo_mem\[4\]\[12\]
+ sky130_fd_sc_hd__dfxtp_1
X_7901_ clknet_leaf_62_clk net221 net195 VGND VGND VPWR VPWR u_register_bank.status_flags\[21\]
+ sky130_fd_sc_hd__dfrtp_1
X_8881_ clknet_leaf_60_clk _0970_ VGND VGND VPWR VPWR u_input_buffer.fifo_mem\[8\]\[7\]
+ sky130_fd_sc_hd__dfxtp_1
X_7832_ net43 u_register_bank.sensor_enable\[9\] _3905_ VGND VGND VPWR VPWR _3915_
+ sky130_fd_sc_hd__mux2_1
X_7763_ u_register_bank.status_flags\[28\] _3849_ _3843_ u_register_bank.sensor_enable\[28\]
+ VGND VGND VPWR VPWR _3875_ sky130_fd_sc_hd__a22o_1
X_4975_ _1409_ net1297 _1971_ VGND VGND VPWR VPWR _1977_ sky130_fd_sc_hd__mux2_1
XFILLER_0_58_261 VGND VGND VPWR VPWR sky130_fd_sc_hd__decap_4
X_6714_ _2965_ VGND VGND VPWR VPWR _2966_ sky130_fd_sc_hd__clkbuf_4
XFILLER_0_73_231 VGND VGND VPWR VPWR sky130_fd_sc_hd__fill_1
X_7694_ u_register_bank.status_flags\[12\] _3814_ _3808_ u_register_bank.sensor_enable\[12\]
+ VGND VGND VPWR VPWR _3822_ sky130_fd_sc_hd__a22o_1
XFILLER_0_46_445 VGND VGND VPWR VPWR sky130_fd_sc_hd__decap_4
XFILLER_0_27_670 VGND VGND VPWR VPWR sky130_fd_sc_hd__fill_2
X_6645_ _2894_ _2896_ VGND VGND VPWR VPWR _2897_ sky130_fd_sc_hd__nor2_4
XFILLER_0_104_528 VGND VGND VPWR VPWR sky130_fd_sc_hd__decap_4
X_6576_ _2853_ VGND VGND VPWR VPWR _1100_ sky130_fd_sc_hd__clkbuf_1
XFILLER_0_6_575 VGND VGND VPWR VPWR sky130_fd_sc_hd__fill_1
XFILLER_0_26_191 VGND VGND VPWR VPWR sky130_fd_sc_hd__fill_2
X_8315_ clknet_leaf_32_clk _0404_ VGND VGND VPWR VPWR u_input_buffer.fifo_mem\[43\]\[1\]
+ sky130_fd_sc_hd__dfxtp_1
X_5527_ net331 _2260_ _2277_ VGND VGND VPWR VPWR _2286_ sky130_fd_sc_hd__mux2_1
X_8246_ clknet_leaf_99_clk _0335_ VGND VGND VPWR VPWR u_input_buffer.fifo_mem\[48\]\[12\]
+ sky130_fd_sc_hd__dfxtp_1
XFILLER_0_112_572 VPWR VGND VPWR VGND sky130_ef_sc_hd__decap_12
X_5458_ u_input_buffer.wr_ptr\[5\] _1589_ net185 VGND VGND VPWR VPWR _2241_ sky130_fd_sc_hd__or3b_1
Xfanout200 net45 VGND VGND VPWR VPWR net200 sky130_fd_sc_hd__clkbuf_8
X_8177_ clknet_leaf_56_clk _0266_ VGND VGND VPWR VPWR u_input_buffer.fifo_mem\[52\]\[7\]
+ sky130_fd_sc_hd__dfxtp_1
Xfanout211 net212 VGND VGND VPWR VPWR net211 sky130_fd_sc_hd__buf_2
XFILLER_0_10_581 VGND VGND VPWR VPWR sky130_fd_sc_hd__decap_6
X_4409_ _1469_ net868 _1640_ VGND VGND VPWR VPWR _1657_ sky130_fd_sc_hd__mux2_1
X_5389_ _1891_ _1969_ VGND VGND VPWR VPWR _2204_ sky130_fd_sc_hd__nand2_4
X_7128_ _3365_ _3367_ _3369_ _3371_ VGND VGND VPWR VPWR _3372_ sky130_fd_sc_hd__or4_1
X_7059_ u_input_buffer.fifo_mem\[6\]\[6\] _3035_ _3037_ u_input_buffer.fifo_mem\[28\]\[6\]
+ _3304_ VGND VGND VPWR VPWR _3305_ sky130_fd_sc_hd__a221o_1
XTAP_1202 VGND VPWR sky130_fd_sc_hd__tapvpwrvgnd_1
XTAP_1213 VGND VPWR sky130_fd_sc_hd__tapvpwrvgnd_1
XTAP_1257 VGND VPWR sky130_fd_sc_hd__tapvpwrvgnd_1
XTAP_1246 VGND VPWR sky130_fd_sc_hd__tapvpwrvgnd_1
XTAP_1235 VGND VPWR sky130_fd_sc_hd__tapvpwrvgnd_1
XTAP_1224 VGND VPWR sky130_fd_sc_hd__tapvpwrvgnd_1
XTAP_1268 VGND VPWR sky130_fd_sc_hd__tapvpwrvgnd_1
XTAP_1279 VGND VPWR sky130_fd_sc_hd__tapvpwrvgnd_1
XFILLER_0_107_388 VGND VGND VPWR VPWR sky130_fd_sc_hd__fill_1
XFILLER_0_24_139 VGND VGND VPWR VPWR sky130_fd_sc_hd__fill_1
XFILLER_0_20_345 VGND VGND VPWR VPWR sky130_fd_sc_hd__decap_3
XFILLER_0_20_389 VGND VGND VPWR VPWR sky130_fd_sc_hd__decap_6
XFILLER_0_87_367 VGND VGND VPWR VPWR sky130_fd_sc_hd__fill_1
X_4760_ _1859_ VGND VGND VPWR VPWR _0278_ sky130_fd_sc_hd__clkbuf_1
X_4691_ _1403_ net1245 _1817_ VGND VGND VPWR VPWR _1822_ sky130_fd_sc_hd__mux2_1
XFILLER_0_102_53 VPWR VGND VPWR VGND sky130_ef_sc_hd__decap_12
X_6430_ _2776_ VGND VGND VPWR VPWR _1031_ sky130_fd_sc_hd__clkbuf_1
XFILLER_0_113_314 VGND VGND VPWR VPWR sky130_fd_sc_hd__fill_2
XFILLER_0_102_97 VGND VGND VPWR VPWR sky130_fd_sc_hd__decap_4
X_6361_ net907 _2506_ _2735_ VGND VGND VPWR VPWR _2740_ sky130_fd_sc_hd__mux2_1
X_8100_ clknet_leaf_105_clk _0189_ VGND VGND VPWR VPWR u_input_buffer.fifo_mem\[57\]\[10\]
+ sky130_fd_sc_hd__dfxtp_1
X_5312_ _2163_ VGND VGND VPWR VPWR _0526_ sky130_fd_sc_hd__clkbuf_1
XFILLER_0_87_55 VGND VGND VPWR VPWR sky130_fd_sc_hd__fill_1
X_6292_ net984 _2506_ _2698_ VGND VGND VPWR VPWR _2703_ sky130_fd_sc_hd__mux2_1
X_9080_ clknet_leaf_88_clk _1168_ VGND VGND VPWR VPWR u_input_buffer.fifo_mem\[63\]\[10\]
+ sky130_fd_sc_hd__dfxtp_1
X_8031_ clknet_leaf_5_clk _0120_ VGND VGND VPWR VPWR u_input_buffer.fifo_mem\[61\]\[5\]
+ sky130_fd_sc_hd__dfxtp_1
X_5243_ net1088 _2012_ _2114_ VGND VGND VPWR VPWR _2127_ sky130_fd_sc_hd__mux2_1
Xhold19 u_sample_counter.sample_count\[14\] VGND VGND VPWR VPWR net231 sky130_fd_sc_hd__dlygate4sd3_1
X_5174_ net652 _2012_ _2077_ VGND VGND VPWR VPWR _2090_ sky130_fd_sc_hd__mux2_1
X_4125_ _1439_ _1442_ _1320_ VGND VGND VPWR VPWR _1443_ sky130_fd_sc_hd__mux2_1
X_4056_ _1383_ VGND VGND VPWR VPWR _0050_ sky130_fd_sc_hd__clkbuf_1
X_8933_ clknet_leaf_110_clk _1022_ VGND VGND VPWR VPWR u_input_buffer.fifo_mem\[5\]\[11\]
+ sky130_fd_sc_hd__dfxtp_1
X_8864_ clknet_leaf_20_clk _0953_ VGND VGND VPWR VPWR u_input_buffer.fifo_mem\[9\]\[6\]
+ sky130_fd_sc_hd__dfxtp_1
X_7815_ _3906_ VGND VGND VPWR VPWR _1286_ sky130_fd_sc_hd__clkbuf_1
XFILLER_0_109_609 VGND VGND VPWR VPWR sky130_fd_sc_hd__fill_2
X_8795_ clknet_leaf_3_clk _0884_ VGND VGND VPWR VPWR u_input_buffer.fifo_mem\[13\]\[1\]
+ sky130_fd_sc_hd__dfxtp_1
X_7746_ _3862_ VGND VGND VPWR VPWR _1261_ sky130_fd_sc_hd__clkbuf_1
X_4958_ net657 _1732_ _1951_ VGND VGND VPWR VPWR _1967_ sky130_fd_sc_hd__mux2_1
XFILLER_0_61_201 VGND VGND VPWR VPWR sky130_fd_sc_hd__decap_3
X_4889_ _1928_ VGND VGND VPWR VPWR _0338_ sky130_fd_sc_hd__clkbuf_1
X_7677_ _3777_ VGND VGND VPWR VPWR _3808_ sky130_fd_sc_hd__clkbuf_4
X_6628_ _2886_ VGND VGND VPWR VPWR _2887_ sky130_fd_sc_hd__clkbuf_4
XFILLER_0_61_234 VGND VGND VPWR VPWR sky130_fd_sc_hd__fill_1
XFILLER_0_61_267 VGND VGND VPWR VPWR sky130_fd_sc_hd__decap_4
XFILLER_0_15_651 VGND VGND VPWR VPWR sky130_fd_sc_hd__decap_4
XFILLER_0_15_673 VGND VGND VPWR VPWR sky130_fd_sc_hd__decap_3
X_6559_ net253 _1384_ _2843_ VGND VGND VPWR VPWR _2845_ sky130_fd_sc_hd__mux2_1
X_8229_ clknet_leaf_107_clk _0318_ VGND VGND VPWR VPWR u_input_buffer.fifo_mem\[49\]\[11\]
+ sky130_fd_sc_hd__dfxtp_1
XFILLER_0_97_610 VGND VGND VPWR VPWR sky130_fd_sc_hd__decap_6
XFILLER_0_16_29 VPWR VGND VPWR VGND sky130_ef_sc_hd__decap_12
XTAP_1021 VGND VPWR sky130_fd_sc_hd__tapvpwrvgnd_1
XTAP_1010 VGND VPWR sky130_fd_sc_hd__tapvpwrvgnd_1
XTAP_1065 VGND VPWR sky130_fd_sc_hd__tapvpwrvgnd_1
XTAP_1043 VGND VPWR sky130_fd_sc_hd__tapvpwrvgnd_1
XTAP_1054 VGND VPWR sky130_fd_sc_hd__tapvpwrvgnd_1
XTAP_1032 VGND VPWR sky130_fd_sc_hd__tapvpwrvgnd_1
XTAP_1098 VGND VPWR sky130_fd_sc_hd__tapvpwrvgnd_1
XTAP_1087 VGND VPWR sky130_fd_sc_hd__tapvpwrvgnd_1
XTAP_1076 VGND VPWR sky130_fd_sc_hd__tapvpwrvgnd_1
XFILLER_0_108_642 VGND VGND VPWR VPWR sky130_fd_sc_hd__fill_2
XFILLER_0_80_521 VGND VGND VPWR VPWR sky130_fd_sc_hd__fill_2
XFILLER_0_80_565 VGND VGND VPWR VPWR sky130_fd_sc_hd__decap_6
XFILLER_0_40_429 VGND VGND VPWR VPWR sky130_fd_sc_hd__fill_1
XFILLER_0_52_289 VGND VGND VPWR VPWR sky130_fd_sc_hd__decap_3
XTAP_816 VGND VPWR sky130_fd_sc_hd__tapvpwrvgnd_1
XTAP_805 VGND VPWR sky130_fd_sc_hd__tapvpwrvgnd_1
XTAP_827 VGND VPWR sky130_fd_sc_hd__tapvpwrvgnd_1
XTAP_838 VGND VPWR sky130_fd_sc_hd__tapvpwrvgnd_1
XTAP_849 VGND VPWR sky130_fd_sc_hd__tapvpwrvgnd_1
X_5930_ net631 _2502_ _2498_ VGND VGND VPWR VPWR _2503_ sky130_fd_sc_hd__mux2_1
X_5861_ net819 _2250_ _2461_ VGND VGND VPWR VPWR _2465_ sky130_fd_sc_hd__mux2_1
X_7600_ _3755_ VGND VGND VPWR VPWR _1222_ sky130_fd_sc_hd__clkbuf_1
X_5792_ _2428_ VGND VGND VPWR VPWR _0741_ sky130_fd_sc_hd__clkbuf_1
XFILLER_0_8_637 VGND VGND VPWR VPWR sky130_fd_sc_hd__decap_6
X_4812_ net422 _1728_ _1873_ VGND VGND VPWR VPWR _1887_ sky130_fd_sc_hd__mux2_1
X_8580_ clknet_leaf_72_clk _0669_ VGND VGND VPWR VPWR u_input_buffer.fifo_mem\[27\]\[10\]
+ sky130_fd_sc_hd__dfxtp_1
XFILLER_0_56_562 VGND VGND VPWR VPWR sky130_fd_sc_hd__decap_4
X_7531_ _3718_ VGND VGND VPWR VPWR _1190_ sky130_fd_sc_hd__clkbuf_1
XFILLER_0_28_253 VGND VGND VPWR VPWR sky130_fd_sc_hd__fill_2
X_4743_ _1849_ VGND VGND VPWR VPWR _0271_ sky130_fd_sc_hd__clkbuf_1
XFILLER_0_114_601 VPWR VGND VPWR VGND sky130_ef_sc_hd__decap_12
X_7462_ _3680_ VGND VGND VPWR VPWR _1159_ sky130_fd_sc_hd__clkbuf_1
XFILLER_0_16_437 VGND VGND VPWR VPWR sky130_fd_sc_hd__fill_2
XFILLER_0_114_645 VPWR VGND VPWR VGND sky130_ef_sc_hd__decap_12
XFILLER_0_113_111 VGND VGND VPWR VPWR sky130_fd_sc_hd__fill_1
X_9201_ net175 _1288_ net207 VGND VGND VPWR VPWR u_register_bank.sensor_enable\[2\]
+ sky130_fd_sc_hd__dfrtp_1
X_6413_ _1628_ net1164 _2752_ VGND VGND VPWR VPWR _2767_ sky130_fd_sc_hd__mux2_1
XFILLER_0_3_320 VGND VGND VPWR VPWR sky130_fd_sc_hd__decap_6
X_4674_ net513 _1730_ _1797_ VGND VGND VPWR VPWR _1812_ sky130_fd_sc_hd__mux2_1
XFILLER_0_98_65 VPWR VGND VPWR VGND sky130_ef_sc_hd__decap_12
X_7393_ u_input_buffer.fifo_mem\[14\]\[15\] _2957_ _2960_ u_input_buffer.fifo_mem\[42\]\[15\]
+ VGND VGND VPWR VPWR _3630_ sky130_fd_sc_hd__a22o_1
XFILLER_0_101_317 VGND VGND VPWR VPWR sky130_fd_sc_hd__fill_1
X_6344_ _2730_ VGND VGND VPWR VPWR _0991_ sky130_fd_sc_hd__clkbuf_1
X_9132_ net170 _1220_ net202 VGND VGND VPWR VPWR u_analytics_engine.threshold\[14\]
+ sky130_fd_sc_hd__dfrtp_1
X_9063_ clknet_leaf_110_clk _1152_ VGND VGND VPWR VPWR u_sensor_interface.sensor_array\[3\]\[10\]
+ sky130_fd_sc_hd__dfxtp_1
X_6275_ _2693_ VGND VGND VPWR VPWR _0959_ sky130_fd_sc_hd__clkbuf_1
Xinput109 sensor_data_in[9] VGND VGND VPWR VPWR net109 sky130_fd_sc_hd__buf_1
X_5226_ _2118_ VGND VGND VPWR VPWR _0485_ sky130_fd_sc_hd__clkbuf_1
X_8014_ clknet_leaf_43_clk _0103_ VGND VGND VPWR VPWR u_input_buffer.fifo_mem\[62\]\[4\]
+ sky130_fd_sc_hd__dfxtp_1
X_5157_ _2081_ VGND VGND VPWR VPWR _0453_ sky130_fd_sc_hd__clkbuf_1
X_5088_ net319 _1994_ _2042_ VGND VGND VPWR VPWR _2045_ sky130_fd_sc_hd__mux2_1
X_4108_ u_sensor_interface.sensor_array\[0\]\[8\] u_sensor_interface.sensor_array\[1\]\[8\]
+ _1318_ VGND VGND VPWR VPWR _1428_ sky130_fd_sc_hd__mux2_1
XFILLER_0_79_643 VGND VGND VPWR VPWR sky130_fd_sc_hd__fill_1
X_4039_ _1371_ VGND VGND VPWR VPWR _0045_ sky130_fd_sc_hd__clkbuf_1
X_8916_ clknet_leaf_73_clk _1005_ VGND VGND VPWR VPWR u_input_buffer.fifo_mem\[6\]\[10\]
+ sky130_fd_sc_hd__dfxtp_1
XFILLER_0_79_665 VGND VGND VPWR VPWR sky130_fd_sc_hd__decap_6
X_8847_ clknet_leaf_50_clk _0936_ VGND VGND VPWR VPWR u_input_buffer.fifo_mem\[10\]\[5\]
+ sky130_fd_sc_hd__dfxtp_1
XPHY_115 VGND VGND VPWR VPWR sky130_fd_sc_hd__decap_3
XPHY_104 VGND VGND VPWR VPWR sky130_fd_sc_hd__decap_3
X_8778_ clknet_leaf_28_clk _0867_ VGND VGND VPWR VPWR u_input_buffer.fifo_mem\[14\]\[0\]
+ sky130_fd_sc_hd__dfxtp_1
XFILLER_0_94_668 VGND VGND VPWR VPWR sky130_fd_sc_hd__fill_2
XPHY_148 VGND VGND VPWR VPWR sky130_fd_sc_hd__decap_3
XPHY_137 VGND VGND VPWR VPWR sky130_fd_sc_hd__decap_3
XPHY_126 VGND VGND VPWR VPWR sky130_fd_sc_hd__decap_3
XPHY_159 VGND VGND VPWR VPWR sky130_fd_sc_hd__decap_3
XFILLER_0_47_573 VGND VGND VPWR VPWR sky130_fd_sc_hd__decap_3
X_7729_ _3774_ VGND VGND VPWR VPWR _3849_ sky130_fd_sc_hd__clkbuf_4
XFILLER_0_19_297 VGND VGND VPWR VPWR sky130_fd_sc_hd__fill_1
XFILLER_0_105_645 VGND VGND VPWR VPWR sky130_fd_sc_hd__decap_8
XANTENNA_60 _2077_ VGND VGND VPWR VPWR sky130_fd_sc_hd__diode_2
XFILLER_0_62_598 VGND VGND VPWR VPWR sky130_fd_sc_hd__fill_2
XFILLER_0_30_440 VGND VGND VPWR VPWR sky130_fd_sc_hd__fill_2
XFILLER_0_57_315 VGND VGND VPWR VPWR sky130_fd_sc_hd__fill_1
XPHY_6 VGND VGND VPWR VPWR sky130_fd_sc_hd__decap_3
XFILLER_0_85_679 VGND VGND VPWR VPWR sky130_fd_sc_hd__fill_1
XFILLER_0_57_337 VGND VGND VPWR VPWR sky130_fd_sc_hd__fill_2
XFILLER_0_5_629 VPWR VGND VPWR VGND sky130_ef_sc_hd__decap_12
Xclkbuf_leaf_104_clk clknet_3_0__leaf_clk VGND VGND VPWR VPWR clknet_leaf_104_clk
+ sky130_fd_sc_hd__clkbuf_16
XFILLER_0_40_215 VGND VGND VPWR VPWR sky130_fd_sc_hd__fill_1
Xhold308 u_input_buffer.fifo_mem\[6\]\[10\] VGND VGND VPWR VPWR net520 sky130_fd_sc_hd__dlygate4sd3_1
X_4390_ _1647_ VGND VGND VPWR VPWR _0120_ sky130_fd_sc_hd__clkbuf_1
Xhold319 u_input_buffer.fifo_mem\[52\]\[13\] VGND VGND VPWR VPWR net531 sky130_fd_sc_hd__dlygate4sd3_1
XTAP_602 VGND VPWR sky130_fd_sc_hd__tapvpwrvgnd_1
XTAP_613 VGND VPWR sky130_fd_sc_hd__tapvpwrvgnd_1
XTAP_624 VGND VPWR sky130_fd_sc_hd__tapvpwrvgnd_1
X_6060_ _2578_ VGND VGND VPWR VPWR _0859_ sky130_fd_sc_hd__clkbuf_1
XTAP_635 VGND VPWR sky130_fd_sc_hd__tapvpwrvgnd_1
XTAP_657 VGND VPWR sky130_fd_sc_hd__tapvpwrvgnd_1
XTAP_646 VGND VPWR sky130_fd_sc_hd__tapvpwrvgnd_1
XTAP_668 VGND VPWR sky130_fd_sc_hd__tapvpwrvgnd_1
Xhold1008 u_input_buffer.fifo_mem\[47\]\[6\] VGND VGND VPWR VPWR net1220 sky130_fd_sc_hd__dlygate4sd3_1
X_5011_ _1402_ VGND VGND VPWR VPWR _1998_ sky130_fd_sc_hd__buf_4
Xhold1019 u_input_buffer.fifo_mem\[9\]\[4\] VGND VGND VPWR VPWR net1231 sky130_fd_sc_hd__dlygate4sd3_1
XTAP_679 VGND VPWR sky130_fd_sc_hd__tapvpwrvgnd_1
XFILLER_0_108_41 VPWR VGND VPWR VGND sky130_ef_sc_hd__decap_12
X_6962_ u_input_buffer.fifo_mem\[29\]\[4\] _2939_ _2941_ u_input_buffer.fifo_mem\[13\]\[4\]
+ _3209_ VGND VGND VPWR VPWR _3210_ sky130_fd_sc_hd__a221o_1
X_6893_ u_input_buffer.fifo_mem\[51\]\[2\] _2990_ _2993_ u_input_buffer.fifo_mem\[11\]\[2\]
+ _3142_ VGND VGND VPWR VPWR _3143_ sky130_fd_sc_hd__a221o_1
X_8701_ clknet_leaf_65_clk _0790_ VGND VGND VPWR VPWR u_input_buffer.fifo_mem\[19\]\[3\]
+ sky130_fd_sc_hd__dfxtp_1
X_5913_ net768 _2268_ _2478_ VGND VGND VPWR VPWR _2492_ sky130_fd_sc_hd__mux2_1
X_5844_ _2455_ VGND VGND VPWR VPWR _0766_ sky130_fd_sc_hd__clkbuf_1
X_8632_ clknet_leaf_75_clk _0721_ VGND VGND VPWR VPWR u_input_buffer.fifo_mem\[24\]\[14\]
+ sky130_fd_sc_hd__dfxtp_1
X_8563_ clknet_leaf_68_clk _0652_ VGND VGND VPWR VPWR u_input_buffer.fifo_mem\[28\]\[9\]
+ sky130_fd_sc_hd__dfxtp_1
XFILLER_0_99_3 VPWR VGND VPWR VGND sky130_ef_sc_hd__decap_12
X_7514_ _3709_ VGND VGND VPWR VPWR _1182_ sky130_fd_sc_hd__clkbuf_1
X_5775_ net468 _2266_ _2406_ VGND VGND VPWR VPWR _2419_ sky130_fd_sc_hd__mux2_1
X_4726_ net751 _1712_ _1836_ VGND VGND VPWR VPWR _1841_ sky130_fd_sc_hd__mux2_1
X_8494_ clknet_leaf_24_clk _0583_ VGND VGND VPWR VPWR u_input_buffer.fifo_mem\[32\]\[4\]
+ sky130_fd_sc_hd__dfxtp_1
X_4657_ _1803_ VGND VGND VPWR VPWR _0231_ sky130_fd_sc_hd__clkbuf_1
X_7445_ u_sensor_interface.sensor_array\[3\]\[10\] net99 _3662_ VGND VGND VPWR VPWR
+ _3671_ sky130_fd_sc_hd__mux2_1
Xinput80 sensor_data_in[40] VGND VGND VPWR VPWR net80 sky130_fd_sc_hd__buf_1
XFILLER_0_114_486 VGND VGND VPWR VPWR sky130_fd_sc_hd__fill_1
Xinput91 sensor_data_in[50] VGND VGND VPWR VPWR net91 sky130_fd_sc_hd__clkbuf_1
Xhold820 u_input_buffer.fifo_mem\[58\]\[13\] VGND VGND VPWR VPWR net1032 sky130_fd_sc_hd__dlygate4sd3_1
X_7376_ u_input_buffer.fifo_mem\[10\]\[14\] _3055_ _3057_ u_input_buffer.fifo_mem\[44\]\[14\]
+ _3613_ VGND VGND VPWR VPWR _3614_ sky130_fd_sc_hd__a221o_1
X_4588_ _1764_ VGND VGND VPWR VPWR _0201_ sky130_fd_sc_hd__clkbuf_1
X_6327_ net453 _2506_ _2717_ VGND VGND VPWR VPWR _2722_ sky130_fd_sc_hd__mux2_1
X_9115_ net177 _1203_ net209 VGND VGND VPWR VPWR u_register_bank.window_cfg\[29\]
+ sky130_fd_sc_hd__dfrtp_1
Xhold831 u_input_buffer.fifo_mem\[12\]\[10\] VGND VGND VPWR VPWR net1043 sky130_fd_sc_hd__dlygate4sd3_1
Xhold864 u_input_buffer.fifo_mem\[60\]\[15\] VGND VGND VPWR VPWR net1076 sky130_fd_sc_hd__dlygate4sd3_1
Xhold853 u_input_buffer.fifo_mem\[41\]\[10\] VGND VGND VPWR VPWR net1065 sky130_fd_sc_hd__dlygate4sd3_1
Xhold842 u_input_buffer.fifo_mem\[47\]\[12\] VGND VGND VPWR VPWR net1054 sky130_fd_sc_hd__dlygate4sd3_1
Xhold886 u_input_buffer.fifo_mem\[38\]\[4\] VGND VGND VPWR VPWR net1098 sky130_fd_sc_hd__dlygate4sd3_1
Xhold897 u_input_buffer.fifo_mem\[49\]\[8\] VGND VGND VPWR VPWR net1109 sky130_fd_sc_hd__dlygate4sd3_1
Xhold875 u_input_buffer.fifo_mem\[13\]\[15\] VGND VGND VPWR VPWR net1087 sky130_fd_sc_hd__dlygate4sd3_1
XFILLER_0_110_681 VGND VGND VPWR VPWR sky130_fd_sc_hd__decap_4
X_9046_ clknet_leaf_69_clk net258 VGND VGND VPWR VPWR u_analytics_engine.data_in\[9\]
+ sky130_fd_sc_hd__dfxtp_2
X_6258_ _1610_ net1231 _2680_ VGND VGND VPWR VPWR _2685_ sky130_fd_sc_hd__mux2_1
X_6189_ _2648_ VGND VGND VPWR VPWR _0918_ sky130_fd_sc_hd__clkbuf_1
X_5209_ net325 _2012_ _2096_ VGND VGND VPWR VPWR _2109_ sky130_fd_sc_hd__mux2_1
XFILLER_0_94_421 VGND VGND VPWR VPWR sky130_fd_sc_hd__decap_8
XFILLER_0_67_657 VGND VGND VPWR VPWR sky130_fd_sc_hd__decap_8
XFILLER_0_66_123 VGND VGND VPWR VPWR sky130_fd_sc_hd__fill_1
XFILLER_0_39_359 VGND VGND VPWR VPWR sky130_fd_sc_hd__decap_4
XFILLER_0_66_167 VGND VGND VPWR VPWR sky130_fd_sc_hd__fill_2
XFILLER_0_35_532 VGND VGND VPWR VPWR sky130_fd_sc_hd__fill_2
XFILLER_0_105_420 VGND VGND VPWR VPWR sky130_fd_sc_hd__fill_1
XFILLER_0_81_159 VGND VGND VPWR VPWR sky130_fd_sc_hd__fill_1
XFILLER_0_35_543 VGND VGND VPWR VPWR sky130_fd_sc_hd__decap_4
XFILLER_0_62_362 VGND VGND VPWR VPWR sky130_fd_sc_hd__fill_2
XFILLER_0_58_635 VGND VGND VPWR VPWR sky130_fd_sc_hd__fill_1
XFILLER_0_97_281 VGND VGND VPWR VPWR sky130_fd_sc_hd__decap_4
XFILLER_0_26_510 VGND VGND VPWR VPWR sky130_fd_sc_hd__fill_1
X_5560_ _2304_ VGND VGND VPWR VPWR _0633_ sky130_fd_sc_hd__clkbuf_1
X_4511_ net619 _1718_ _1704_ VGND VGND VPWR VPWR _1719_ sky130_fd_sc_hd__mux2_1
XFILLER_0_81_671 VGND VGND VPWR VPWR sky130_fd_sc_hd__fill_1
XFILLER_0_79_23 VPWR VGND VPWR VGND sky130_ef_sc_hd__decap_12
X_5491_ _1438_ VGND VGND VPWR VPWR _2264_ sky130_fd_sc_hd__clkbuf_4
XFILLER_0_26_587 VGND VGND VPWR VPWR sky130_fd_sc_hd__fill_1
XFILLER_0_41_502 VGND VGND VPWR VPWR sky130_fd_sc_hd__fill_2
XFILLER_0_110_53 VPWR VGND VPWR VGND sky130_ef_sc_hd__decap_12
Xhold116 u_input_buffer.fifo_mem\[15\]\[2\] VGND VGND VPWR VPWR net328 sky130_fd_sc_hd__dlygate4sd3_1
Xhold105 u_input_buffer.fifo_mem\[4\]\[10\] VGND VGND VPWR VPWR net317 sky130_fd_sc_hd__dlygate4sd3_1
X_4442_ _1675_ VGND VGND VPWR VPWR _0144_ sky130_fd_sc_hd__clkbuf_1
X_7230_ u_input_buffer.fifo_mem\[33\]\[11\] _2897_ _2903_ u_input_buffer.fifo_mem\[61\]\[11\]
+ _3470_ VGND VGND VPWR VPWR _3471_ sky130_fd_sc_hd__a221o_1
Xhold138 u_input_buffer.fifo_mem\[62\]\[2\] VGND VGND VPWR VPWR net350 sky130_fd_sc_hd__dlygate4sd3_1
Xhold149 u_input_buffer.fifo_mem\[7\]\[9\] VGND VGND VPWR VPWR net361 sky130_fd_sc_hd__dlygate4sd3_1
Xhold127 u_input_buffer.fifo_mem\[16\]\[12\] VGND VGND VPWR VPWR net339 sky130_fd_sc_hd__dlygate4sd3_1
XFILLER_0_110_97 VGND VGND VPWR VPWR sky130_fd_sc_hd__decap_4
X_7161_ u_input_buffer.fifo_mem\[16\]\[9\] _2971_ _2973_ u_input_buffer.fifo_mem\[49\]\[9\]
+ _2975_ VGND VGND VPWR VPWR _3404_ sky130_fd_sc_hd__a221o_1
XFILLER_0_1_665 VGND VGND VPWR VPWR sky130_fd_sc_hd__decap_6
X_4373_ u_input_buffer.wr_ptr\[0\] u_analytics_engine.data_valid _1594_ VGND VGND
+ VPWR VPWR _1636_ sky130_fd_sc_hd__and3_1
XFILLER_0_95_55 VGND VGND VPWR VPWR sky130_fd_sc_hd__fill_1
X_7092_ u_input_buffer.fifo_mem\[8\]\[7\] _3004_ _3006_ u_input_buffer.fifo_mem\[19\]\[7\]
+ _3336_ VGND VGND VPWR VPWR _3337_ sky130_fd_sc_hd__a221o_1
XTAP_421 VGND VPWR sky130_fd_sc_hd__tapvpwrvgnd_1
XTAP_410 VGND VPWR sky130_fd_sc_hd__tapvpwrvgnd_1
XTAP_432 VGND VPWR sky130_fd_sc_hd__tapvpwrvgnd_1
X_6112_ _2606_ VGND VGND VPWR VPWR _2607_ sky130_fd_sc_hd__clkbuf_4
X_6043_ net480 _2496_ _2569_ VGND VGND VPWR VPWR _2570_ sky130_fd_sc_hd__mux2_1
XTAP_443 VGND VPWR sky130_fd_sc_hd__tapvpwrvgnd_1
XTAP_454 VGND VPWR sky130_fd_sc_hd__tapvpwrvgnd_1
XTAP_465 VGND VPWR sky130_fd_sc_hd__tapvpwrvgnd_1
XTAP_476 VGND VPWR sky130_fd_sc_hd__tapvpwrvgnd_1
XTAP_487 VGND VPWR sky130_fd_sc_hd__tapvpwrvgnd_1
XTAP_498 VGND VPWR sky130_fd_sc_hd__tapvpwrvgnd_1
XFILLER_0_28_71 VGND VGND VPWR VPWR sky130_fd_sc_hd__decap_4
X_7994_ clknet_leaf_82_clk _0083_ net187 VGND VGND VPWR VPWR u_sample_counter.sample_count\[17\]
+ sky130_fd_sc_hd__dfrtp_1
XTAP_1609 VGND VPWR sky130_fd_sc_hd__tapvpwrvgnd_1
X_6945_ u_input_buffer.fifo_mem\[23\]\[3\] _3046_ _3048_ u_input_buffer.fifo_mem\[20\]\[3\]
+ _3193_ VGND VGND VPWR VPWR _3194_ sky130_fd_sc_hd__a221o_1
XFILLER_0_44_70 VGND VGND VPWR VPWR sky130_fd_sc_hd__decap_4
XFILLER_0_76_443 VGND VGND VPWR VPWR sky130_fd_sc_hd__decap_3
XFILLER_0_49_657 VPWR VGND VPWR VGND sky130_ef_sc_hd__decap_12
XFILLER_0_91_413 VGND VGND VPWR VPWR sky130_fd_sc_hd__fill_1
X_6876_ net253 _3086_ _3088_ VGND VGND VPWR VPWR _3127_ sky130_fd_sc_hd__o21a_1
XFILLER_0_64_605 VGND VGND VPWR VPWR sky130_fd_sc_hd__fill_1
XFILLER_0_91_435 VGND VGND VPWR VPWR sky130_fd_sc_hd__decap_4
XFILLER_0_76_498 VGND VGND VPWR VPWR sky130_fd_sc_hd__decap_6
XFILLER_0_63_137 VGND VGND VPWR VPWR sky130_fd_sc_hd__decap_4
X_8615_ clknet_leaf_0_clk _0704_ VGND VGND VPWR VPWR u_input_buffer.fifo_mem\[25\]\[13\]
+ sky130_fd_sc_hd__dfxtp_1
X_5827_ _1608_ net1264 _2443_ VGND VGND VPWR VPWR _2447_ sky130_fd_sc_hd__mux2_1
XFILLER_0_106_228 VGND VGND VPWR VPWR sky130_fd_sc_hd__fill_1
X_5758_ _2410_ VGND VGND VPWR VPWR _0725_ sky130_fd_sc_hd__clkbuf_1
X_8546_ clknet_leaf_1_clk _0635_ VGND VGND VPWR VPWR u_input_buffer.fifo_mem\[29\]\[8\]
+ sky130_fd_sc_hd__dfxtp_1
X_4709_ _1457_ net1021 _1816_ VGND VGND VPWR VPWR _1831_ sky130_fd_sc_hd__mux2_1
X_8477_ clknet_leaf_4_clk _0566_ VGND VGND VPWR VPWR u_input_buffer.fifo_mem\[33\]\[3\]
+ sky130_fd_sc_hd__dfxtp_1
X_5689_ _2373_ VGND VGND VPWR VPWR _0693_ sky130_fd_sc_hd__clkbuf_1
X_7428_ _1322_ VGND VGND VPWR VPWR _3662_ sky130_fd_sc_hd__buf_6
XFILLER_0_32_579 VGND VGND VPWR VPWR sky130_fd_sc_hd__decap_8
Xhold661 u_input_buffer.fifo_mem\[42\]\[9\] VGND VGND VPWR VPWR net873 sky130_fd_sc_hd__dlygate4sd3_1
Xhold650 u_input_buffer.fifo_mem\[9\]\[15\] VGND VGND VPWR VPWR net862 sky130_fd_sc_hd__dlygate4sd3_1
Xhold672 u_input_buffer.fifo_mem\[19\]\[15\] VGND VGND VPWR VPWR net884 sky130_fd_sc_hd__dlygate4sd3_1
X_7359_ u_input_buffer.fifo_mem\[12\]\[14\] _2979_ _2981_ u_input_buffer.fifo_mem\[18\]\[14\]
+ _3596_ VGND VGND VPWR VPWR _3597_ sky130_fd_sc_hd__a221o_1
Xhold694 u_input_buffer.fifo_mem\[48\]\[5\] VGND VGND VPWR VPWR net906 sky130_fd_sc_hd__dlygate4sd3_1
XFILLER_0_5_6 VPWR VGND VPWR VGND sky130_ef_sc_hd__decap_12
Xhold683 u_input_buffer.fifo_mem\[59\]\[15\] VGND VGND VPWR VPWR net895 sky130_fd_sc_hd__dlygate4sd3_1
X_9029_ clknet_leaf_97_clk _1118_ net185 VGND VGND VPWR VPWR u_input_buffer.rd_ptr\[4\]
+ sky130_fd_sc_hd__dfrtp_1
XFILLER_0_94_284 VGND VGND VPWR VPWR sky130_fd_sc_hd__fill_2
XFILLER_0_39_178 VGND VGND VPWR VPWR sky130_fd_sc_hd__fill_1
XFILLER_0_54_159 VGND VGND VPWR VPWR sky130_fd_sc_hd__fill_2
XFILLER_0_50_365 VGND VGND VPWR VPWR sky130_fd_sc_hd__decap_8
XFILLER_0_81_57 VGND VGND VPWR VPWR sky130_fd_sc_hd__fill_2
X_6730_ _2981_ VGND VGND VPWR VPWR _2982_ sky130_fd_sc_hd__buf_4
XFILLER_0_58_421 VGND VGND VPWR VPWR sky130_fd_sc_hd__fill_2
X_4991_ _1457_ net959 _1970_ VGND VGND VPWR VPWR _1985_ sky130_fd_sc_hd__mux2_1
XFILLER_0_81_79 VGND VGND VPWR VPWR sky130_fd_sc_hd__fill_1
X_3942_ _1319_ VGND VGND VPWR VPWR _1320_ sky130_fd_sc_hd__clkinv_4
X_6661_ _2912_ VGND VGND VPWR VPWR _2913_ sky130_fd_sc_hd__clkbuf_4
X_8400_ clknet_leaf_67_clk _0489_ VGND VGND VPWR VPWR u_input_buffer.fifo_mem\[38\]\[6\]
+ sky130_fd_sc_hd__dfxtp_1
X_6592_ u_input_buffer.count\[0\] u_input_buffer.count\[1\] VGND VGND VPWR VPWR _2862_
+ sky130_fd_sc_hd__nor2_1
X_5612_ _2331_ VGND VGND VPWR VPWR _0658_ sky130_fd_sc_hd__clkbuf_1
X_8331_ clknet_leaf_27_clk _0420_ VGND VGND VPWR VPWR u_input_buffer.fifo_mem\[42\]\[1\]
+ sky130_fd_sc_hd__dfxtp_1
XFILLER_0_30_50 VGND VGND VPWR VPWR sky130_fd_sc_hd__decap_4
X_5543_ u_input_buffer.wr_ptr\[5\] u_input_buffer.wr_ptr\[4\] net185 VGND VGND VPWR
+ VPWR _2294_ sky130_fd_sc_hd__and3b_1
XFILLER_0_54_671 VGND VGND VPWR VPWR sky130_fd_sc_hd__fill_2
XFILLER_0_53_181 VGND VGND VPWR VPWR sky130_fd_sc_hd__fill_1
X_5474_ net494 _2252_ _2244_ VGND VGND VPWR VPWR _2253_ sky130_fd_sc_hd__mux2_1
X_8262_ clknet_leaf_75_clk _0351_ VGND VGND VPWR VPWR u_input_buffer.fifo_mem\[47\]\[12\]
+ sky130_fd_sc_hd__dfxtp_1
X_8193_ clknet_leaf_38_clk _0282_ VGND VGND VPWR VPWR u_input_buffer.fifo_mem\[51\]\[7\]
+ sky130_fd_sc_hd__dfxtp_1
X_4425_ net896 _1612_ _1661_ VGND VGND VPWR VPWR _1667_ sky130_fd_sc_hd__mux2_1
X_7213_ u_input_buffer.fifo_mem\[7\]\[10\] _3024_ _3026_ u_input_buffer.fifo_mem\[22\]\[10\]
+ _3454_ VGND VGND VPWR VPWR _3455_ sky130_fd_sc_hd__a221o_1
X_7144_ u_input_buffer.fifo_mem\[26\]\[8\] _3066_ _3068_ u_input_buffer.fifo_mem\[62\]\[8\]
+ _3387_ VGND VGND VPWR VPWR _3388_ sky130_fd_sc_hd__a221o_1
XFILLER_0_1_473 VPWR VGND VPWR VGND sky130_ef_sc_hd__decap_12
X_4356_ u_input_buffer.data_in\[11\] VGND VGND VPWR VPWR _1624_ sky130_fd_sc_hd__clkbuf_4
XTAP_240 VGND VPWR sky130_fd_sc_hd__tapvpwrvgnd_1
XTAP_251 VGND VPWR sky130_fd_sc_hd__tapvpwrvgnd_1
X_4287_ _1562_ _1566_ _1561_ VGND VGND VPWR VPWR _1567_ sky130_fd_sc_hd__or3b_1
X_7075_ u_input_buffer.fifo_mem\[37\]\[7\] _2923_ _2926_ u_input_buffer.fifo_mem\[9\]\[7\]
+ VGND VGND VPWR VPWR _3320_ sky130_fd_sc_hd__a22o_1
XTAP_284 VGND VPWR sky130_fd_sc_hd__tapvpwrvgnd_1
XTAP_262 VGND VPWR sky130_fd_sc_hd__tapvpwrvgnd_1
XTAP_273 VGND VPWR sky130_fd_sc_hd__tapvpwrvgnd_1
X_6026_ _2559_ VGND VGND VPWR VPWR _0844_ sky130_fd_sc_hd__clkbuf_1
XTAP_295 VGND VPWR sky130_fd_sc_hd__tapvpwrvgnd_1
XFILLER_0_55_80 VGND VGND VPWR VPWR sky130_fd_sc_hd__fill_1
XTAP_1406 VGND VPWR sky130_fd_sc_hd__tapvpwrvgnd_1
Xclkbuf_leaf_93_clk clknet_3_3__leaf_clk VGND VGND VPWR VPWR clknet_leaf_93_clk sky130_fd_sc_hd__clkbuf_16
XTAP_1439 VGND VPWR sky130_fd_sc_hd__tapvpwrvgnd_1
XTAP_1428 VGND VPWR sky130_fd_sc_hd__tapvpwrvgnd_1
XTAP_1417 VGND VPWR sky130_fd_sc_hd__tapvpwrvgnd_1
X_7977_ clknet_leaf_59_clk _0066_ net199 VGND VGND VPWR VPWR u_sample_counter.sample_count\[0\]
+ sky130_fd_sc_hd__dfrtp_1
XFILLER_0_76_240 VGND VGND VPWR VPWR sky130_fd_sc_hd__decap_4
X_6928_ u_input_buffer.fifo_mem\[34\]\[3\] _2966_ _2969_ u_input_buffer.fifo_mem\[48\]\[3\]
+ _3176_ VGND VGND VPWR VPWR _3177_ sky130_fd_sc_hd__a221o_1
X_6859_ u_input_buffer.fifo_mem\[31\]\[1\] _3017_ _3020_ u_input_buffer.fifo_mem\[38\]\[1\]
+ VGND VGND VPWR VPWR _3110_ sky130_fd_sc_hd__a22o_1
XFILLER_0_9_573 VPWR VGND VPWR VGND sky130_ef_sc_hd__decap_12
XFILLER_0_107_559 VGND VGND VPWR VPWR sky130_fd_sc_hd__fill_1
XFILLER_0_45_671 VGND VGND VPWR VPWR sky130_fd_sc_hd__fill_1
X_8529_ clknet_leaf_55_clk _0618_ VGND VGND VPWR VPWR u_input_buffer.fifo_mem\[30\]\[7\]
+ sky130_fd_sc_hd__dfxtp_1
XFILLER_0_60_641 VGND VGND VPWR VPWR sky130_fd_sc_hd__decap_3
XFILLER_0_32_365 VGND VGND VPWR VPWR sky130_fd_sc_hd__decap_3
XFILLER_0_102_253 VGND VGND VPWR VPWR sky130_fd_sc_hd__fill_1
Xhold480 u_input_buffer.fifo_mem\[38\]\[9\] VGND VGND VPWR VPWR net692 sky130_fd_sc_hd__dlygate4sd3_1
XFILLER_0_3_3 VPWR VGND VPWR VGND sky130_ef_sc_hd__decap_12
Xhold491 u_input_buffer.fifo_mem\[52\]\[9\] VGND VGND VPWR VPWR net703 sky130_fd_sc_hd__dlygate4sd3_1
Xclkbuf_leaf_84_clk clknet_3_2__leaf_clk VGND VGND VPWR VPWR clknet_leaf_84_clk sky130_fd_sc_hd__clkbuf_16
XFILLER_0_67_251 VGND VGND VPWR VPWR sky130_fd_sc_hd__decap_3
XFILLER_0_28_616 VGND VGND VPWR VPWR sky130_fd_sc_hd__fill_1
XFILLER_0_43_608 VGND VGND VPWR VPWR sky130_fd_sc_hd__decap_3
XFILLER_0_82_298 VGND VGND VPWR VPWR sky130_fd_sc_hd__fill_1
XFILLER_0_11_505 VPWR VGND VPWR VGND sky130_ef_sc_hd__decap_12
XFILLER_0_51_685 VGND VGND VPWR VPWR sky130_fd_sc_hd__fill_1
X_4210_ u_sample_counter.sample_count\[16\] _1494_ _1500_ net232 VGND VGND VPWR VPWR
+ _1505_ sky130_fd_sc_hd__a31o_1
X_5190_ _2099_ VGND VGND VPWR VPWR _0468_ sky130_fd_sc_hd__clkbuf_1
X_4141_ u_input_buffer.data_in\[13\] VGND VGND VPWR VPWR _1456_ sky130_fd_sc_hd__buf_4
X_4072_ _1396_ VGND VGND VPWR VPWR _1397_ sky130_fd_sc_hd__buf_2
X_7900_ clknet_leaf_64_clk net226 net196 VGND VGND VPWR VPWR u_register_bank.status_flags\[20\]
+ sky130_fd_sc_hd__dfrtp_1
X_8880_ clknet_leaf_67_clk _0969_ VGND VGND VPWR VPWR u_input_buffer.fifo_mem\[8\]\[6\]
+ sky130_fd_sc_hd__dfxtp_1
Xclkbuf_leaf_75_clk clknet_3_3__leaf_clk VGND VGND VPWR VPWR clknet_leaf_75_clk sky130_fd_sc_hd__clkbuf_16
X_7831_ _3914_ VGND VGND VPWR VPWR _1294_ sky130_fd_sc_hd__clkbuf_1
X_4974_ _1976_ VGND VGND VPWR VPWR _0375_ sky130_fd_sc_hd__clkbuf_1
XFILLER_0_58_251 VGND VGND VPWR VPWR sky130_fd_sc_hd__fill_1
X_7762_ _3874_ VGND VGND VPWR VPWR _1265_ sky130_fd_sc_hd__clkbuf_1
X_7693_ _3821_ VGND VGND VPWR VPWR _1249_ sky130_fd_sc_hd__clkbuf_1
X_6713_ _2896_ _2964_ VGND VGND VPWR VPWR _2965_ sky130_fd_sc_hd__nor2_4
X_6644_ _2895_ VGND VGND VPWR VPWR _2896_ sky130_fd_sc_hd__buf_8
X_6575_ net257 _1432_ _2843_ VGND VGND VPWR VPWR _2853_ sky130_fd_sc_hd__mux2_1
X_8314_ clknet_leaf_33_clk _0403_ VGND VGND VPWR VPWR u_input_buffer.fifo_mem\[43\]\[0\]
+ sky130_fd_sc_hd__dfxtp_1
X_5526_ _2285_ VGND VGND VPWR VPWR _0618_ sky130_fd_sc_hd__clkbuf_1
X_5457_ _1376_ VGND VGND VPWR VPWR _2240_ sky130_fd_sc_hd__clkbuf_4
X_8245_ clknet_leaf_9_clk _0334_ VGND VGND VPWR VPWR u_input_buffer.fifo_mem\[48\]\[11\]
+ sky130_fd_sc_hd__dfxtp_1
XFILLER_0_112_584 VGND VGND VPWR VPWR sky130_fd_sc_hd__decap_4
X_4408_ _1656_ VGND VGND VPWR VPWR _0129_ sky130_fd_sc_hd__clkbuf_1
X_8176_ clknet_leaf_55_clk _0265_ VGND VGND VPWR VPWR u_input_buffer.fifo_mem\[52\]\[6\]
+ sky130_fd_sc_hd__dfxtp_1
Xfanout201 net205 VGND VGND VPWR VPWR net201 sky130_fd_sc_hd__clkbuf_4
X_5388_ _2203_ VGND VGND VPWR VPWR _0562_ sky130_fd_sc_hd__clkbuf_1
Xfanout212 net11 VGND VGND VPWR VPWR net212 sky130_fd_sc_hd__clkbuf_4
X_4339_ net1153 _1612_ _1602_ VGND VGND VPWR VPWR _1613_ sky130_fd_sc_hd__mux2_1
X_7127_ u_input_buffer.fifo_mem\[51\]\[8\] _2990_ _2993_ u_input_buffer.fifo_mem\[11\]\[8\]
+ _3370_ VGND VGND VPWR VPWR _3371_ sky130_fd_sc_hd__a221o_1
X_7058_ u_input_buffer.fifo_mem\[52\]\[6\] _3039_ _3041_ u_input_buffer.fifo_mem\[56\]\[6\]
+ VGND VGND VPWR VPWR _3304_ sky130_fd_sc_hd__a22o_1
X_6009_ net803 _2500_ _2549_ VGND VGND VPWR VPWR _2551_ sky130_fd_sc_hd__mux2_1
XFILLER_0_96_302 VGND VGND VPWR VPWR sky130_fd_sc_hd__decap_6
Xclkbuf_leaf_66_clk clknet_3_6__leaf_clk VGND VGND VPWR VPWR clknet_leaf_66_clk sky130_fd_sc_hd__clkbuf_16
XTAP_1203 VGND VPWR sky130_fd_sc_hd__tapvpwrvgnd_1
XTAP_1214 VGND VPWR sky130_fd_sc_hd__tapvpwrvgnd_1
XTAP_1247 VGND VPWR sky130_fd_sc_hd__tapvpwrvgnd_1
XTAP_1236 VGND VPWR sky130_fd_sc_hd__tapvpwrvgnd_1
XTAP_1225 VGND VPWR sky130_fd_sc_hd__tapvpwrvgnd_1
XTAP_1269 VGND VPWR sky130_fd_sc_hd__tapvpwrvgnd_1
XTAP_1258 VGND VPWR sky130_fd_sc_hd__tapvpwrvgnd_1
XFILLER_0_24_118 VGND VGND VPWR VPWR sky130_fd_sc_hd__decap_4
XFILLER_0_32_184 VGND VGND VPWR VPWR sky130_fd_sc_hd__fill_1
Xclkbuf_leaf_57_clk clknet_3_7__leaf_clk VGND VGND VPWR VPWR clknet_leaf_57_clk sky130_fd_sc_hd__clkbuf_16
XFILLER_0_1_18 VPWR VGND VPWR VGND sky130_ef_sc_hd__decap_12
XFILLER_0_87_346 VGND VGND VPWR VPWR sky130_fd_sc_hd__decap_4
X_4690_ _1821_ VGND VGND VPWR VPWR _0246_ sky130_fd_sc_hd__clkbuf_1
XFILLER_0_70_213 VGND VGND VPWR VPWR sky130_fd_sc_hd__decap_4
XFILLER_0_43_449 VGND VGND VPWR VPWR sky130_fd_sc_hd__fill_1
XFILLER_0_113_337 VGND VGND VPWR VPWR sky130_fd_sc_hd__decap_6
XFILLER_0_113_326 VGND VGND VPWR VPWR sky130_fd_sc_hd__fill_2
XFILLER_0_102_65 VPWR VGND VPWR VGND sky130_ef_sc_hd__decap_12
X_6360_ _2739_ VGND VGND VPWR VPWR _0998_ sky130_fd_sc_hd__clkbuf_1
XFILLER_0_24_641 VGND VGND VPWR VPWR sky130_fd_sc_hd__decap_3
XFILLER_0_24_663 VGND VGND VPWR VPWR sky130_fd_sc_hd__decap_3
XFILLER_0_23_173 VGND VGND VPWR VPWR sky130_fd_sc_hd__fill_1
X_5311_ net902 _2012_ _2150_ VGND VGND VPWR VPWR _2163_ sky130_fd_sc_hd__mux2_1
X_6291_ _2702_ VGND VGND VPWR VPWR _0966_ sky130_fd_sc_hd__clkbuf_1
XFILLER_0_11_335 VGND VGND VPWR VPWR sky130_fd_sc_hd__fill_1
X_8030_ clknet_leaf_4_clk _0119_ VGND VGND VPWR VPWR u_input_buffer.fifo_mem\[61\]\[4\]
+ sky130_fd_sc_hd__dfxtp_1
X_5242_ _2126_ VGND VGND VPWR VPWR _0493_ sky130_fd_sc_hd__clkbuf_1
X_5173_ _2089_ VGND VGND VPWR VPWR _0461_ sky130_fd_sc_hd__clkbuf_1
X_4124_ _1441_ u_sensor_interface.sensor_array\[3\]\[10\] net113 VGND VGND VPWR VPWR
+ _1442_ sky130_fd_sc_hd__mux2_1
Xinput1 cfg_addr[0] VGND VGND VPWR VPWR net1 sky130_fd_sc_hd__clkbuf_2
Xclkbuf_leaf_48_clk clknet_3_7__leaf_clk VGND VGND VPWR VPWR clknet_leaf_48_clk sky130_fd_sc_hd__clkbuf_16
X_4055_ _1377_ _1382_ _0000_ VGND VGND VPWR VPWR _1383_ sky130_fd_sc_hd__mux2_1
X_8932_ clknet_leaf_104_clk _1021_ VGND VGND VPWR VPWR u_input_buffer.fifo_mem\[5\]\[10\]
+ sky130_fd_sc_hd__dfxtp_1
X_8863_ clknet_leaf_20_clk _0952_ VGND VGND VPWR VPWR u_input_buffer.fifo_mem\[9\]\[5\]
+ sky130_fd_sc_hd__dfxtp_1
XFILLER_0_93_305 VPWR VGND VPWR VGND sky130_ef_sc_hd__decap_12
X_7814_ net12 u_register_bank.sensor_enable\[0\] _3905_ VGND VGND VPWR VPWR _3906_
+ sky130_fd_sc_hd__mux2_1
XFILLER_0_93_327 VGND VGND VPWR VPWR sky130_fd_sc_hd__decap_8
XFILLER_0_19_402 VGND VGND VPWR VPWR sky130_fd_sc_hd__fill_2
X_8794_ clknet_leaf_2_clk _0883_ VGND VGND VPWR VPWR u_input_buffer.fifo_mem\[13\]\[0\]
+ sky130_fd_sc_hd__dfxtp_1
X_7745_ _3861_ net129 _3852_ VGND VGND VPWR VPWR _3862_ sky130_fd_sc_hd__mux2_1
X_4957_ _1966_ VGND VGND VPWR VPWR _0368_ sky130_fd_sc_hd__clkbuf_1
X_7676_ _3807_ VGND VGND VPWR VPWR _1246_ sky130_fd_sc_hd__clkbuf_1
X_4888_ net529 _1734_ _1911_ VGND VGND VPWR VPWR _1928_ sky130_fd_sc_hd__mux2_1
XFILLER_0_61_213 VGND VGND VPWR VPWR sky130_fd_sc_hd__decap_4
XFILLER_0_34_449 VGND VGND VPWR VPWR sky130_fd_sc_hd__fill_1
X_6627_ _2885_ _2882_ _2878_ VGND VGND VPWR VPWR _2886_ sky130_fd_sc_hd__and3_4
XFILLER_0_46_287 VGND VGND VPWR VPWR sky130_fd_sc_hd__fill_1
X_6558_ _2844_ VGND VGND VPWR VPWR _1091_ sky130_fd_sc_hd__clkbuf_1
XFILLER_0_15_641 VGND VGND VPWR VPWR sky130_fd_sc_hd__decap_6
X_6489_ net536 _1376_ _2807_ VGND VGND VPWR VPWR _2808_ sky130_fd_sc_hd__mux2_1
XFILLER_0_30_655 VGND VGND VPWR VPWR sky130_fd_sc_hd__decap_8
XFILLER_0_42_493 VGND VGND VPWR VPWR sky130_fd_sc_hd__fill_2
X_5509_ _1600_ _2242_ VGND VGND VPWR VPWR _2276_ sky130_fd_sc_hd__nor2_4
X_8228_ clknet_leaf_99_clk _0317_ VGND VGND VPWR VPWR u_input_buffer.fifo_mem\[49\]\[10\]
+ sky130_fd_sc_hd__dfxtp_1
XFILLER_0_100_565 VGND VGND VPWR VPWR sky130_fd_sc_hd__fill_1
X_8159_ clknet_leaf_2_clk _0248_ VGND VGND VPWR VPWR u_input_buffer.fifo_mem\[53\]\[5\]
+ sky130_fd_sc_hd__dfxtp_1
Xclkbuf_leaf_39_clk clknet_3_4__leaf_clk VGND VGND VPWR VPWR clknet_leaf_39_clk sky130_fd_sc_hd__clkbuf_16
XFILLER_0_69_357 VGND VGND VPWR VPWR sky130_fd_sc_hd__fill_1
XTAP_1022 VGND VPWR sky130_fd_sc_hd__tapvpwrvgnd_1
XTAP_1011 VGND VPWR sky130_fd_sc_hd__tapvpwrvgnd_1
XTAP_1000 VGND VPWR sky130_fd_sc_hd__tapvpwrvgnd_1
XTAP_1044 VGND VPWR sky130_fd_sc_hd__tapvpwrvgnd_1
XTAP_1055 VGND VPWR sky130_fd_sc_hd__tapvpwrvgnd_1
XTAP_1033 VGND VPWR sky130_fd_sc_hd__tapvpwrvgnd_1
XFILLER_0_77_390 VGND VGND VPWR VPWR sky130_fd_sc_hd__fill_2
XTAP_1099 VGND VPWR sky130_fd_sc_hd__tapvpwrvgnd_1
XTAP_1088 VGND VPWR sky130_fd_sc_hd__tapvpwrvgnd_1
XTAP_1077 VGND VPWR sky130_fd_sc_hd__tapvpwrvgnd_1
XTAP_1066 VGND VPWR sky130_fd_sc_hd__tapvpwrvgnd_1
XFILLER_0_106_9 VGND VGND VPWR VPWR sky130_fd_sc_hd__fill_2
XFILLER_0_0_505 VPWR VGND VPWR VGND sky130_ef_sc_hd__decap_12
XTAP_817 VGND VPWR sky130_fd_sc_hd__tapvpwrvgnd_1
XTAP_806 VGND VPWR sky130_fd_sc_hd__tapvpwrvgnd_1
XTAP_828 VGND VPWR sky130_fd_sc_hd__tapvpwrvgnd_1
XTAP_839 VGND VPWR sky130_fd_sc_hd__tapvpwrvgnd_1
XFILLER_0_73_25 VGND VGND VPWR VPWR sky130_fd_sc_hd__fill_1
X_5860_ _2464_ VGND VGND VPWR VPWR _0773_ sky130_fd_sc_hd__clkbuf_1
X_4811_ _1886_ VGND VGND VPWR VPWR _0302_ sky130_fd_sc_hd__clkbuf_1
X_5791_ net1210 _2248_ _2425_ VGND VGND VPWR VPWR _2428_ sky130_fd_sc_hd__mux2_1
XFILLER_0_56_530 VGND VGND VPWR VPWR sky130_fd_sc_hd__fill_2
XFILLER_0_71_500 VGND VGND VPWR VPWR sky130_fd_sc_hd__decap_4
X_7530_ net19 u_register_bank.window_cfg\[16\] _3711_ VGND VGND VPWR VPWR _3718_ sky130_fd_sc_hd__mux2_1
X_4742_ net1017 _1728_ _1835_ VGND VGND VPWR VPWR _1849_ sky130_fd_sc_hd__mux2_1
X_7461_ net286 _1384_ _3678_ VGND VGND VPWR VPWR _3680_ sky130_fd_sc_hd__mux2_1
X_4673_ _1811_ VGND VGND VPWR VPWR _0239_ sky130_fd_sc_hd__clkbuf_1
XFILLER_0_28_298 VGND VGND VPWR VPWR sky130_fd_sc_hd__fill_1
XFILLER_0_114_613 VPWR VGND VPWR VGND sky130_ef_sc_hd__decap_12
X_9200_ net178 _1287_ net212 VGND VGND VPWR VPWR u_register_bank.sensor_enable\[1\]
+ sky130_fd_sc_hd__dfrtp_1
X_6412_ _2766_ VGND VGND VPWR VPWR _1023_ sky130_fd_sc_hd__clkbuf_1
XFILLER_0_114_657 VPWR VGND VPWR VGND sky130_ef_sc_hd__decap_12
XFILLER_0_98_77 VGND VGND VPWR VPWR sky130_fd_sc_hd__decap_6
X_7392_ u_input_buffer.fifo_mem\[1\]\[15\] _2931_ _3626_ _3628_ VGND VGND VPWR VPWR
+ _3629_ sky130_fd_sc_hd__a211o_1
XFILLER_0_24_460 VGND VGND VPWR VPWR sky130_fd_sc_hd__decap_3
XFILLER_0_113_167 VGND VGND VPWR VPWR sky130_fd_sc_hd__fill_1
X_6343_ net901 _2522_ _2716_ VGND VGND VPWR VPWR _2730_ sky130_fd_sc_hd__mux2_1
X_9131_ net170 _1219_ net202 VGND VGND VPWR VPWR u_analytics_engine.threshold\[13\]
+ sky130_fd_sc_hd__dfrtp_2
X_6274_ _1626_ net1110 _2679_ VGND VGND VPWR VPWR _2693_ sky130_fd_sc_hd__mux2_1
X_9062_ clknet_leaf_106_clk _1151_ VGND VGND VPWR VPWR u_sensor_interface.sensor_array\[3\]\[9\]
+ sky130_fd_sc_hd__dfxtp_1
X_5225_ net811 _1994_ _2115_ VGND VGND VPWR VPWR _2118_ sky130_fd_sc_hd__mux2_1
X_8013_ clknet_leaf_43_clk _0102_ VGND VGND VPWR VPWR u_input_buffer.fifo_mem\[62\]\[3\]
+ sky130_fd_sc_hd__dfxtp_1
XFILLER_0_44_3 VGND VGND VPWR VPWR sky130_fd_sc_hd__decap_8
X_5156_ net407 _1994_ _2078_ VGND VGND VPWR VPWR _2081_ sky130_fd_sc_hd__mux2_1
X_5087_ _2044_ VGND VGND VPWR VPWR _0420_ sky130_fd_sc_hd__clkbuf_1
X_4107_ _1426_ VGND VGND VPWR VPWR _1427_ sky130_fd_sc_hd__buf_2
X_8915_ clknet_leaf_65_clk _1004_ VGND VGND VPWR VPWR u_input_buffer.fifo_mem\[6\]\[9\]
+ sky130_fd_sc_hd__dfxtp_1
X_4038_ net353 net48 _1367_ VGND VGND VPWR VPWR _1371_ sky130_fd_sc_hd__mux2_1
XFILLER_0_2_83 VGND VGND VPWR VPWR sky130_fd_sc_hd__fill_1
X_8846_ clknet_leaf_36_clk _0935_ VGND VGND VPWR VPWR u_input_buffer.fifo_mem\[10\]\[4\]
+ sky130_fd_sc_hd__dfxtp_1
XFILLER_0_78_176 VGND VGND VPWR VPWR sky130_fd_sc_hd__fill_1
XFILLER_0_63_80 VGND VGND VPWR VPWR sky130_fd_sc_hd__fill_2
XPHY_116 VGND VGND VPWR VPWR sky130_fd_sc_hd__decap_3
XPHY_105 VGND VGND VPWR VPWR sky130_fd_sc_hd__decap_3
XPHY_149 VGND VGND VPWR VPWR sky130_fd_sc_hd__decap_3
XPHY_138 VGND VGND VPWR VPWR sky130_fd_sc_hd__decap_3
XPHY_127 VGND VGND VPWR VPWR sky130_fd_sc_hd__decap_3
X_5989_ _1618_ net1281 _2531_ VGND VGND VPWR VPWR _2540_ sky130_fd_sc_hd__mux2_1
X_8777_ clknet_leaf_95_clk _0866_ VGND VGND VPWR VPWR u_input_buffer.fifo_mem\[15\]\[15\]
+ sky130_fd_sc_hd__dfxtp_1
X_7728_ net167 VGND VGND VPWR VPWR _3848_ sky130_fd_sc_hd__clkbuf_4
XFILLER_0_62_533 VGND VGND VPWR VPWR sky130_fd_sc_hd__decap_4
XANTENNA_50 u_analytics_engine.data_in\[13\] VGND VGND VPWR VPWR sky130_fd_sc_hd__diode_2
X_7659_ _3794_ net140 _3782_ VGND VGND VPWR VPWR _3795_ sky130_fd_sc_hd__mux2_1
XFILLER_0_105_635 VGND VGND VPWR VPWR sky130_fd_sc_hd__fill_2
XANTENNA_61 _2077_ VGND VGND VPWR VPWR sky130_fd_sc_hd__diode_2
XFILLER_0_7_671 VGND VGND VPWR VPWR sky130_fd_sc_hd__fill_1
XFILLER_0_34_246 VGND VGND VPWR VPWR sky130_fd_sc_hd__decap_3
XFILLER_0_15_460 VGND VGND VPWR VPWR sky130_fd_sc_hd__fill_2
XFILLER_0_30_496 VGND VGND VPWR VPWR sky130_fd_sc_hd__fill_1
XFILLER_0_100_362 VGND VGND VPWR VPWR sky130_fd_sc_hd__fill_2
XPHY_7 VGND VGND VPWR VPWR sky130_fd_sc_hd__decap_3
XFILLER_0_38_530 VGND VGND VPWR VPWR sky130_fd_sc_hd__fill_2
XFILLER_0_25_213 VGND VGND VPWR VPWR sky130_fd_sc_hd__decap_4
XFILLER_0_4_118 VGND VGND VPWR VPWR sky130_fd_sc_hd__fill_1
XFILLER_0_21_430 VGND VGND VPWR VPWR sky130_fd_sc_hd__fill_2
Xhold309 u_input_buffer.fifo_mem\[2\]\[14\] VGND VGND VPWR VPWR net521 sky130_fd_sc_hd__dlygate4sd3_1
XFILLER_0_0_335 VGND VGND VPWR VPWR sky130_fd_sc_hd__fill_1
XTAP_603 VGND VPWR sky130_fd_sc_hd__tapvpwrvgnd_1
XTAP_614 VGND VPWR sky130_fd_sc_hd__tapvpwrvgnd_1
XTAP_625 VGND VPWR sky130_fd_sc_hd__tapvpwrvgnd_1
X_5010_ _1997_ VGND VGND VPWR VPWR _0390_ sky130_fd_sc_hd__clkbuf_1
XTAP_636 VGND VPWR sky130_fd_sc_hd__tapvpwrvgnd_1
XTAP_658 VGND VPWR sky130_fd_sc_hd__tapvpwrvgnd_1
XTAP_647 VGND VPWR sky130_fd_sc_hd__tapvpwrvgnd_1
XTAP_669 VGND VPWR sky130_fd_sc_hd__tapvpwrvgnd_1
Xhold1009 u_input_buffer.fifo_mem\[53\]\[6\] VGND VGND VPWR VPWR net1221 sky130_fd_sc_hd__dlygate4sd3_1
XFILLER_0_108_53 VPWR VGND VPWR VGND sky130_ef_sc_hd__decap_12
XFILLER_0_84_68 VGND VGND VPWR VPWR sky130_fd_sc_hd__decap_3
X_8700_ clknet_leaf_60_clk _0789_ VGND VGND VPWR VPWR u_input_buffer.fifo_mem\[19\]\[2\]
+ sky130_fd_sc_hd__dfxtp_1
X_6961_ u_input_buffer.fifo_mem\[17\]\[4\] _2943_ _2945_ u_input_buffer.fifo_mem\[5\]\[4\]
+ VGND VGND VPWR VPWR _3209_ sky130_fd_sc_hd__a22o_1
X_6892_ u_input_buffer.fifo_mem\[50\]\[2\] _2995_ _2997_ u_input_buffer.fifo_mem\[4\]\[2\]
+ VGND VGND VPWR VPWR _3142_ sky130_fd_sc_hd__a22o_1
X_5912_ _2491_ VGND VGND VPWR VPWR _0798_ sky130_fd_sc_hd__clkbuf_1
XFILLER_0_76_658 VGND VGND VPWR VPWR sky130_fd_sc_hd__decap_8
X_5843_ _1624_ net1225 _2442_ VGND VGND VPWR VPWR _2455_ sky130_fd_sc_hd__mux2_1
X_8631_ clknet_leaf_76_clk _0720_ VGND VGND VPWR VPWR u_input_buffer.fifo_mem\[24\]\[13\]
+ sky130_fd_sc_hd__dfxtp_1
XFILLER_0_48_349 VGND VGND VPWR VPWR sky130_fd_sc_hd__decap_4
XFILLER_0_91_617 VGND VGND VPWR VPWR sky130_fd_sc_hd__fill_1
X_8562_ clknet_leaf_69_clk _0651_ VGND VGND VPWR VPWR u_input_buffer.fifo_mem\[28\]\[8\]
+ sky130_fd_sc_hd__dfxtp_1
X_7513_ net42 u_register_bank.window_cfg\[8\] _3700_ VGND VGND VPWR VPWR _3709_ sky130_fd_sc_hd__mux2_1
X_5774_ _2418_ VGND VGND VPWR VPWR _0733_ sky130_fd_sc_hd__clkbuf_1
X_8493_ clknet_leaf_24_clk _0582_ VGND VGND VPWR VPWR u_input_buffer.fifo_mem\[32\]\[3\]
+ sky130_fd_sc_hd__dfxtp_1
X_4725_ _1840_ VGND VGND VPWR VPWR _0262_ sky130_fd_sc_hd__clkbuf_1
XFILLER_0_16_246 VGND VGND VPWR VPWR sky130_fd_sc_hd__decap_3
X_4656_ net721 _1712_ _1798_ VGND VGND VPWR VPWR _1803_ sky130_fd_sc_hd__mux2_1
X_7444_ _3670_ VGND VGND VPWR VPWR _1151_ sky130_fd_sc_hd__clkbuf_1
X_4587_ net1092 _1716_ _1757_ VGND VGND VPWR VPWR _1764_ sky130_fd_sc_hd__mux2_1
Xhold821 u_input_buffer.fifo_mem\[9\]\[2\] VGND VGND VPWR VPWR net1033 sky130_fd_sc_hd__dlygate4sd3_1
XFILLER_0_12_430 VGND VGND VPWR VPWR sky130_fd_sc_hd__fill_2
Xinput70 sensor_data_in[31] VGND VGND VPWR VPWR net70 sky130_fd_sc_hd__clkbuf_1
Xinput81 sensor_data_in[41] VGND VGND VPWR VPWR net81 sky130_fd_sc_hd__clkbuf_1
Xhold810 u_input_buffer.fifo_mem\[1\]\[3\] VGND VGND VPWR VPWR net1022 sky130_fd_sc_hd__dlygate4sd3_1
X_7375_ u_input_buffer.fifo_mem\[15\]\[14\] _3059_ _3061_ u_input_buffer.fifo_mem\[43\]\[14\]
+ VGND VGND VPWR VPWR _3613_ sky130_fd_sc_hd__a22o_1
X_9114_ net176 _1202_ net208 VGND VGND VPWR VPWR u_register_bank.window_cfg\[28\]
+ sky130_fd_sc_hd__dfrtp_1
X_6326_ _2721_ VGND VGND VPWR VPWR _0982_ sky130_fd_sc_hd__clkbuf_1
Xhold832 u_input_buffer.fifo_mem\[17\]\[13\] VGND VGND VPWR VPWR net1044 sky130_fd_sc_hd__dlygate4sd3_1
Xhold854 u_input_buffer.fifo_mem\[41\]\[13\] VGND VGND VPWR VPWR net1066 sky130_fd_sc_hd__dlygate4sd3_1
Xinput92 sensor_data_in[51] VGND VGND VPWR VPWR net92 sky130_fd_sc_hd__buf_1
Xhold843 u_input_buffer.fifo_mem\[33\]\[3\] VGND VGND VPWR VPWR net1055 sky130_fd_sc_hd__dlygate4sd3_1
Xhold865 u_input_buffer.fifo_mem\[54\]\[1\] VGND VGND VPWR VPWR net1077 sky130_fd_sc_hd__dlygate4sd3_1
XFILLER_0_12_485 VPWR VGND VPWR VGND sky130_ef_sc_hd__decap_12
Xhold887 u_input_buffer.fifo_mem\[46\]\[15\] VGND VGND VPWR VPWR net1099 sky130_fd_sc_hd__dlygate4sd3_1
Xhold898 u_input_buffer.fifo_mem\[9\]\[12\] VGND VGND VPWR VPWR net1110 sky130_fd_sc_hd__dlygate4sd3_1
Xhold876 u_input_buffer.fifo_mem\[38\]\[11\] VGND VGND VPWR VPWR net1088 sky130_fd_sc_hd__dlygate4sd3_1
X_6257_ _2684_ VGND VGND VPWR VPWR _0950_ sky130_fd_sc_hd__clkbuf_1
X_9045_ clknet_leaf_69_clk net251 VGND VGND VPWR VPWR u_analytics_engine.data_in\[8\]
+ sky130_fd_sc_hd__dfxtp_2
X_6188_ net1014 _2504_ _2644_ VGND VGND VPWR VPWR _2648_ sky130_fd_sc_hd__mux2_1
X_5208_ _2108_ VGND VGND VPWR VPWR _0477_ sky130_fd_sc_hd__clkbuf_1
X_5139_ _2071_ VGND VGND VPWR VPWR _0445_ sky130_fd_sc_hd__clkbuf_1
XFILLER_0_66_102 VGND VGND VPWR VPWR sky130_fd_sc_hd__fill_2
X_8829_ clknet_leaf_16_clk _0918_ VGND VGND VPWR VPWR u_input_buffer.fifo_mem\[11\]\[3\]
+ sky130_fd_sc_hd__dfxtp_1
XFILLER_0_94_477 VGND VGND VPWR VPWR sky130_fd_sc_hd__decap_4
XFILLER_0_22_216 VGND VGND VPWR VPWR sky130_fd_sc_hd__fill_2
XFILLER_0_22_227 VGND VGND VPWR VPWR sky130_fd_sc_hd__fill_2
XFILLER_0_22_249 VGND VGND VPWR VPWR sky130_fd_sc_hd__decap_3
XFILLER_0_101_671 VGND VGND VPWR VPWR sky130_fd_sc_hd__fill_1
XFILLER_0_97_293 VGND VGND VPWR VPWR sky130_fd_sc_hd__decap_3
XFILLER_0_85_477 VPWR VGND VPWR VGND sky130_ef_sc_hd__decap_12
XFILLER_0_72_127 VGND VGND VPWR VPWR sky130_fd_sc_hd__decap_4
XFILLER_0_79_35 VPWR VGND VPWR VGND sky130_ef_sc_hd__decap_12
X_4510_ _1420_ VGND VGND VPWR VPWR _1718_ sky130_fd_sc_hd__buf_4
X_5490_ _2263_ VGND VGND VPWR VPWR _0604_ sky130_fd_sc_hd__clkbuf_1
XFILLER_0_5_449 VGND VGND VPWR VPWR sky130_fd_sc_hd__decap_8
XFILLER_0_110_21 VGND VGND VPWR VPWR sky130_fd_sc_hd__decap_6
XFILLER_0_102_3 VPWR VGND VPWR VGND sky130_ef_sc_hd__decap_12
Xhold106 u_input_buffer.fifo_mem\[24\]\[1\] VGND VGND VPWR VPWR net318 sky130_fd_sc_hd__dlygate4sd3_1
X_4441_ net958 _1628_ _1660_ VGND VGND VPWR VPWR _1675_ sky130_fd_sc_hd__mux2_1
Xhold117 u_input_buffer.fifo_mem\[28\]\[13\] VGND VGND VPWR VPWR net329 sky130_fd_sc_hd__dlygate4sd3_1
XFILLER_0_110_65 VPWR VGND VPWR VGND sky130_ef_sc_hd__decap_12
Xhold139 u_input_buffer.fifo_mem\[10\]\[1\] VGND VGND VPWR VPWR net351 sky130_fd_sc_hd__dlygate4sd3_1
X_7160_ u_input_buffer.fifo_mem\[36\]\[9\] _2951_ _2955_ u_input_buffer.fifo_mem\[35\]\[9\]
+ _3402_ VGND VGND VPWR VPWR _3403_ sky130_fd_sc_hd__a221o_1
Xhold128 u_input_buffer.fifo_mem\[2\]\[15\] VGND VGND VPWR VPWR net340 sky130_fd_sc_hd__dlygate4sd3_1
XTAP_400 VGND VPWR sky130_fd_sc_hd__tapvpwrvgnd_1
X_6111_ _1639_ _2605_ VGND VGND VPWR VPWR _2606_ sky130_fd_sc_hd__nand2_4
X_4372_ _1597_ u_input_buffer.wr_ptr\[2\] VGND VGND VPWR VPWR _1635_ sky130_fd_sc_hd__nand2_1
X_7091_ u_input_buffer.fifo_mem\[47\]\[7\] _2879_ _3007_ _3009_ u_input_buffer.fifo_mem\[24\]\[7\]
+ VGND VGND VPWR VPWR _3336_ sky130_fd_sc_hd__a32o_1
XFILLER_0_0_165 VGND VGND VPWR VPWR sky130_fd_sc_hd__decap_3
XTAP_422 VGND VPWR sky130_fd_sc_hd__tapvpwrvgnd_1
XTAP_411 VGND VPWR sky130_fd_sc_hd__tapvpwrvgnd_1
XTAP_433 VGND VPWR sky130_fd_sc_hd__tapvpwrvgnd_1
XFILLER_0_95_89 VGND VGND VPWR VPWR sky130_fd_sc_hd__decap_3
X_6042_ _2568_ VGND VGND VPWR VPWR _2569_ sky130_fd_sc_hd__buf_4
XTAP_444 VGND VPWR sky130_fd_sc_hd__tapvpwrvgnd_1
XTAP_455 VGND VPWR sky130_fd_sc_hd__tapvpwrvgnd_1
XTAP_466 VGND VPWR sky130_fd_sc_hd__tapvpwrvgnd_1
XTAP_488 VGND VPWR sky130_fd_sc_hd__tapvpwrvgnd_1
XTAP_477 VGND VPWR sky130_fd_sc_hd__tapvpwrvgnd_1
XTAP_499 VGND VPWR sky130_fd_sc_hd__tapvpwrvgnd_1
X_7993_ clknet_leaf_82_clk _0082_ net187 VGND VGND VPWR VPWR u_sample_counter.sample_count\[16\]
+ sky130_fd_sc_hd__dfrtp_1
X_6944_ u_input_buffer.fifo_mem\[39\]\[3\] _3050_ _3052_ u_input_buffer.fifo_mem\[40\]\[3\]
+ VGND VGND VPWR VPWR _3193_ sky130_fd_sc_hd__a22o_1
X_6875_ _3107_ _3116_ _3125_ VGND VGND VPWR VPWR _3126_ sky130_fd_sc_hd__or3_1
X_8614_ clknet_leaf_108_clk _0703_ VGND VGND VPWR VPWR u_input_buffer.fifo_mem\[25\]\[12\]
+ sky130_fd_sc_hd__dfxtp_1
XFILLER_0_63_127 VGND VGND VPWR VPWR sky130_fd_sc_hd__fill_1
X_5826_ _2446_ VGND VGND VPWR VPWR _0757_ sky130_fd_sc_hd__clkbuf_1
X_5757_ net633 _2248_ _2407_ VGND VGND VPWR VPWR _2410_ sky130_fd_sc_hd__mux2_1
XFILLER_0_91_458 VGND VGND VPWR VPWR sky130_fd_sc_hd__fill_1
XFILLER_0_17_555 VGND VGND VPWR VPWR sky130_fd_sc_hd__decap_4
X_8545_ clknet_leaf_1_clk _0634_ VGND VGND VPWR VPWR u_input_buffer.fifo_mem\[29\]\[7\]
+ sky130_fd_sc_hd__dfxtp_1
X_8476_ clknet_leaf_5_clk _0565_ VGND VGND VPWR VPWR u_input_buffer.fifo_mem\[33\]\[2\]
+ sky130_fd_sc_hd__dfxtp_1
X_4708_ _1830_ VGND VGND VPWR VPWR _0255_ sky130_fd_sc_hd__clkbuf_1
X_7427_ _3661_ VGND VGND VPWR VPWR _1143_ sky130_fd_sc_hd__clkbuf_1
X_5688_ _1606_ net1234 _2370_ VGND VGND VPWR VPWR _2373_ sky130_fd_sc_hd__mux2_1
XFILLER_0_4_493 VPWR VGND VPWR VGND sky130_ef_sc_hd__decap_12
X_4639_ _1792_ VGND VGND VPWR VPWR _0224_ sky130_fd_sc_hd__clkbuf_1
Xhold640 u_input_buffer.fifo_mem\[39\]\[4\] VGND VGND VPWR VPWR net852 sky130_fd_sc_hd__dlygate4sd3_1
Xhold662 u_input_buffer.fifo_mem\[3\]\[6\] VGND VGND VPWR VPWR net874 sky130_fd_sc_hd__dlygate4sd3_1
X_7358_ u_input_buffer.fifo_mem\[2\]\[14\] _2983_ _2985_ u_input_buffer.fifo_mem\[32\]\[14\]
+ VGND VGND VPWR VPWR _3596_ sky130_fd_sc_hd__a22o_1
Xhold651 u_input_buffer.fifo_mem\[54\]\[12\] VGND VGND VPWR VPWR net863 sky130_fd_sc_hd__dlygate4sd3_1
Xhold695 u_input_buffer.fifo_mem\[6\]\[4\] VGND VGND VPWR VPWR net907 sky130_fd_sc_hd__dlygate4sd3_1
Xhold684 u_input_buffer.fifo_mem\[60\]\[5\] VGND VGND VPWR VPWR net896 sky130_fd_sc_hd__dlygate4sd3_1
X_7289_ u_input_buffer.fifo_mem\[27\]\[12\] _3012_ _3014_ u_input_buffer.fifo_mem\[59\]\[12\]
+ _3528_ VGND VGND VPWR VPWR _3529_ sky130_fd_sc_hd__a221o_1
X_6309_ _2711_ VGND VGND VPWR VPWR _0975_ sky130_fd_sc_hd__clkbuf_1
Xhold673 u_input_buffer.fifo_mem\[13\]\[0\] VGND VGND VPWR VPWR net885 sky130_fd_sc_hd__dlygate4sd3_1
X_9028_ clknet_leaf_94_clk _1117_ net192 VGND VGND VPWR VPWR u_input_buffer.rd_ptr\[3\]
+ sky130_fd_sc_hd__dfrtp_4
XFILLER_0_24_19 VGND VGND VPWR VPWR sky130_fd_sc_hd__fill_1
XFILLER_0_23_503 VGND VGND VPWR VPWR sky130_fd_sc_hd__fill_1
XFILLER_0_62_193 VGND VGND VPWR VPWR sky130_fd_sc_hd__decap_3
XFILLER_0_2_419 VGND VGND VPWR VPWR sky130_fd_sc_hd__fill_1
XFILLER_0_23_569 VGND VGND VPWR VPWR sky130_fd_sc_hd__decap_8
XFILLER_0_50_355 VGND VGND VPWR VPWR sky130_fd_sc_hd__decap_8
XFILLER_0_31_591 VPWR VGND VPWR VGND sky130_ef_sc_hd__decap_12
XFILLER_0_4_29 VGND VGND VPWR VPWR sky130_fd_sc_hd__decap_8
X_4990_ _1984_ VGND VGND VPWR VPWR _0383_ sky130_fd_sc_hd__clkbuf_1
XFILLER_0_14_41 VPWR VGND VPWR VGND sky130_ef_sc_hd__decap_12
X_3941_ _1318_ net110 net113 net112 VGND VGND VPWR VPWR _1319_ sky130_fd_sc_hd__nor4_2
XFILLER_0_14_85 VGND VGND VPWR VPWR sky130_fd_sc_hd__fill_2
X_6660_ _2910_ _2911_ VGND VGND VPWR VPWR _2912_ sky130_fd_sc_hd__and2_4
XFILLER_0_46_639 VGND VGND VPWR VPWR sky130_fd_sc_hd__decap_4
X_6591_ _1474_ _2861_ net1322 VGND VGND VPWR VPWR _1107_ sky130_fd_sc_hd__o21ba_1
X_5611_ net1137 _2274_ _2314_ VGND VGND VPWR VPWR _2331_ sky130_fd_sc_hd__mux2_1
X_8330_ clknet_leaf_27_clk _0419_ VGND VGND VPWR VPWR u_input_buffer.fifo_mem\[42\]\[0\]
+ sky130_fd_sc_hd__dfxtp_1
X_5542_ _2293_ VGND VGND VPWR VPWR _0626_ sky130_fd_sc_hd__clkbuf_1
X_5473_ _1402_ VGND VGND VPWR VPWR _2252_ sky130_fd_sc_hd__clkbuf_4
X_8261_ clknet_leaf_75_clk _0350_ VGND VGND VPWR VPWR u_input_buffer.fifo_mem\[47\]\[11\]
+ sky130_fd_sc_hd__dfxtp_1
X_8192_ clknet_leaf_37_clk _0281_ VGND VGND VPWR VPWR u_input_buffer.fifo_mem\[51\]\[6\]
+ sky130_fd_sc_hd__dfxtp_1
X_4424_ _1666_ VGND VGND VPWR VPWR _0135_ sky130_fd_sc_hd__clkbuf_1
X_7212_ u_input_buffer.fifo_mem\[30\]\[10\] _3028_ _3030_ u_input_buffer.fifo_mem\[58\]\[10\]
+ VGND VGND VPWR VPWR _3454_ sky130_fd_sc_hd__a22o_1
X_7143_ u_input_buffer.fifo_mem\[3\]\[8\] _3070_ _3072_ u_input_buffer.fifo_mem\[60\]\[8\]
+ VGND VGND VPWR VPWR _3387_ sky130_fd_sc_hd__a22o_1
XFILLER_0_1_485 VPWR VGND VPWR VGND sky130_ef_sc_hd__decap_12
X_4355_ _1623_ VGND VGND VPWR VPWR _0109_ sky130_fd_sc_hd__clkbuf_1
XTAP_241 VGND VPWR sky130_fd_sc_hd__tapvpwrvgnd_1
X_7074_ u_input_buffer.fifo_mem\[33\]\[7\] _2898_ _2904_ u_input_buffer.fifo_mem\[61\]\[7\]
+ _3318_ VGND VGND VPWR VPWR _3319_ sky130_fd_sc_hd__a221o_1
X_4286_ u_analytics_engine.threshold\[6\] _1560_ _1563_ u_analytics_engine.threshold\[5\]
+ VGND VGND VPWR VPWR _1566_ sky130_fd_sc_hd__a22o_1
XTAP_263 VGND VPWR sky130_fd_sc_hd__tapvpwrvgnd_1
XTAP_252 VGND VPWR sky130_fd_sc_hd__tapvpwrvgnd_1
XTAP_274 VGND VPWR sky130_fd_sc_hd__tapvpwrvgnd_1
X_6025_ net310 _2516_ _2549_ VGND VGND VPWR VPWR _2559_ sky130_fd_sc_hd__mux2_1
XTAP_296 VGND VPWR sky130_fd_sc_hd__tapvpwrvgnd_1
XTAP_285 VGND VPWR sky130_fd_sc_hd__tapvpwrvgnd_1
XFILLER_0_55_92 VGND VGND VPWR VPWR sky130_fd_sc_hd__fill_1
XTAP_1429 VGND VPWR sky130_fd_sc_hd__tapvpwrvgnd_1
XTAP_1418 VGND VPWR sky130_fd_sc_hd__tapvpwrvgnd_1
XTAP_1407 VGND VPWR sky130_fd_sc_hd__tapvpwrvgnd_1
X_7976_ clknet_leaf_39_clk _0000_ net194 VGND VGND VPWR VPWR u_analytics_engine.data_valid
+ sky130_fd_sc_hd__dfrtp_4
X_6927_ u_input_buffer.fifo_mem\[16\]\[3\] _2971_ _2973_ u_input_buffer.fifo_mem\[49\]\[3\]
+ _2975_ VGND VGND VPWR VPWR _3176_ sky130_fd_sc_hd__a221o_1
XFILLER_0_37_617 VGND VGND VPWR VPWR sky130_fd_sc_hd__decap_8
X_6858_ u_input_buffer.fifo_mem\[8\]\[1\] _3004_ _3006_ u_input_buffer.fifo_mem\[19\]\[1\]
+ _3108_ VGND VGND VPWR VPWR _3109_ sky130_fd_sc_hd__a221o_1
XFILLER_0_9_541 VPWR VGND VPWR VGND sky130_ef_sc_hd__decap_12
XFILLER_0_49_499 VGND VGND VPWR VPWR sky130_fd_sc_hd__fill_2
XFILLER_0_91_222 VGND VGND VPWR VPWR sky130_fd_sc_hd__fill_2
XFILLER_0_9_585 VPWR VGND VPWR VGND sky130_ef_sc_hd__decap_12
X_5809_ net518 _2266_ _2424_ VGND VGND VPWR VPWR _2437_ sky130_fd_sc_hd__mux2_1
XFILLER_0_91_277 VGND VGND VPWR VPWR sky130_fd_sc_hd__decap_3
X_8528_ clknet_leaf_59_clk _0617_ VGND VGND VPWR VPWR u_input_buffer.fifo_mem\[30\]\[6\]
+ sky130_fd_sc_hd__dfxtp_1
XFILLER_0_17_341 VGND VGND VPWR VPWR sky130_fd_sc_hd__fill_1
XFILLER_0_17_374 VGND VGND VPWR VPWR sky130_fd_sc_hd__decap_4
XFILLER_0_45_650 VPWR VGND VPWR VGND sky130_ef_sc_hd__decap_12
XFILLER_0_45_683 VGND VGND VPWR VPWR sky130_fd_sc_hd__decap_3
X_6789_ _3040_ VGND VGND VPWR VPWR _3041_ sky130_fd_sc_hd__buf_4
X_8459_ clknet_leaf_17_clk _0548_ VGND VGND VPWR VPWR u_input_buffer.fifo_mem\[34\]\[1\]
+ sky130_fd_sc_hd__dfxtp_1
Xhold481 u_input_buffer.fifo_mem\[34\]\[14\] VGND VGND VPWR VPWR net693 sky130_fd_sc_hd__dlygate4sd3_1
Xhold470 u_input_buffer.fifo_mem\[43\]\[15\] VGND VGND VPWR VPWR net682 sky130_fd_sc_hd__dlygate4sd3_1
Xhold492 u_input_buffer.fifo_mem\[35\]\[4\] VGND VGND VPWR VPWR net704 sky130_fd_sc_hd__dlygate4sd3_1
XFILLER_0_99_322 VGND VGND VPWR VPWR sky130_fd_sc_hd__decap_6
XFILLER_0_95_583 VGND VGND VPWR VPWR sky130_fd_sc_hd__decap_4
XFILLER_0_55_447 VGND VGND VPWR VPWR sky130_fd_sc_hd__fill_1
XFILLER_0_82_277 VGND VGND VPWR VPWR sky130_fd_sc_hd__fill_2
XFILLER_0_23_322 VGND VGND VPWR VPWR sky130_fd_sc_hd__decap_4
XFILLER_0_51_631 VGND VGND VPWR VPWR sky130_fd_sc_hd__decap_3
XFILLER_0_11_517 VPWR VGND VPWR VGND sky130_ef_sc_hd__decap_12
X_4140_ _1455_ VGND VGND VPWR VPWR _0062_ sky130_fd_sc_hd__clkbuf_1
X_4071_ u_input_buffer.data_in\[3\] VGND VGND VPWR VPWR _1396_ sky130_fd_sc_hd__clkbuf_4
X_7830_ net42 u_register_bank.sensor_enable\[8\] _3905_ VGND VGND VPWR VPWR _3914_
+ sky130_fd_sc_hd__mux2_1
X_4973_ _1403_ net1172 _1971_ VGND VGND VPWR VPWR _1976_ sky130_fd_sc_hd__mux2_1
X_7761_ _3873_ net133 _3852_ VGND VGND VPWR VPWR _3874_ sky130_fd_sc_hd__mux2_1
X_7692_ _3820_ net116 _3817_ VGND VGND VPWR VPWR _3821_ sky130_fd_sc_hd__mux2_1
X_6712_ u_input_buffer.rd_ptr\[0\] u_input_buffer.rd_ptr\[3\] u_input_buffer.rd_ptr\[2\]
+ u_input_buffer.rd_ptr\[1\] VGND VGND VPWR VPWR _2964_ sky130_fd_sc_hd__or4b_4
XFILLER_0_6_500 VPWR VGND VPWR VGND sky130_ef_sc_hd__decap_12
XFILLER_0_18_138 VGND VGND VPWR VPWR sky130_fd_sc_hd__fill_2
X_6643_ u_input_buffer.rd_ptr\[4\] u_input_buffer.rd_ptr\[5\] VGND VGND VPWR VPWR
+ _2895_ sky130_fd_sc_hd__or2b_2
XFILLER_0_6_533 VPWR VGND VPWR VGND sky130_ef_sc_hd__decap_12
X_6574_ _2852_ VGND VGND VPWR VPWR _1099_ sky130_fd_sc_hd__clkbuf_1
XFILLER_0_14_300 VGND VGND VPWR VPWR sky130_fd_sc_hd__fill_1
XFILLER_0_26_182 VGND VGND VPWR VPWR sky130_fd_sc_hd__fill_1
X_5525_ net878 _2258_ _2277_ VGND VGND VPWR VPWR _2285_ sky130_fd_sc_hd__mux2_1
XFILLER_0_14_344 VGND VGND VPWR VPWR sky130_fd_sc_hd__fill_2
X_8313_ clknet_leaf_95_clk _0402_ VGND VGND VPWR VPWR u_input_buffer.fifo_mem\[44\]\[15\]
+ sky130_fd_sc_hd__dfxtp_1
XFILLER_0_74_3 VGND VGND VPWR VPWR sky130_fd_sc_hd__decap_8
X_5456_ _2239_ VGND VGND VPWR VPWR _0594_ sky130_fd_sc_hd__clkbuf_1
X_8244_ clknet_leaf_11_clk _0333_ VGND VGND VPWR VPWR u_input_buffer.fifo_mem\[48\]\[10\]
+ sky130_fd_sc_hd__dfxtp_1
X_4407_ _1463_ net1050 _1640_ VGND VGND VPWR VPWR _1656_ sky130_fd_sc_hd__mux2_1
X_8175_ clknet_leaf_52_clk _0264_ VGND VGND VPWR VPWR u_input_buffer.fifo_mem\[52\]\[5\]
+ sky130_fd_sc_hd__dfxtp_1
Xfanout202 net204 VGND VGND VPWR VPWR net202 sky130_fd_sc_hd__clkbuf_4
X_5387_ net491 _2020_ _2186_ VGND VGND VPWR VPWR _2203_ sky130_fd_sc_hd__mux2_1
X_4338_ u_input_buffer.data_in\[5\] VGND VGND VPWR VPWR _1612_ sky130_fd_sc_hd__clkbuf_4
X_7126_ u_input_buffer.fifo_mem\[50\]\[8\] _2995_ _2997_ u_input_buffer.fifo_mem\[4\]\[8\]
+ VGND VGND VPWR VPWR _3370_ sky130_fd_sc_hd__a22o_1
X_7057_ u_input_buffer.fifo_mem\[7\]\[6\] _3025_ _3027_ u_input_buffer.fifo_mem\[22\]\[6\]
+ _3302_ VGND VGND VPWR VPWR _3303_ sky130_fd_sc_hd__a221o_1
X_4269_ u_analytics_engine.threshold\[8\] VGND VGND VPWR VPWR _1549_ sky130_fd_sc_hd__inv_2
XFILLER_0_5_94 VGND VGND VPWR VPWR sky130_fd_sc_hd__decap_4
X_6008_ _2550_ VGND VGND VPWR VPWR _0835_ sky130_fd_sc_hd__clkbuf_1
XTAP_1204 VGND VPWR sky130_fd_sc_hd__tapvpwrvgnd_1
XTAP_1248 VGND VPWR sky130_fd_sc_hd__tapvpwrvgnd_1
XTAP_1237 VGND VPWR sky130_fd_sc_hd__tapvpwrvgnd_1
XTAP_1226 VGND VPWR sky130_fd_sc_hd__tapvpwrvgnd_1
XTAP_1215 VGND VPWR sky130_fd_sc_hd__tapvpwrvgnd_1
X_7959_ clknet_leaf_110_clk _0049_ VGND VGND VPWR VPWR u_sensor_interface.sensor_array\[0\]\[15\]
+ sky130_fd_sc_hd__dfxtp_1
XTAP_1259 VGND VPWR sky130_fd_sc_hd__tapvpwrvgnd_1
XFILLER_0_37_447 VGND VGND VPWR VPWR sky130_fd_sc_hd__fill_1
XFILLER_0_24_108 VGND VGND VPWR VPWR sky130_fd_sc_hd__fill_1
XFILLER_0_25_609 VGND VGND VPWR VPWR sky130_fd_sc_hd__decap_4
XFILLER_0_107_357 VGND VGND VPWR VPWR sky130_fd_sc_hd__decap_4
XFILLER_0_64_288 VGND VGND VPWR VPWR sky130_fd_sc_hd__decap_8
XFILLER_0_99_130 VGND VGND VPWR VPWR sky130_fd_sc_hd__decap_3
XFILLER_0_99_141 VGND VGND VPWR VPWR sky130_fd_sc_hd__decap_8
XFILLER_0_62_27 VGND VGND VPWR VPWR sky130_fd_sc_hd__fill_1
XFILLER_0_95_391 VGND VGND VPWR VPWR sky130_fd_sc_hd__fill_1
XFILLER_0_55_222 VGND VGND VPWR VPWR sky130_fd_sc_hd__fill_2
XFILLER_0_3_503 VGND VGND VPWR VPWR sky130_fd_sc_hd__fill_1
XFILLER_0_102_77 VGND VGND VPWR VPWR sky130_fd_sc_hd__decap_6
XFILLER_0_11_75 VGND VGND VPWR VPWR sky130_fd_sc_hd__decap_6
XFILLER_0_11_53 VGND VGND VPWR VPWR sky130_fd_sc_hd__decap_3
XFILLER_0_87_13 VPWR VGND VPWR VGND sky130_ef_sc_hd__decap_12
X_6290_ net866 _2504_ _2698_ VGND VGND VPWR VPWR _2702_ sky130_fd_sc_hd__mux2_1
X_5310_ _2162_ VGND VGND VPWR VPWR _0525_ sky130_fd_sc_hd__clkbuf_1
XFILLER_0_87_57 VPWR VGND VPWR VGND sky130_ef_sc_hd__decap_12
X_5241_ net442 _2010_ _2114_ VGND VGND VPWR VPWR _2126_ sky130_fd_sc_hd__mux2_1
X_5172_ net903 _2010_ _2077_ VGND VGND VPWR VPWR _2089_ sky130_fd_sc_hd__mux2_1
X_4123_ _1440_ u_sensor_interface.sensor_array\[2\]\[10\] net112 VGND VGND VPWR VPWR
+ _1441_ sky130_fd_sc_hd__mux2_1
Xinput2 cfg_addr[1] VGND VGND VPWR VPWR net2 sky130_fd_sc_hd__buf_1
X_4054_ _1380_ u_sensor_interface.sensor_array\[3\]\[0\] _1381_ VGND VGND VPWR VPWR
+ _1382_ sky130_fd_sc_hd__mux2_1
X_8931_ clknet_leaf_111_clk _1020_ VGND VGND VPWR VPWR u_input_buffer.fifo_mem\[5\]\[9\]
+ sky130_fd_sc_hd__dfxtp_1
X_8862_ clknet_leaf_21_clk _0951_ VGND VGND VPWR VPWR u_input_buffer.fifo_mem\[9\]\[4\]
+ sky130_fd_sc_hd__dfxtp_1
X_7813_ _3904_ VGND VGND VPWR VPWR _3905_ sky130_fd_sc_hd__buf_4
X_8793_ clknet_leaf_96_clk _0882_ VGND VGND VPWR VPWR u_input_buffer.fifo_mem\[14\]\[15\]
+ sky130_fd_sc_hd__dfxtp_1
XFILLER_0_93_317 VGND VGND VPWR VPWR sky130_fd_sc_hd__fill_1
X_7744_ u_register_bank.window_cfg\[23\] _3847_ _3848_ u_register_bank.threshold_cfg\[23\]
+ _3860_ VGND VGND VPWR VPWR _3861_ sky130_fd_sc_hd__a221o_1
X_4956_ net1011 _1730_ _1951_ VGND VGND VPWR VPWR _1966_ sky130_fd_sc_hd__mux2_1
XFILLER_0_52_82 VGND VGND VPWR VPWR sky130_fd_sc_hd__fill_2
X_7675_ _3806_ net144 _3782_ VGND VGND VPWR VPWR _3807_ sky130_fd_sc_hd__mux2_1
XFILLER_0_74_575 VGND VGND VPWR VPWR sky130_fd_sc_hd__decap_4
X_4887_ _1927_ VGND VGND VPWR VPWR _0337_ sky130_fd_sc_hd__clkbuf_1
XFILLER_0_34_417 VGND VGND VPWR VPWR sky130_fd_sc_hd__decap_3
X_6626_ u_input_buffer.rd_ptr\[5\] VGND VGND VPWR VPWR _2885_ sky130_fd_sc_hd__buf_2
X_6557_ net683 _1376_ _2843_ VGND VGND VPWR VPWR _2844_ sky130_fd_sc_hd__mux2_1
X_5508_ _2275_ VGND VGND VPWR VPWR _0610_ sky130_fd_sc_hd__clkbuf_1
X_6488_ _2806_ VGND VGND VPWR VPWR _2807_ sky130_fd_sc_hd__buf_4
XFILLER_0_30_645 VGND VGND VPWR VPWR sky130_fd_sc_hd__fill_1
X_5439_ net576 _2004_ _2223_ VGND VGND VPWR VPWR _2231_ sky130_fd_sc_hd__mux2_1
X_8227_ clknet_leaf_19_clk _0316_ VGND VGND VPWR VPWR u_input_buffer.fifo_mem\[49\]\[9\]
+ sky130_fd_sc_hd__dfxtp_1
X_8158_ clknet_leaf_4_clk _0247_ VGND VGND VPWR VPWR u_input_buffer.fifo_mem\[53\]\[4\]
+ sky130_fd_sc_hd__dfxtp_1
X_7109_ _3335_ _3344_ _3353_ VGND VGND VPWR VPWR _3354_ sky130_fd_sc_hd__or3_1
X_8089_ clknet_leaf_86_clk _0178_ VGND VGND VPWR VPWR u_input_buffer.fifo_mem\[58\]\[15\]
+ sky130_fd_sc_hd__dfxtp_1
XTAP_1012 VGND VPWR sky130_fd_sc_hd__tapvpwrvgnd_1
XTAP_1001 VGND VPWR sky130_fd_sc_hd__tapvpwrvgnd_1
XTAP_1045 VGND VPWR sky130_fd_sc_hd__tapvpwrvgnd_1
XTAP_1056 VGND VPWR sky130_fd_sc_hd__tapvpwrvgnd_1
XTAP_1034 VGND VPWR sky130_fd_sc_hd__tapvpwrvgnd_1
XTAP_1023 VGND VPWR sky130_fd_sc_hd__tapvpwrvgnd_1
XTAP_1089 VGND VPWR sky130_fd_sc_hd__tapvpwrvgnd_1
XTAP_1078 VGND VPWR sky130_fd_sc_hd__tapvpwrvgnd_1
XTAP_1067 VGND VPWR sky130_fd_sc_hd__tapvpwrvgnd_1
XFILLER_0_107_154 VGND VGND VPWR VPWR sky130_fd_sc_hd__fill_2
XFILLER_0_107_132 VGND VGND VPWR VPWR sky130_fd_sc_hd__fill_1
XFILLER_0_0_517 VGND VGND VPWR VPWR sky130_fd_sc_hd__fill_2
XFILLER_0_0_539 VPWR VGND VPWR VGND sky130_ef_sc_hd__decap_12
XTAP_807 VGND VPWR sky130_fd_sc_hd__tapvpwrvgnd_1
XFILLER_0_57_27 VGND VGND VPWR VPWR sky130_fd_sc_hd__fill_1
XTAP_818 VGND VPWR sky130_fd_sc_hd__tapvpwrvgnd_1
XTAP_829 VGND VPWR sky130_fd_sc_hd__tapvpwrvgnd_1
XFILLER_0_88_645 VGND VGND VPWR VPWR sky130_fd_sc_hd__decap_6
XFILLER_0_87_166 VGND VGND VPWR VPWR sky130_fd_sc_hd__fill_2
X_4810_ net473 _1726_ _1873_ VGND VGND VPWR VPWR _1886_ sky130_fd_sc_hd__mux2_1
X_5790_ _2427_ VGND VGND VPWR VPWR _0740_ sky130_fd_sc_hd__clkbuf_1
XTAP_1590 VGND VPWR sky130_fd_sc_hd__tapvpwrvgnd_1
XFILLER_0_113_65 VGND VGND VPWR VPWR sky130_fd_sc_hd__fill_2
XFILLER_0_56_575 VGND VGND VPWR VPWR sky130_fd_sc_hd__fill_1
X_4741_ _1848_ VGND VGND VPWR VPWR _0270_ sky130_fd_sc_hd__clkbuf_1
XFILLER_0_113_76 VPWR VGND VPWR VGND sky130_ef_sc_hd__decap_12
X_7460_ _3679_ VGND VGND VPWR VPWR _1158_ sky130_fd_sc_hd__clkbuf_1
X_4672_ net863 _1728_ _1797_ VGND VGND VPWR VPWR _1811_ sky130_fd_sc_hd__mux2_1
XFILLER_0_22_85 VGND VGND VPWR VPWR sky130_fd_sc_hd__fill_2
XFILLER_0_43_225 VGND VGND VPWR VPWR sky130_fd_sc_hd__fill_1
XFILLER_0_114_625 VPWR VGND VPWR VGND sky130_ef_sc_hd__decap_12
XFILLER_0_113_113 VPWR VGND VPWR VGND sky130_ef_sc_hd__decap_12
X_6411_ _1626_ net1125 _2752_ VGND VGND VPWR VPWR _2766_ sky130_fd_sc_hd__mux2_1
XFILLER_0_114_669 VGND VGND VPWR VPWR sky130_fd_sc_hd__decap_8
X_7391_ u_input_buffer.fifo_mem\[29\]\[15\] _2938_ _2940_ u_input_buffer.fifo_mem\[13\]\[15\]
+ _3627_ VGND VGND VPWR VPWR _3628_ sky130_fd_sc_hd__a221o_1
XFILLER_0_24_472 VGND VGND VPWR VPWR sky130_fd_sc_hd__fill_1
X_9130_ net172 _1218_ net203 VGND VGND VPWR VPWR u_analytics_engine.threshold\[12\]
+ sky130_fd_sc_hd__dfrtp_1
XFILLER_0_12_645 VPWR VGND VPWR VGND sky130_ef_sc_hd__decap_12
XFILLER_0_11_111 VGND VGND VPWR VPWR sky130_fd_sc_hd__fill_1
X_6342_ _2729_ VGND VGND VPWR VPWR _0990_ sky130_fd_sc_hd__clkbuf_1
X_9061_ clknet_leaf_31_clk _1150_ VGND VGND VPWR VPWR u_sensor_interface.sensor_array\[3\]\[8\]
+ sky130_fd_sc_hd__dfxtp_1
XFILLER_0_11_166 VGND VGND VPWR VPWR sky130_fd_sc_hd__fill_2
X_6273_ _2692_ VGND VGND VPWR VPWR _0958_ sky130_fd_sc_hd__clkbuf_1
X_8012_ clknet_leaf_44_clk _0101_ VGND VGND VPWR VPWR u_input_buffer.fifo_mem\[62\]\[2\]
+ sky130_fd_sc_hd__dfxtp_1
X_5224_ _2117_ VGND VGND VPWR VPWR _0484_ sky130_fd_sc_hd__clkbuf_1
X_5155_ _2080_ VGND VGND VPWR VPWR _0452_ sky130_fd_sc_hd__clkbuf_1
XFILLER_0_37_3 VGND VGND VPWR VPWR sky130_fd_sc_hd__decap_3
X_5086_ net926 _1992_ _2042_ VGND VGND VPWR VPWR _2044_ sky130_fd_sc_hd__mux2_1
X_4106_ u_input_buffer.data_in\[8\] VGND VGND VPWR VPWR _1426_ sky130_fd_sc_hd__clkbuf_4
X_4037_ _1370_ VGND VGND VPWR VPWR _0044_ sky130_fd_sc_hd__clkbuf_1
X_8914_ clknet_leaf_77_clk _1003_ VGND VGND VPWR VPWR u_input_buffer.fifo_mem\[6\]\[8\]
+ sky130_fd_sc_hd__dfxtp_1
X_8845_ clknet_leaf_40_clk _0934_ VGND VGND VPWR VPWR u_input_buffer.fifo_mem\[10\]\[3\]
+ sky130_fd_sc_hd__dfxtp_1
XFILLER_0_78_155 VGND VGND VPWR VPWR sky130_fd_sc_hd__fill_1
XFILLER_0_66_306 VGND VGND VPWR VPWR sky130_fd_sc_hd__fill_2
XPHY_106 VGND VGND VPWR VPWR sky130_fd_sc_hd__decap_3
XPHY_139 VGND VGND VPWR VPWR sky130_fd_sc_hd__decap_3
XPHY_128 VGND VGND VPWR VPWR sky130_fd_sc_hd__decap_3
XFILLER_0_59_391 VGND VGND VPWR VPWR sky130_fd_sc_hd__fill_1
XPHY_117 VGND VGND VPWR VPWR sky130_fd_sc_hd__decap_3
X_5988_ _2539_ VGND VGND VPWR VPWR _0826_ sky130_fd_sc_hd__clkbuf_1
X_8776_ clknet_leaf_95_clk _0865_ VGND VGND VPWR VPWR u_input_buffer.fifo_mem\[15\]\[14\]
+ sky130_fd_sc_hd__dfxtp_1
XFILLER_0_93_169 VGND VGND VPWR VPWR sky130_fd_sc_hd__fill_2
X_4939_ _1957_ VGND VGND VPWR VPWR _0359_ sky130_fd_sc_hd__clkbuf_1
X_7727_ _3698_ VGND VGND VPWR VPWR _3847_ sky130_fd_sc_hd__clkbuf_4
X_7658_ u_register_bank.window_cfg\[4\] _3772_ _3773_ u_analytics_engine.threshold\[4\]
+ _3793_ VGND VGND VPWR VPWR _3794_ sky130_fd_sc_hd__a221o_1
XANTENNA_40 net134 VGND VGND VPWR VPWR sky130_fd_sc_hd__diode_2
XFILLER_0_62_512 VGND VGND VPWR VPWR sky130_fd_sc_hd__fill_1
XFILLER_0_19_277 VGND VGND VPWR VPWR sky130_fd_sc_hd__decap_3
XFILLER_0_105_625 VGND VGND VPWR VPWR sky130_fd_sc_hd__fill_2
XANTENNA_51 u_analytics_engine.data_valid VGND VGND VPWR VPWR sky130_fd_sc_hd__diode_2
X_6609_ _2872_ _2861_ VGND VGND VPWR VPWR _1114_ sky130_fd_sc_hd__xor2_1
XFILLER_0_104_124 VGND VGND VPWR VPWR sky130_fd_sc_hd__decap_4
XFILLER_0_62_589 VGND VGND VPWR VPWR sky130_fd_sc_hd__fill_2
X_7589_ net14 u_analytics_engine.threshold\[11\] _3748_ VGND VGND VPWR VPWR _3750_
+ sky130_fd_sc_hd__mux2_1
XFILLER_0_104_157 VGND VGND VPWR VPWR sky130_fd_sc_hd__fill_1
XFILLER_0_15_494 VGND VGND VPWR VPWR sky130_fd_sc_hd__decap_3
XFILLER_0_113_680 VGND VGND VPWR VPWR sky130_fd_sc_hd__fill_2
XPHY_8 VGND VGND VPWR VPWR sky130_fd_sc_hd__decap_3
XFILLER_0_38_553 VGND VGND VPWR VPWR sky130_fd_sc_hd__decap_6
XFILLER_0_108_452 VGND VGND VPWR VPWR sky130_fd_sc_hd__fill_1
XFILLER_0_5_609 VGND VGND VPWR VPWR sky130_fd_sc_hd__decap_6
XFILLER_0_38_597 VGND VGND VPWR VPWR sky130_fd_sc_hd__decap_3
XFILLER_0_7_18 VPWR VGND VPWR VGND sky130_ef_sc_hd__decap_12
XFILLER_0_111_617 VPWR VGND VPWR VGND sky130_ef_sc_hd__decap_12
XTAP_604 VGND VPWR sky130_fd_sc_hd__tapvpwrvgnd_1
XTAP_615 VGND VPWR sky130_fd_sc_hd__tapvpwrvgnd_1
XTAP_626 VGND VPWR sky130_fd_sc_hd__tapvpwrvgnd_1
XTAP_637 VGND VPWR sky130_fd_sc_hd__tapvpwrvgnd_1
XTAP_659 VGND VPWR sky130_fd_sc_hd__tapvpwrvgnd_1
XTAP_648 VGND VPWR sky130_fd_sc_hd__tapvpwrvgnd_1
XFILLER_0_17_30 VPWR VGND VPWR VGND sky130_ef_sc_hd__decap_12
XFILLER_0_108_65 VPWR VGND VPWR VGND sky130_ef_sc_hd__decap_12
X_6960_ u_input_buffer.fifo_mem\[53\]\[4\] _2934_ _2936_ u_input_buffer.fifo_mem\[57\]\[4\]
+ VGND VGND VPWR VPWR _3208_ sky130_fd_sc_hd__a22o_1
XFILLER_0_88_431 VGND VGND VPWR VPWR sky130_fd_sc_hd__decap_3
X_5911_ net584 _2266_ _2478_ VGND VGND VPWR VPWR _2491_ sky130_fd_sc_hd__mux2_1
X_6891_ u_input_buffer.fifo_mem\[12\]\[2\] _2980_ _2982_ u_input_buffer.fifo_mem\[18\]\[2\]
+ _3140_ VGND VGND VPWR VPWR _3141_ sky130_fd_sc_hd__a221o_1
X_5842_ _2454_ VGND VGND VPWR VPWR _0765_ sky130_fd_sc_hd__clkbuf_1
X_8630_ clknet_leaf_75_clk _0719_ VGND VGND VPWR VPWR u_input_buffer.fifo_mem\[24\]\[12\]
+ sky130_fd_sc_hd__dfxtp_1
XFILLER_0_48_339 VGND VGND VPWR VPWR sky130_fd_sc_hd__fill_1
X_8561_ clknet_leaf_55_clk _0650_ VGND VGND VPWR VPWR u_input_buffer.fifo_mem\[28\]\[7\]
+ sky130_fd_sc_hd__dfxtp_1
X_5773_ net977 _2264_ _2406_ VGND VGND VPWR VPWR _2418_ sky130_fd_sc_hd__mux2_1
X_7512_ _3708_ VGND VGND VPWR VPWR _1181_ sky130_fd_sc_hd__clkbuf_1
X_4724_ net459 _1710_ _1836_ VGND VGND VPWR VPWR _1840_ sky130_fd_sc_hd__mux2_1
XFILLER_0_56_383 VGND VGND VPWR VPWR sky130_fd_sc_hd__decap_4
X_8492_ clknet_leaf_26_clk _0581_ VGND VGND VPWR VPWR u_input_buffer.fifo_mem\[32\]\[2\]
+ sky130_fd_sc_hd__dfxtp_1
X_4655_ _1802_ VGND VGND VPWR VPWR _0230_ sky130_fd_sc_hd__clkbuf_1
X_7443_ u_sensor_interface.sensor_array\[3\]\[9\] net98 _3662_ VGND VGND VPWR VPWR
+ _3670_ sky130_fd_sc_hd__mux2_1
Xinput82 sensor_data_in[42] VGND VGND VPWR VPWR net82 sky130_fd_sc_hd__clkbuf_2
X_4586_ _1763_ VGND VGND VPWR VPWR _0200_ sky130_fd_sc_hd__clkbuf_1
Xhold811 u_input_buffer.fifo_mem\[58\]\[9\] VGND VGND VPWR VPWR net1023 sky130_fd_sc_hd__dlygate4sd3_1
Xinput71 sensor_data_in[32] VGND VGND VPWR VPWR net71 sky130_fd_sc_hd__clkbuf_2
Xinput60 sensor_data_in[22] VGND VGND VPWR VPWR net60 sky130_fd_sc_hd__buf_1
X_7374_ u_input_buffer.fifo_mem\[23\]\[14\] _3045_ _3047_ u_input_buffer.fifo_mem\[20\]\[14\]
+ _3611_ VGND VGND VPWR VPWR _3612_ sky130_fd_sc_hd__a221o_1
Xhold800 u_input_buffer.fifo_mem\[1\]\[1\] VGND VGND VPWR VPWR net1012 sky130_fd_sc_hd__dlygate4sd3_1
XFILLER_0_101_116 VGND VGND VPWR VPWR sky130_fd_sc_hd__fill_2
X_6325_ net668 _2504_ _2717_ VGND VGND VPWR VPWR _2721_ sky130_fd_sc_hd__mux2_1
Xinput93 sensor_data_in[52] VGND VGND VPWR VPWR net93 sky130_fd_sc_hd__clkbuf_1
Xhold822 u_input_buffer.fifo_mem\[25\]\[14\] VGND VGND VPWR VPWR net1034 sky130_fd_sc_hd__dlygate4sd3_1
Xhold855 u_input_buffer.fifo_mem\[13\]\[8\] VGND VGND VPWR VPWR net1067 sky130_fd_sc_hd__dlygate4sd3_1
Xhold844 u_input_buffer.fifo_mem\[25\]\[0\] VGND VGND VPWR VPWR net1056 sky130_fd_sc_hd__dlygate4sd3_1
Xhold833 u_input_buffer.fifo_mem\[10\]\[11\] VGND VGND VPWR VPWR net1045 sky130_fd_sc_hd__dlygate4sd3_1
X_9113_ net172 _1201_ net203 VGND VGND VPWR VPWR u_register_bank.window_cfg\[27\]
+ sky130_fd_sc_hd__dfrtp_1
Xhold877 u_input_buffer.fifo_mem\[52\]\[7\] VGND VGND VPWR VPWR net1089 sky130_fd_sc_hd__dlygate4sd3_1
X_9044_ clknet_leaf_49_clk _1133_ VGND VGND VPWR VPWR u_analytics_engine.data_in\[7\]
+ sky130_fd_sc_hd__dfxtp_2
XFILLER_0_12_497 VPWR VGND VPWR VGND sky130_ef_sc_hd__decap_12
XFILLER_0_12_475 VGND VGND VPWR VPWR sky130_fd_sc_hd__fill_1
Xhold866 u_input_buffer.fifo_mem\[29\]\[11\] VGND VGND VPWR VPWR net1078 sky130_fd_sc_hd__dlygate4sd3_1
Xhold888 u_input_buffer.fifo_mem\[53\]\[1\] VGND VGND VPWR VPWR net1100 sky130_fd_sc_hd__dlygate4sd3_1
X_6256_ _1608_ net1258 _2680_ VGND VGND VPWR VPWR _2684_ sky130_fd_sc_hd__mux2_1
Xhold899 u_input_buffer.fifo_mem\[22\]\[10\] VGND VGND VPWR VPWR net1111 sky130_fd_sc_hd__dlygate4sd3_1
X_6187_ _2647_ VGND VGND VPWR VPWR _0917_ sky130_fd_sc_hd__clkbuf_1
X_5207_ net888 _2010_ _2096_ VGND VGND VPWR VPWR _2108_ sky130_fd_sc_hd__mux2_1
X_5138_ _1439_ net1065 _2059_ VGND VGND VPWR VPWR _2071_ sky130_fd_sc_hd__mux2_1
X_5069_ _2034_ VGND VGND VPWR VPWR _0412_ sky130_fd_sc_hd__clkbuf_1
XFILLER_0_74_91 VGND VGND VPWR VPWR sky130_fd_sc_hd__fill_1
X_8828_ clknet_leaf_37_clk _0917_ VGND VGND VPWR VPWR u_input_buffer.fifo_mem\[11\]\[2\]
+ sky130_fd_sc_hd__dfxtp_1
X_8759_ clknet_leaf_9_clk _0848_ VGND VGND VPWR VPWR u_input_buffer.fifo_mem\[16\]\[13\]
+ sky130_fd_sc_hd__dfxtp_1
XFILLER_0_109_249 VGND VGND VPWR VPWR sky130_fd_sc_hd__decap_3
XFILLER_0_35_556 VGND VGND VPWR VPWR sky130_fd_sc_hd__decap_4
XFILLER_0_105_488 VGND VGND VPWR VPWR sky130_fd_sc_hd__fill_1
XFILLER_0_38_29 VGND VGND VPWR VPWR sky130_fd_sc_hd__decap_4
XFILLER_0_85_445 VGND VGND VPWR VPWR sky130_fd_sc_hd__decap_3
XFILLER_0_85_489 VGND VGND VPWR VPWR sky130_fd_sc_hd__fill_1
XFILLER_0_72_117 VGND VGND VPWR VPWR sky130_fd_sc_hd__fill_1
XFILLER_0_81_673 VPWR VGND VPWR VGND sky130_ef_sc_hd__decap_12
Xhold107 u_input_buffer.fifo_mem\[42\]\[2\] VGND VGND VPWR VPWR net319 sky130_fd_sc_hd__dlygate4sd3_1
XFILLER_0_80_183 VGND VGND VPWR VPWR sky130_fd_sc_hd__fill_1
X_4440_ _1674_ VGND VGND VPWR VPWR _0143_ sky130_fd_sc_hd__clkbuf_1
XFILLER_0_53_386 VGND VGND VPWR VPWR sky130_fd_sc_hd__decap_3
XFILLER_0_110_77 VGND VGND VPWR VPWR sky130_fd_sc_hd__decap_6
Xhold118 u_input_buffer.fifo_mem\[54\]\[14\] VGND VGND VPWR VPWR net330 sky130_fd_sc_hd__dlygate4sd3_1
Xhold129 u_input_buffer.fifo_mem\[16\]\[10\] VGND VGND VPWR VPWR net341 sky130_fd_sc_hd__dlygate4sd3_1
XFILLER_0_0_133 VGND VGND VPWR VPWR sky130_fd_sc_hd__fill_1
X_4371_ _1589_ _1590_ VGND VGND VPWR VPWR _1634_ sky130_fd_sc_hd__nor2_4
X_6110_ _2604_ VGND VGND VPWR VPWR _2605_ sky130_fd_sc_hd__clkbuf_4
XFILLER_0_95_57 VPWR VGND VPWR VGND sky130_ef_sc_hd__decap_12
X_7090_ _3319_ _3321_ _3325_ _3334_ VGND VGND VPWR VPWR _3335_ sky130_fd_sc_hd__or4_2
XTAP_401 VGND VPWR sky130_fd_sc_hd__tapvpwrvgnd_1
XTAP_412 VGND VPWR sky130_fd_sc_hd__tapvpwrvgnd_1
XTAP_423 VGND VPWR sky130_fd_sc_hd__tapvpwrvgnd_1
XTAP_434 VGND VPWR sky130_fd_sc_hd__tapvpwrvgnd_1
XTAP_445 VGND VPWR sky130_fd_sc_hd__tapvpwrvgnd_1
XTAP_456 VGND VPWR sky130_fd_sc_hd__tapvpwrvgnd_1
XTAP_467 VGND VPWR sky130_fd_sc_hd__tapvpwrvgnd_1
X_6041_ _1932_ _2567_ VGND VGND VPWR VPWR _2568_ sky130_fd_sc_hd__nor2_2
XTAP_489 VGND VPWR sky130_fd_sc_hd__tapvpwrvgnd_1
XTAP_478 VGND VPWR sky130_fd_sc_hd__tapvpwrvgnd_1
X_7992_ clknet_leaf_82_clk _0081_ net188 VGND VGND VPWR VPWR u_sample_counter.sample_count\[15\]
+ sky130_fd_sc_hd__dfrtp_1
X_6943_ _3185_ _3187_ _3189_ _3191_ VGND VGND VPWR VPWR _3192_ sky130_fd_sc_hd__or4_1
XFILLER_0_49_615 VGND VGND VPWR VPWR sky130_fd_sc_hd__fill_1
X_6874_ _3118_ _3120_ _3122_ _3124_ VGND VGND VPWR VPWR _3125_ sky130_fd_sc_hd__or4_1
XFILLER_0_49_626 VGND VGND VPWR VPWR sky130_fd_sc_hd__decap_4
X_8613_ clknet_leaf_108_clk _0702_ VGND VGND VPWR VPWR u_input_buffer.fifo_mem\[25\]\[11\]
+ sky130_fd_sc_hd__dfxtp_1
XFILLER_0_36_309 VGND VGND VPWR VPWR sky130_fd_sc_hd__fill_2
X_5825_ _1606_ net1156 _2443_ VGND VGND VPWR VPWR _2446_ sky130_fd_sc_hd__mux2_1
XFILLER_0_29_372 VGND VGND VPWR VPWR sky130_fd_sc_hd__fill_2
X_5756_ _2409_ VGND VGND VPWR VPWR _0724_ sky130_fd_sc_hd__clkbuf_1
XFILLER_0_60_82 VGND VGND VPWR VPWR sky130_fd_sc_hd__fill_2
X_8544_ clknet_leaf_8_clk _0633_ VGND VGND VPWR VPWR u_input_buffer.fifo_mem\[29\]\[6\]
+ sky130_fd_sc_hd__dfxtp_1
XFILLER_0_71_150 VGND VGND VPWR VPWR sky130_fd_sc_hd__fill_1
X_4707_ _1451_ net1008 _1816_ VGND VGND VPWR VPWR _1830_ sky130_fd_sc_hd__mux2_1
X_5687_ _2372_ VGND VGND VPWR VPWR _0692_ sky130_fd_sc_hd__clkbuf_1
X_8475_ clknet_leaf_5_clk _0564_ VGND VGND VPWR VPWR u_input_buffer.fifo_mem\[33\]\[1\]
+ sky130_fd_sc_hd__dfxtp_1
X_7426_ u_sensor_interface.sensor_array\[3\]\[1\] net89 _1367_ VGND VGND VPWR VPWR
+ _3661_ sky130_fd_sc_hd__mux2_1
XFILLER_0_71_172 VGND VGND VPWR VPWR sky130_fd_sc_hd__fill_2
X_4638_ net826 _1730_ _1777_ VGND VGND VPWR VPWR _1792_ sky130_fd_sc_hd__mux2_1
Xhold630 u_input_buffer.fifo_mem\[28\]\[3\] VGND VGND VPWR VPWR net842 sky130_fd_sc_hd__dlygate4sd3_1
Xhold663 u_input_buffer.fifo_mem\[40\]\[4\] VGND VGND VPWR VPWR net875 sky130_fd_sc_hd__dlygate4sd3_1
Xhold641 u_input_buffer.fifo_mem\[18\]\[4\] VGND VGND VPWR VPWR net853 sky130_fd_sc_hd__dlygate4sd3_1
Xhold652 u_input_buffer.fifo_mem\[19\]\[3\] VGND VGND VPWR VPWR net864 sky130_fd_sc_hd__dlygate4sd3_1
X_4569_ _1753_ VGND VGND VPWR VPWR _0193_ sky130_fd_sc_hd__clkbuf_1
X_7357_ u_input_buffer.fifo_mem\[34\]\[14\] _2965_ _2968_ u_input_buffer.fifo_mem\[48\]\[14\]
+ _3594_ VGND VGND VPWR VPWR _3595_ sky130_fd_sc_hd__a221o_1
Xhold685 u_input_buffer.fifo_mem\[6\]\[7\] VGND VGND VPWR VPWR net897 sky130_fd_sc_hd__dlygate4sd3_1
Xhold674 u_input_buffer.fifo_mem\[34\]\[0\] VGND VGND VPWR VPWR net886 sky130_fd_sc_hd__dlygate4sd3_1
Xhold696 u_input_buffer.fifo_mem\[33\]\[12\] VGND VGND VPWR VPWR net908 sky130_fd_sc_hd__dlygate4sd3_1
X_6308_ net892 _2522_ _2697_ VGND VGND VPWR VPWR _2711_ sky130_fd_sc_hd__mux2_1
X_7288_ u_input_buffer.fifo_mem\[31\]\[12\] _3016_ _3019_ u_input_buffer.fifo_mem\[38\]\[12\]
+ VGND VGND VPWR VPWR _3528_ sky130_fd_sc_hd__a22o_1
X_9027_ clknet_leaf_94_clk _1116_ net192 VGND VGND VPWR VPWR u_input_buffer.rd_ptr\[2\]
+ sky130_fd_sc_hd__dfrtp_4
X_6239_ _2674_ VGND VGND VPWR VPWR _0942_ sky130_fd_sc_hd__clkbuf_1
XTAP_990 VGND VPWR sky130_fd_sc_hd__tapvpwrvgnd_1
XFILLER_0_67_434 VGND VGND VPWR VPWR sky130_fd_sc_hd__fill_1
XFILLER_0_82_437 VGND VGND VPWR VPWR sky130_fd_sc_hd__decap_4
XFILLER_0_55_629 VGND VGND VPWR VPWR sky130_fd_sc_hd__decap_3
XFILLER_0_54_128 VGND VGND VPWR VPWR sky130_fd_sc_hd__decap_3
XFILLER_0_62_161 VGND VGND VPWR VPWR sky130_fd_sc_hd__fill_1
X_3940_ net111 VGND VGND VPWR VPWR _1318_ sky130_fd_sc_hd__buf_8
XFILLER_0_105_55 VGND VGND VPWR VPWR sky130_fd_sc_hd__fill_1
XFILLER_0_14_53 VPWR VGND VPWR VGND sky130_ef_sc_hd__decap_12
X_6590_ _2860_ VGND VGND VPWR VPWR _2861_ sky130_fd_sc_hd__clkbuf_4
X_5610_ _2330_ VGND VGND VPWR VPWR _0657_ sky130_fd_sc_hd__clkbuf_1
XFILLER_0_5_225 VGND VGND VPWR VPWR sky130_fd_sc_hd__decap_6
X_5541_ net1079 _2274_ _2276_ VGND VGND VPWR VPWR _2293_ sky130_fd_sc_hd__mux2_1
XFILLER_0_14_548 VPWR VGND VPWR VGND sky130_ef_sc_hd__decap_12
X_8260_ clknet_leaf_76_clk _0349_ VGND VGND VPWR VPWR u_input_buffer.fifo_mem\[47\]\[10\]
+ sky130_fd_sc_hd__dfxtp_1
XFILLER_0_53_172 VGND VGND VPWR VPWR sky130_fd_sc_hd__fill_1
X_5472_ _2251_ VGND VGND VPWR VPWR _0598_ sky130_fd_sc_hd__clkbuf_1
X_7211_ u_input_buffer.fifo_mem\[27\]\[10\] _3012_ _3014_ u_input_buffer.fifo_mem\[59\]\[10\]
+ _3452_ VGND VGND VPWR VPWR _3453_ sky130_fd_sc_hd__a221o_1
XFILLER_0_111_233 VGND VGND VPWR VPWR sky130_fd_sc_hd__fill_2
X_8191_ clknet_leaf_30_clk _0280_ VGND VGND VPWR VPWR u_input_buffer.fifo_mem\[51\]\[5\]
+ sky130_fd_sc_hd__dfxtp_1
X_4423_ net628 _1610_ _1661_ VGND VGND VPWR VPWR _1666_ sky130_fd_sc_hd__mux2_1
X_7142_ u_input_buffer.fifo_mem\[10\]\[8\] _3056_ _3058_ u_input_buffer.fifo_mem\[44\]\[8\]
+ _3385_ VGND VGND VPWR VPWR _3386_ sky130_fd_sc_hd__a221o_1
X_4354_ net1267 _1622_ _1601_ VGND VGND VPWR VPWR _1623_ sky130_fd_sc_hd__mux2_1
XTAP_242 VGND VPWR sky130_fd_sc_hd__tapvpwrvgnd_1
XFILLER_0_1_497 VGND VGND VPWR VPWR sky130_fd_sc_hd__decap_6
X_7073_ u_input_buffer.fifo_mem\[21\]\[7\] _2909_ _2913_ u_input_buffer.fifo_mem\[25\]\[7\]
+ VGND VGND VPWR VPWR _3318_ sky130_fd_sc_hd__a22o_1
X_4285_ u_analytics_engine.threshold\[5\] _1563_ _1564_ u_analytics_engine.threshold\[4\]
+ VGND VGND VPWR VPWR _1565_ sky130_fd_sc_hd__o22a_1
X_6024_ _2558_ VGND VGND VPWR VPWR _0843_ sky130_fd_sc_hd__clkbuf_1
XTAP_264 VGND VPWR sky130_fd_sc_hd__tapvpwrvgnd_1
XTAP_253 VGND VPWR sky130_fd_sc_hd__tapvpwrvgnd_1
XTAP_275 VGND VPWR sky130_fd_sc_hd__tapvpwrvgnd_1
XTAP_297 VGND VPWR sky130_fd_sc_hd__tapvpwrvgnd_1
XTAP_286 VGND VPWR sky130_fd_sc_hd__tapvpwrvgnd_1
X_7975_ clknet_leaf_102_clk _0065_ net184 VGND VGND VPWR VPWR u_input_buffer.data_in\[15\]
+ sky130_fd_sc_hd__dfrtp_1
XTAP_1419 VGND VPWR sky130_fd_sc_hd__tapvpwrvgnd_1
X_6926_ u_input_buffer.fifo_mem\[36\]\[3\] _2951_ _2955_ u_input_buffer.fifo_mem\[35\]\[3\]
+ _3174_ VGND VGND VPWR VPWR _3175_ sky130_fd_sc_hd__a221o_1
XTAP_1408 VGND VPWR sky130_fd_sc_hd__tapvpwrvgnd_1
XFILLER_0_49_456 VGND VGND VPWR VPWR sky130_fd_sc_hd__fill_2
X_6857_ u_input_buffer.fifo_mem\[47\]\[1\] _2880_ _3007_ _3009_ u_input_buffer.fifo_mem\[24\]\[1\]
+ VGND VGND VPWR VPWR _3108_ sky130_fd_sc_hd__a32o_1
XFILLER_0_9_553 VGND VGND VPWR VPWR sky130_fd_sc_hd__decap_6
XFILLER_0_49_478 VGND VGND VPWR VPWR sky130_fd_sc_hd__fill_1
X_5808_ _2436_ VGND VGND VPWR VPWR _0749_ sky130_fd_sc_hd__clkbuf_1
X_6788_ _2900_ _3002_ VGND VGND VPWR VPWR _3040_ sky130_fd_sc_hd__nor2_2
X_8527_ clknet_leaf_55_clk _0616_ VGND VGND VPWR VPWR u_input_buffer.fifo_mem\[30\]\[5\]
+ sky130_fd_sc_hd__dfxtp_1
XFILLER_0_9_597 VPWR VGND VPWR VGND sky130_ef_sc_hd__decap_12
XFILLER_0_44_150 VGND VGND VPWR VPWR sky130_fd_sc_hd__decap_3
XFILLER_0_45_662 VGND VGND VPWR VPWR sky130_fd_sc_hd__fill_2
XFILLER_0_45_673 VGND VGND VPWR VPWR sky130_fd_sc_hd__fill_2
X_5739_ _2399_ VGND VGND VPWR VPWR _0717_ sky130_fd_sc_hd__clkbuf_1
XFILLER_0_115_561 VGND VGND VPWR VPWR sky130_fd_sc_hd__fill_2
X_8458_ clknet_leaf_25_clk _0547_ VGND VGND VPWR VPWR u_input_buffer.fifo_mem\[34\]\[0\]
+ sky130_fd_sc_hd__dfxtp_1
X_8389_ clknet_leaf_93_clk _0478_ VGND VGND VPWR VPWR u_input_buffer.fifo_mem\[39\]\[11\]
+ sky130_fd_sc_hd__dfxtp_1
X_7409_ u_input_buffer.fifo_mem\[52\]\[15\] _3038_ _3040_ u_input_buffer.fifo_mem\[56\]\[15\]
+ VGND VGND VPWR VPWR _3646_ sky130_fd_sc_hd__a22o_1
Xhold460 u_input_buffer.fifo_mem\[28\]\[4\] VGND VGND VPWR VPWR net672 sky130_fd_sc_hd__dlygate4sd3_1
Xhold471 u_input_buffer.fifo_mem\[0\]\[0\] VGND VGND VPWR VPWR net683 sky130_fd_sc_hd__dlygate4sd3_1
Xhold482 u_input_buffer.fifo_mem\[15\]\[4\] VGND VGND VPWR VPWR net694 sky130_fd_sc_hd__dlygate4sd3_1
Xhold493 u_input_buffer.fifo_mem\[51\]\[15\] VGND VGND VPWR VPWR net705 sky130_fd_sc_hd__dlygate4sd3_1
XFILLER_0_95_573 VGND VGND VPWR VPWR sky130_fd_sc_hd__fill_2
XFILLER_0_55_426 VGND VGND VPWR VPWR sky130_fd_sc_hd__fill_2
XFILLER_0_55_437 VGND VGND VPWR VPWR sky130_fd_sc_hd__fill_2
XFILLER_0_36_640 VGND VGND VPWR VPWR sky130_fd_sc_hd__decap_4
XFILLER_0_36_662 VGND VGND VPWR VPWR sky130_fd_sc_hd__fill_1
XFILLER_0_23_301 VGND VGND VPWR VPWR sky130_fd_sc_hd__fill_2
XFILLER_0_51_654 VGND VGND VPWR VPWR sky130_fd_sc_hd__decap_4
XFILLER_0_11_529 VPWR VGND VPWR VGND sky130_ef_sc_hd__decap_12
X_4070_ _1395_ VGND VGND VPWR VPWR _0052_ sky130_fd_sc_hd__clkbuf_1
X_4972_ _1975_ VGND VGND VPWR VPWR _0374_ sky130_fd_sc_hd__clkbuf_1
X_7760_ u_register_bank.window_cfg\[27\] _3847_ _3848_ u_register_bank.threshold_cfg\[27\]
+ _3872_ VGND VGND VPWR VPWR _3873_ sky130_fd_sc_hd__a221o_1
X_6711_ u_input_buffer.fifo_mem\[36\]\[0\] _2951_ _2955_ u_input_buffer.fifo_mem\[35\]\[0\]
+ _2962_ VGND VGND VPWR VPWR _2963_ sky130_fd_sc_hd__a221o_1
XFILLER_0_86_573 VGND VGND VPWR VPWR sky130_fd_sc_hd__decap_4
X_7691_ u_register_bank.window_cfg\[11\] _3812_ _3813_ u_analytics_engine.threshold\[11\]
+ _3819_ VGND VGND VPWR VPWR _3820_ sky130_fd_sc_hd__a221o_1
X_6642_ u_input_buffer.rd_ptr\[1\] u_input_buffer.rd_ptr\[3\] u_input_buffer.rd_ptr\[2\]
+ u_input_buffer.rd_ptr\[0\] VGND VGND VPWR VPWR _2894_ sky130_fd_sc_hd__or4b_4
XFILLER_0_6_545 VPWR VGND VPWR VGND sky130_ef_sc_hd__decap_12
XFILLER_0_6_512 VPWR VGND VPWR VGND sky130_ef_sc_hd__decap_12
XFILLER_0_27_673 VGND VGND VPWR VPWR sky130_fd_sc_hd__fill_1
X_6573_ net250 _1426_ _2843_ VGND VGND VPWR VPWR _2852_ sky130_fd_sc_hd__mux2_1
X_8312_ clknet_leaf_95_clk _0401_ VGND VGND VPWR VPWR u_input_buffer.fifo_mem\[44\]\[14\]
+ sky130_fd_sc_hd__dfxtp_1
X_5524_ _2284_ VGND VGND VPWR VPWR _0617_ sky130_fd_sc_hd__clkbuf_1
XFILLER_0_6_589 VPWR VGND VPWR VGND sky130_ef_sc_hd__decap_12
X_8243_ clknet_leaf_15_clk _0332_ VGND VGND VPWR VPWR u_input_buffer.fifo_mem\[48\]\[9\]
+ sky130_fd_sc_hd__dfxtp_1
X_5455_ net1118 _2020_ _2222_ VGND VGND VPWR VPWR _2239_ sky130_fd_sc_hd__mux2_1
X_8174_ clknet_leaf_55_clk _0263_ VGND VGND VPWR VPWR u_input_buffer.fifo_mem\[52\]\[4\]
+ sky130_fd_sc_hd__dfxtp_1
XFILLER_0_67_3 VGND VGND VPWR VPWR sky130_fd_sc_hd__decap_6
X_4406_ _1655_ VGND VGND VPWR VPWR _0128_ sky130_fd_sc_hd__clkbuf_1
XFILLER_0_112_597 VGND VGND VPWR VPWR sky130_fd_sc_hd__fill_1
X_7125_ u_input_buffer.fifo_mem\[12\]\[8\] _2980_ _2982_ u_input_buffer.fifo_mem\[18\]\[8\]
+ _3368_ VGND VGND VPWR VPWR _3369_ sky130_fd_sc_hd__a221o_1
X_5386_ _2202_ VGND VGND VPWR VPWR _0561_ sky130_fd_sc_hd__clkbuf_1
Xfanout203 net204 VGND VGND VPWR VPWR net203 sky130_fd_sc_hd__clkbuf_4
X_4337_ _1611_ VGND VGND VPWR VPWR _0103_ sky130_fd_sc_hd__clkbuf_1
X_7056_ u_input_buffer.fifo_mem\[30\]\[6\] _3029_ _3031_ u_input_buffer.fifo_mem\[58\]\[6\]
+ VGND VGND VPWR VPWR _3302_ sky130_fd_sc_hd__a22o_1
XFILLER_0_66_70 VGND VGND VPWR VPWR sky130_fd_sc_hd__decap_3
X_4268_ u_analytics_engine.threshold\[9\] _1546_ _1544_ _1547_ VGND VGND VPWR VPWR
+ _1548_ sky130_fd_sc_hd__a211oi_2
X_6007_ net603 _2496_ _2549_ VGND VGND VPWR VPWR _2550_ sky130_fd_sc_hd__mux2_1
X_4199_ u_sample_counter.sample_count\[12\] _1494_ u_sample_counter.sample_count\[13\]
+ VGND VGND VPWR VPWR _1498_ sky130_fd_sc_hd__a21o_1
XFILLER_0_96_326 VGND VGND VPWR VPWR sky130_fd_sc_hd__fill_1
XTAP_1205 VGND VPWR sky130_fd_sc_hd__tapvpwrvgnd_1
X_7958_ clknet_leaf_27_clk _0048_ VGND VGND VPWR VPWR u_sensor_interface.sensor_array\[0\]\[14\]
+ sky130_fd_sc_hd__dfxtp_2
XTAP_1238 VGND VPWR sky130_fd_sc_hd__tapvpwrvgnd_1
XTAP_1227 VGND VPWR sky130_fd_sc_hd__tapvpwrvgnd_1
XTAP_1216 VGND VPWR sky130_fd_sc_hd__tapvpwrvgnd_1
X_6909_ u_input_buffer.fifo_mem\[3\]\[2\] _3070_ _3072_ u_input_buffer.fifo_mem\[60\]\[2\]
+ VGND VGND VPWR VPWR _3159_ sky130_fd_sc_hd__a22o_1
XTAP_1249 VGND VPWR sky130_fd_sc_hd__tapvpwrvgnd_1
X_7889_ clknet_leaf_79_clk net234 net191 VGND VGND VPWR VPWR u_register_bank.status_flags\[9\]
+ sky130_fd_sc_hd__dfrtp_1
XFILLER_0_92_521 VGND VGND VPWR VPWR sky130_fd_sc_hd__fill_2
XFILLER_0_17_150 VGND VGND VPWR VPWR sky130_fd_sc_hd__decap_3
Xhold290 u_input_buffer.fifo_mem\[51\]\[7\] VGND VGND VPWR VPWR net502 sky130_fd_sc_hd__dlygate4sd3_1
XFILLER_0_46_29 VGND VGND VPWR VPWR sky130_fd_sc_hd__fill_1
XFILLER_0_28_437 VGND VGND VPWR VPWR sky130_fd_sc_hd__fill_2
XFILLER_0_28_448 VGND VGND VPWR VPWR sky130_fd_sc_hd__fill_1
XFILLER_0_55_245 VGND VGND VPWR VPWR sky130_fd_sc_hd__fill_2
XFILLER_0_55_289 VGND VGND VPWR VPWR sky130_fd_sc_hd__decap_6
XFILLER_0_55_278 VGND VGND VPWR VPWR sky130_fd_sc_hd__fill_2
XFILLER_0_11_21 VPWR VGND VPWR VGND sky130_ef_sc_hd__decap_12
XFILLER_0_113_306 VGND VGND VPWR VPWR sky130_fd_sc_hd__fill_2
XFILLER_0_106_391 VGND VGND VPWR VPWR sky130_fd_sc_hd__decap_4
XFILLER_0_87_25 VPWR VGND VPWR VGND sky130_ef_sc_hd__decap_12
XFILLER_0_3_559 VGND VGND VPWR VPWR sky130_fd_sc_hd__fill_1
X_5240_ _2125_ VGND VGND VPWR VPWR _0492_ sky130_fd_sc_hd__clkbuf_1
XFILLER_0_11_348 VPWR VGND VPWR VGND sky130_ef_sc_hd__decap_12
XFILLER_0_87_69 VGND VGND VPWR VPWR sky130_fd_sc_hd__decap_4
X_5171_ _2088_ VGND VGND VPWR VPWR _0460_ sky130_fd_sc_hd__clkbuf_1
X_4122_ u_sensor_interface.sensor_array\[0\]\[10\] u_sensor_interface.sensor_array\[1\]\[10\]
+ net111 VGND VGND VPWR VPWR _1440_ sky130_fd_sc_hd__mux2_1
X_4053_ net113 VGND VGND VPWR VPWR _1381_ sky130_fd_sc_hd__clkbuf_8
X_8930_ clknet_leaf_0_clk _1019_ VGND VGND VPWR VPWR u_input_buffer.fifo_mem\[5\]\[8\]
+ sky130_fd_sc_hd__dfxtp_1
Xinput3 cfg_addr[2] VGND VGND VPWR VPWR net3 sky130_fd_sc_hd__clkbuf_4
X_8861_ clknet_leaf_21_clk _0950_ VGND VGND VPWR VPWR u_input_buffer.fifo_mem\[9\]\[3\]
+ sky130_fd_sc_hd__dfxtp_1
X_7812_ net44 _3778_ VGND VGND VPWR VPWR _3904_ sky130_fd_sc_hd__nand2_2
X_8792_ clknet_leaf_13_clk _0881_ VGND VGND VPWR VPWR u_input_buffer.fifo_mem\[14\]\[14\]
+ sky130_fd_sc_hd__dfxtp_1
X_7743_ u_register_bank.status_flags\[23\] _3849_ _3843_ u_register_bank.sensor_enable\[23\]
+ VGND VGND VPWR VPWR _3860_ sky130_fd_sc_hd__a22o_1
XFILLER_0_59_573 VGND VGND VPWR VPWR sky130_fd_sc_hd__decap_4
X_4955_ _1965_ VGND VGND VPWR VPWR _0367_ sky130_fd_sc_hd__clkbuf_1
X_7674_ u_register_bank.window_cfg\[8\] _3772_ _3773_ u_analytics_engine.threshold\[8\]
+ _3805_ VGND VGND VPWR VPWR _3806_ sky130_fd_sc_hd__a221o_1
X_4886_ net828 _1732_ _1911_ VGND VGND VPWR VPWR _1927_ sky130_fd_sc_hd__mux2_1
XFILLER_0_74_587 VGND VGND VPWR VPWR sky130_fd_sc_hd__fill_1
X_6625_ _2883_ _2884_ VGND VGND VPWR VPWR _1118_ sky130_fd_sc_hd__nor2_1
XFILLER_0_27_492 VGND VGND VPWR VPWR sky130_fd_sc_hd__fill_2
X_6556_ _2842_ VGND VGND VPWR VPWR _2843_ sky130_fd_sc_hd__buf_4
X_5507_ net726 _2274_ _2243_ VGND VGND VPWR VPWR _2275_ sky130_fd_sc_hd__mux2_1
X_8226_ clknet_leaf_18_clk _0315_ VGND VGND VPWR VPWR u_input_buffer.fifo_mem\[49\]\[8\]
+ sky130_fd_sc_hd__dfxtp_1
XFILLER_0_30_624 VGND VGND VPWR VPWR sky130_fd_sc_hd__decap_6
X_6487_ _1872_ _2567_ VGND VGND VPWR VPWR _2806_ sky130_fd_sc_hd__nor2_4
X_5438_ _2230_ VGND VGND VPWR VPWR _0585_ sky130_fd_sc_hd__clkbuf_1
XFILLER_0_2_581 VGND VGND VPWR VPWR sky130_fd_sc_hd__decap_6
X_5369_ net805 _2002_ _2187_ VGND VGND VPWR VPWR _2194_ sky130_fd_sc_hd__mux2_1
X_8157_ clknet_leaf_3_clk _0246_ VGND VGND VPWR VPWR u_input_buffer.fifo_mem\[53\]\[3\]
+ sky130_fd_sc_hd__dfxtp_1
X_7108_ _3346_ _3348_ _3350_ _3352_ VGND VGND VPWR VPWR _3353_ sky130_fd_sc_hd__or4_1
X_8088_ clknet_leaf_85_clk _0177_ VGND VGND VPWR VPWR u_input_buffer.fifo_mem\[58\]\[14\]
+ sky130_fd_sc_hd__dfxtp_1
X_7039_ u_input_buffer.fifo_mem\[17\]\[6\] _2943_ _2945_ u_input_buffer.fifo_mem\[5\]\[6\]
+ VGND VGND VPWR VPWR _3285_ sky130_fd_sc_hd__a22o_1
XFILLER_0_69_337 VGND VGND VPWR VPWR sky130_fd_sc_hd__fill_1
XTAP_1013 VGND VPWR sky130_fd_sc_hd__tapvpwrvgnd_1
XTAP_1002 VGND VPWR sky130_fd_sc_hd__tapvpwrvgnd_1
XFILLER_0_84_307 VGND VGND VPWR VPWR sky130_fd_sc_hd__fill_1
XTAP_1046 VGND VPWR sky130_fd_sc_hd__tapvpwrvgnd_1
XTAP_1035 VGND VPWR sky130_fd_sc_hd__tapvpwrvgnd_1
XTAP_1024 VGND VPWR sky130_fd_sc_hd__tapvpwrvgnd_1
XFILLER_0_108_601 VGND VGND VPWR VPWR sky130_fd_sc_hd__decap_6
XFILLER_0_77_370 VGND VGND VPWR VPWR sky130_fd_sc_hd__decap_4
XTAP_1079 VGND VPWR sky130_fd_sc_hd__tapvpwrvgnd_1
XTAP_1068 VGND VPWR sky130_fd_sc_hd__tapvpwrvgnd_1
XTAP_1057 VGND VPWR sky130_fd_sc_hd__tapvpwrvgnd_1
XFILLER_0_37_234 VGND VGND VPWR VPWR sky130_fd_sc_hd__fill_1
XFILLER_0_108_623 VGND VGND VPWR VPWR sky130_fd_sc_hd__fill_2
XFILLER_0_92_340 VGND VGND VPWR VPWR sky130_fd_sc_hd__fill_1
XFILLER_0_108_645 VGND VGND VPWR VPWR sky130_fd_sc_hd__decap_6
XFILLER_0_9_180 VGND VGND VPWR VPWR sky130_fd_sc_hd__fill_2
XFILLER_0_33_440 VGND VGND VPWR VPWR sky130_fd_sc_hd__fill_1
XFILLER_0_110_309 VGND VGND VPWR VPWR sky130_fd_sc_hd__fill_1
XFILLER_0_103_361 VGND VGND VPWR VPWR sky130_fd_sc_hd__decap_3
XTAP_808 VGND VPWR sky130_fd_sc_hd__tapvpwrvgnd_1
XTAP_819 VGND VPWR sky130_fd_sc_hd__tapvpwrvgnd_1
XFILLER_0_87_178 VGND VGND VPWR VPWR sky130_fd_sc_hd__fill_1
XFILLER_0_68_392 VGND VGND VPWR VPWR sky130_fd_sc_hd__fill_1
XTAP_1591 VGND VPWR sky130_fd_sc_hd__tapvpwrvgnd_1
XFILLER_0_113_55 VGND VGND VPWR VPWR sky130_fd_sc_hd__fill_1
XTAP_1580 VGND VPWR sky130_fd_sc_hd__tapvpwrvgnd_1
Xclkbuf_leaf_107_clk clknet_3_0__leaf_clk VGND VGND VPWR VPWR clknet_leaf_107_clk
+ sky130_fd_sc_hd__clkbuf_16
X_4740_ net443 _1726_ _1835_ VGND VGND VPWR VPWR _1848_ sky130_fd_sc_hd__mux2_1
XFILLER_0_113_88 VGND VGND VPWR VPWR sky130_fd_sc_hd__decap_8
X_4671_ _1810_ VGND VGND VPWR VPWR _0238_ sky130_fd_sc_hd__clkbuf_1
XFILLER_0_113_99 VPWR VGND VPWR VGND sky130_ef_sc_hd__decap_12
X_6410_ _2765_ VGND VGND VPWR VPWR _1022_ sky130_fd_sc_hd__clkbuf_1
X_7390_ u_input_buffer.fifo_mem\[17\]\[15\] _2942_ _2944_ u_input_buffer.fifo_mem\[5\]\[15\]
+ VGND VGND VPWR VPWR _3627_ sky130_fd_sc_hd__a22o_1
XFILLER_0_114_637 VGND VGND VPWR VPWR sky130_fd_sc_hd__decap_6
XFILLER_0_113_125 VPWR VGND VPWR VGND sky130_ef_sc_hd__decap_12
XFILLER_0_3_334 VGND VGND VPWR VPWR sky130_fd_sc_hd__fill_2
X_6341_ net381 _2520_ _2716_ VGND VGND VPWR VPWR _2729_ sky130_fd_sc_hd__mux2_1
XFILLER_0_113_169 VPWR VGND VPWR VGND sky130_ef_sc_hd__decap_12
XFILLER_0_3_367 VGND VGND VPWR VPWR sky130_fd_sc_hd__fill_1
XFILLER_0_51_281 VGND VGND VPWR VPWR sky130_fd_sc_hd__fill_2
X_9060_ clknet_leaf_105_clk _1149_ VGND VGND VPWR VPWR u_sensor_interface.sensor_array\[3\]\[7\]
+ sky130_fd_sc_hd__dfxtp_1
X_6272_ _1624_ net1291 _2679_ VGND VGND VPWR VPWR _2692_ sky130_fd_sc_hd__mux2_1
X_5223_ net1292 _1992_ _2115_ VGND VGND VPWR VPWR _2117_ sky130_fd_sc_hd__mux2_1
X_8011_ clknet_leaf_44_clk _0100_ VGND VGND VPWR VPWR u_input_buffer.fifo_mem\[62\]\[1\]
+ sky130_fd_sc_hd__dfxtp_1
X_5154_ net972 _1992_ _2078_ VGND VGND VPWR VPWR _2080_ sky130_fd_sc_hd__mux2_1
X_4105_ _1425_ VGND VGND VPWR VPWR _0057_ sky130_fd_sc_hd__clkbuf_1
X_5085_ _2043_ VGND VGND VPWR VPWR _0419_ sky130_fd_sc_hd__clkbuf_1
X_8913_ clknet_leaf_55_clk _1002_ VGND VGND VPWR VPWR u_input_buffer.fifo_mem\[6\]\[7\]
+ sky130_fd_sc_hd__dfxtp_1
X_4036_ u_sensor_interface.sensor_array\[0\]\[10\] net47 _1367_ VGND VGND VPWR VPWR
+ _1370_ sky130_fd_sc_hd__mux2_1
XFILLER_0_2_41 VPWR VGND VPWR VGND sky130_ef_sc_hd__decap_12
X_8844_ clknet_leaf_49_clk _0933_ VGND VGND VPWR VPWR u_input_buffer.fifo_mem\[10\]\[2\]
+ sky130_fd_sc_hd__dfxtp_1
XFILLER_0_2_85 VGND VGND VPWR VPWR sky130_fd_sc_hd__decap_4
XPHY_107 VGND VGND VPWR VPWR sky130_fd_sc_hd__decap_3
XPHY_129 VGND VGND VPWR VPWR sky130_fd_sc_hd__decap_3
XPHY_118 VGND VGND VPWR VPWR sky130_fd_sc_hd__decap_3
X_8775_ clknet_leaf_13_clk _0864_ VGND VGND VPWR VPWR u_input_buffer.fifo_mem\[15\]\[13\]
+ sky130_fd_sc_hd__dfxtp_1
X_5987_ _1616_ net976 _2531_ VGND VGND VPWR VPWR _2539_ sky130_fd_sc_hd__mux2_1
X_4938_ net881 _1712_ _1952_ VGND VGND VPWR VPWR _1957_ sky130_fd_sc_hd__mux2_1
X_7726_ _3846_ VGND VGND VPWR VPWR _1257_ sky130_fd_sc_hd__clkbuf_1
XFILLER_0_19_256 VGND VGND VPWR VPWR sky130_fd_sc_hd__decap_4
X_7657_ u_register_bank.status_flags\[4\] _3775_ _3778_ u_register_bank.sensor_enable\[4\]
+ VGND VGND VPWR VPWR _3793_ sky130_fd_sc_hd__a22o_1
X_4869_ _1918_ VGND VGND VPWR VPWR _0328_ sky130_fd_sc_hd__clkbuf_1
XANTENNA_41 _2246_ VGND VGND VPWR VPWR sky130_fd_sc_hd__diode_2
XANTENNA_30 net71 VGND VGND VPWR VPWR sky130_fd_sc_hd__diode_2
XFILLER_0_19_289 VGND VGND VPWR VPWR sky130_fd_sc_hd__fill_2
XANTENNA_52 u_analytics_engine.data_valid VGND VGND VPWR VPWR sky130_fd_sc_hd__diode_2
XFILLER_0_7_673 VPWR VGND VPWR VGND sky130_ef_sc_hd__decap_12
X_6608_ u_input_buffer.rd_ptr\[0\] VGND VGND VPWR VPWR _2872_ sky130_fd_sc_hd__clkbuf_2
XFILLER_0_6_194 VGND VGND VPWR VPWR sky130_fd_sc_hd__fill_2
X_7588_ _3749_ VGND VGND VPWR VPWR _1216_ sky130_fd_sc_hd__clkbuf_1
XFILLER_0_30_410 VGND VGND VPWR VPWR sky130_fd_sc_hd__fill_1
XFILLER_0_30_421 VGND VGND VPWR VPWR sky130_fd_sc_hd__fill_2
X_6539_ _1618_ net1104 _2825_ VGND VGND VPWR VPWR _2834_ sky130_fd_sc_hd__mux2_1
X_9189_ clknet_leaf_50_clk _1277_ net199 VGND VGND VPWR VPWR net161 sky130_fd_sc_hd__dfrtp_2
XFILLER_0_100_331 VGND VGND VPWR VPWR sky130_fd_sc_hd__decap_6
X_8209_ clknet_leaf_39_clk _0298_ VGND VGND VPWR VPWR u_input_buffer.fifo_mem\[50\]\[7\]
+ sky130_fd_sc_hd__dfxtp_1
XPHY_9 VGND VGND VPWR VPWR sky130_fd_sc_hd__decap_3
XFILLER_0_84_115 VGND VGND VPWR VPWR sky130_fd_sc_hd__fill_2
XFILLER_0_93_660 VPWR VGND VPWR VGND sky130_ef_sc_hd__decap_12
XFILLER_0_38_543 VGND VGND VPWR VPWR sky130_fd_sc_hd__fill_1
XFILLER_0_108_442 VGND VGND VPWR VPWR sky130_fd_sc_hd__decap_3
XFILLER_0_108_475 VGND VGND VPWR VPWR sky130_fd_sc_hd__fill_1
XFILLER_0_80_332 VGND VGND VPWR VPWR sky130_fd_sc_hd__decap_3
XFILLER_0_80_365 VGND VGND VPWR VPWR sky130_fd_sc_hd__decap_6
XFILLER_0_33_281 VGND VGND VPWR VPWR sky130_fd_sc_hd__fill_1
XFILLER_0_111_629 VPWR VGND VPWR VGND sky130_ef_sc_hd__decap_12
XFILLER_0_68_27 VGND VGND VPWR VPWR sky130_fd_sc_hd__fill_1
XFILLER_0_110_139 VGND VGND VPWR VPWR sky130_fd_sc_hd__fill_1
XTAP_605 VGND VPWR sky130_fd_sc_hd__tapvpwrvgnd_1
XTAP_616 VGND VPWR sky130_fd_sc_hd__tapvpwrvgnd_1
XTAP_627 VGND VPWR sky130_fd_sc_hd__tapvpwrvgnd_1
XTAP_638 VGND VPWR sky130_fd_sc_hd__tapvpwrvgnd_1
XTAP_649 VGND VPWR sky130_fd_sc_hd__tapvpwrvgnd_1
XFILLER_0_84_15 VPWR VGND VPWR VGND sky130_ef_sc_hd__decap_12
XFILLER_0_108_77 VGND VGND VPWR VPWR sky130_fd_sc_hd__decap_6
XFILLER_0_17_42 VPWR VGND VPWR VGND sky130_ef_sc_hd__decap_12
XFILLER_0_88_443 VGND VGND VPWR VPWR sky130_fd_sc_hd__decap_6
XFILLER_0_17_86 VGND VGND VPWR VPWR sky130_fd_sc_hd__decap_3
X_5910_ _2490_ VGND VGND VPWR VPWR _0797_ sky130_fd_sc_hd__clkbuf_1
X_6890_ u_input_buffer.fifo_mem\[2\]\[2\] _2984_ _2986_ u_input_buffer.fifo_mem\[32\]\[2\]
+ VGND VGND VPWR VPWR _3140_ sky130_fd_sc_hd__a22o_1
X_5841_ _1622_ net990 _2442_ VGND VGND VPWR VPWR _2454_ sky130_fd_sc_hd__mux2_1
XFILLER_0_29_532 VGND VGND VPWR VPWR sky130_fd_sc_hd__decap_4
X_8560_ clknet_leaf_52_clk _0649_ VGND VGND VPWR VPWR u_input_buffer.fifo_mem\[28\]\[6\]
+ sky130_fd_sc_hd__dfxtp_1
X_5772_ _2417_ VGND VGND VPWR VPWR _0732_ sky130_fd_sc_hd__clkbuf_1
X_4723_ _1839_ VGND VGND VPWR VPWR _0261_ sky130_fd_sc_hd__clkbuf_1
X_7511_ net41 u_register_bank.window_cfg\[7\] _3700_ VGND VGND VPWR VPWR _3708_ sky130_fd_sc_hd__mux2_1
X_8491_ clknet_leaf_25_clk _0580_ VGND VGND VPWR VPWR u_input_buffer.fifo_mem\[32\]\[1\]
+ sky130_fd_sc_hd__dfxtp_1
XFILLER_0_84_682 VGND VGND VPWR VPWR sky130_fd_sc_hd__decap_4
X_7442_ _3669_ VGND VGND VPWR VPWR _1150_ sky130_fd_sc_hd__clkbuf_1
X_4654_ net375 _1710_ _1798_ VGND VGND VPWR VPWR _1802_ sky130_fd_sc_hd__mux2_1
XFILLER_0_4_643 VGND VGND VPWR VPWR sky130_fd_sc_hd__fill_1
X_4585_ net748 _1714_ _1757_ VGND VGND VPWR VPWR _1763_ sky130_fd_sc_hd__mux2_1
Xhold812 u_input_buffer.fifo_mem\[28\]\[7\] VGND VGND VPWR VPWR net1024 sky130_fd_sc_hd__dlygate4sd3_1
Xinput50 sensor_data_in[13] VGND VGND VPWR VPWR net50 sky130_fd_sc_hd__clkbuf_2
Xinput61 sensor_data_in[23] VGND VGND VPWR VPWR net61 sky130_fd_sc_hd__clkbuf_1
Xhold801 u_input_buffer.fifo_mem\[49\]\[11\] VGND VGND VPWR VPWR net1013 sky130_fd_sc_hd__dlygate4sd3_1
X_7373_ u_input_buffer.fifo_mem\[39\]\[14\] _3049_ _3051_ u_input_buffer.fifo_mem\[40\]\[14\]
+ VGND VGND VPWR VPWR _3611_ sky130_fd_sc_hd__a22o_1
Xinput72 sensor_data_in[33] VGND VGND VPWR VPWR net72 sky130_fd_sc_hd__buf_1
Xhold834 u_input_buffer.fifo_mem\[23\]\[5\] VGND VGND VPWR VPWR net1046 sky130_fd_sc_hd__dlygate4sd3_1
X_6324_ _2720_ VGND VGND VPWR VPWR _0981_ sky130_fd_sc_hd__clkbuf_1
Xinput83 sensor_data_in[43] VGND VGND VPWR VPWR net83 sky130_fd_sc_hd__clkbuf_1
Xhold845 u_input_buffer.fifo_mem\[29\]\[10\] VGND VGND VPWR VPWR net1057 sky130_fd_sc_hd__dlygate4sd3_1
Xhold823 u_input_buffer.fifo_mem\[13\]\[13\] VGND VGND VPWR VPWR net1035 sky130_fd_sc_hd__dlygate4sd3_1
Xinput94 sensor_data_in[53] VGND VGND VPWR VPWR net94 sky130_fd_sc_hd__clkbuf_1
X_9112_ net174 _1200_ net206 VGND VGND VPWR VPWR u_register_bank.window_cfg\[26\]
+ sky130_fd_sc_hd__dfrtp_1
Xhold856 u_input_buffer.fifo_mem\[43\]\[0\] VGND VGND VPWR VPWR net1068 sky130_fd_sc_hd__dlygate4sd3_1
Xhold878 u_input_buffer.fifo_mem\[31\]\[5\] VGND VGND VPWR VPWR net1090 sky130_fd_sc_hd__dlygate4sd3_1
X_9043_ clknet_leaf_46_clk _1132_ VGND VGND VPWR VPWR u_analytics_engine.data_in\[6\]
+ sky130_fd_sc_hd__dfxtp_2
X_6255_ _2683_ VGND VGND VPWR VPWR _0949_ sky130_fd_sc_hd__clkbuf_1
Xhold889 u_input_buffer.fifo_mem\[29\]\[14\] VGND VGND VPWR VPWR net1101 sky130_fd_sc_hd__dlygate4sd3_1
Xhold867 u_input_buffer.fifo_mem\[30\]\[15\] VGND VGND VPWR VPWR net1079 sky130_fd_sc_hd__dlygate4sd3_1
X_5206_ _2107_ VGND VGND VPWR VPWR _0476_ sky130_fd_sc_hd__clkbuf_1
XFILLER_0_58_82 VGND VGND VPWR VPWR sky130_fd_sc_hd__fill_2
X_6186_ net644 _2502_ _2644_ VGND VGND VPWR VPWR _2647_ sky130_fd_sc_hd__mux2_1
X_5137_ _2070_ VGND VGND VPWR VPWR _0444_ sky130_fd_sc_hd__clkbuf_1
X_5068_ net384 _2008_ _2024_ VGND VGND VPWR VPWR _2034_ sky130_fd_sc_hd__mux2_1
X_4019_ net1314 net68 _1356_ VGND VGND VPWR VPWR _1361_ sky130_fd_sc_hd__mux2_1
XFILLER_0_79_465 VGND VGND VPWR VPWR sky130_fd_sc_hd__fill_1
X_8827_ clknet_leaf_38_clk _0916_ VGND VGND VPWR VPWR u_input_buffer.fifo_mem\[11\]\[1\]
+ sky130_fd_sc_hd__dfxtp_1
XFILLER_0_90_80 VGND VGND VPWR VPWR sky130_fd_sc_hd__decap_4
XFILLER_0_66_159 VGND VGND VPWR VPWR sky130_fd_sc_hd__decap_8
X_8758_ clknet_leaf_99_clk _0847_ VGND VGND VPWR VPWR u_input_buffer.fifo_mem\[16\]\[12\]
+ sky130_fd_sc_hd__dfxtp_1
XFILLER_0_75_671 VGND VGND VPWR VPWR sky130_fd_sc_hd__fill_1
X_7709_ _3833_ VGND VGND VPWR VPWR _1253_ sky130_fd_sc_hd__clkbuf_1
X_8689_ clknet_leaf_49_clk _0778_ VGND VGND VPWR VPWR u_input_buffer.fifo_mem\[20\]\[7\]
+ sky130_fd_sc_hd__dfxtp_1
XFILLER_0_105_412 VGND VGND VPWR VPWR sky130_fd_sc_hd__fill_2
XFILLER_0_30_273 VGND VGND VPWR VPWR sky130_fd_sc_hd__fill_2
XFILLER_0_101_673 VPWR VGND VPWR VGND sky130_ef_sc_hd__decap_12
XFILLER_0_70_39 VGND VGND VPWR VPWR sky130_fd_sc_hd__fill_2
XFILLER_0_38_340 VGND VGND VPWR VPWR sky130_fd_sc_hd__fill_2
XFILLER_0_81_685 VGND VGND VPWR VPWR sky130_fd_sc_hd__fill_1
XFILLER_0_81_663 VGND VGND VPWR VPWR sky130_fd_sc_hd__decap_8
XFILLER_0_41_505 VGND VGND VPWR VPWR sky130_fd_sc_hd__fill_1
XFILLER_0_80_195 VGND VGND VPWR VPWR sky130_fd_sc_hd__fill_1
Xhold108 u_input_buffer.fifo_mem\[60\]\[3\] VGND VGND VPWR VPWR net320 sky130_fd_sc_hd__dlygate4sd3_1
XFILLER_0_13_218 VGND VGND VPWR VPWR sky130_fd_sc_hd__fill_2
Xhold119 u_input_buffer.fifo_mem\[30\]\[8\] VGND VGND VPWR VPWR net331 sky130_fd_sc_hd__dlygate4sd3_1
X_4370_ _1633_ VGND VGND VPWR VPWR _0114_ sky130_fd_sc_hd__clkbuf_1
XTAP_402 VGND VPWR sky130_fd_sc_hd__tapvpwrvgnd_1
XTAP_413 VGND VPWR sky130_fd_sc_hd__tapvpwrvgnd_1
XFILLER_0_1_679 VGND VGND VPWR VPWR sky130_fd_sc_hd__fill_1
XTAP_424 VGND VPWR sky130_fd_sc_hd__tapvpwrvgnd_1
XFILLER_0_95_69 VPWR VGND VPWR VGND sky130_ef_sc_hd__decap_12
XTAP_435 VGND VPWR sky130_fd_sc_hd__tapvpwrvgnd_1
XTAP_446 VGND VPWR sky130_fd_sc_hd__tapvpwrvgnd_1
XTAP_457 VGND VPWR sky130_fd_sc_hd__tapvpwrvgnd_1
X_6040_ _2566_ VGND VGND VPWR VPWR _2567_ sky130_fd_sc_hd__buf_8
XTAP_468 VGND VPWR sky130_fd_sc_hd__tapvpwrvgnd_1
XTAP_479 VGND VPWR sky130_fd_sc_hd__tapvpwrvgnd_1
XFILLER_0_28_85 VGND VGND VPWR VPWR sky130_fd_sc_hd__decap_6
X_7991_ clknet_leaf_80_clk _0080_ net188 VGND VGND VPWR VPWR u_sample_counter.sample_count\[14\]
+ sky130_fd_sc_hd__dfrtp_1
X_6942_ u_input_buffer.fifo_mem\[6\]\[3\] _3035_ _3037_ u_input_buffer.fifo_mem\[28\]\[3\]
+ _3190_ VGND VGND VPWR VPWR _3191_ sky130_fd_sc_hd__a221o_1
X_6873_ u_input_buffer.fifo_mem\[63\]\[1\] _2887_ _3076_ u_input_buffer.fifo_mem\[55\]\[1\]
+ _3123_ VGND VGND VPWR VPWR _3124_ sky130_fd_sc_hd__a221o_1
X_8612_ clknet_leaf_105_clk _0701_ VGND VGND VPWR VPWR u_input_buffer.fifo_mem\[25\]\[10\]
+ sky130_fd_sc_hd__dfxtp_1
X_5824_ _2445_ VGND VGND VPWR VPWR _0756_ sky130_fd_sc_hd__clkbuf_1
XFILLER_0_57_682 VGND VGND VPWR VPWR sky130_fd_sc_hd__decap_4
XFILLER_0_57_660 VGND VGND VPWR VPWR sky130_fd_sc_hd__fill_1
X_5755_ net750 _2246_ _2407_ VGND VGND VPWR VPWR _2409_ sky130_fd_sc_hd__mux2_1
XFILLER_0_56_170 VGND VGND VPWR VPWR sky130_fd_sc_hd__decap_4
X_8543_ clknet_leaf_2_clk _0632_ VGND VGND VPWR VPWR u_input_buffer.fifo_mem\[29\]\[5\]
+ sky130_fd_sc_hd__dfxtp_1
X_4706_ _1829_ VGND VGND VPWR VPWR _0254_ sky130_fd_sc_hd__clkbuf_1
X_8474_ clknet_leaf_6_clk _0563_ VGND VGND VPWR VPWR u_input_buffer.fifo_mem\[33\]\[0\]
+ sky130_fd_sc_hd__dfxtp_1
X_5686_ _1604_ net1145 _2370_ VGND VGND VPWR VPWR _2372_ sky130_fd_sc_hd__mux2_1
X_7425_ _3660_ VGND VGND VPWR VPWR _1142_ sky130_fd_sc_hd__clkbuf_1
XFILLER_0_72_685 VGND VGND VPWR VPWR sky130_fd_sc_hd__fill_1
XFILLER_0_4_440 VPWR VGND VPWR VGND sky130_ef_sc_hd__decap_12
X_4637_ _1791_ VGND VGND VPWR VPWR _0223_ sky130_fd_sc_hd__clkbuf_1
Xhold620 u_input_buffer.fifo_mem\[1\]\[6\] VGND VGND VPWR VPWR net832 sky130_fd_sc_hd__dlygate4sd3_1
XFILLER_0_12_251 VGND VGND VPWR VPWR sky130_fd_sc_hd__fill_1
X_4568_ _1463_ net971 _1737_ VGND VGND VPWR VPWR _1753_ sky130_fd_sc_hd__mux2_1
Xhold642 u_input_buffer.fifo_mem\[41\]\[15\] VGND VGND VPWR VPWR net854 sky130_fd_sc_hd__dlygate4sd3_1
Xhold631 u_input_buffer.fifo_mem\[28\]\[12\] VGND VGND VPWR VPWR net843 sky130_fd_sc_hd__dlygate4sd3_1
X_7356_ u_input_buffer.fifo_mem\[16\]\[14\] _2970_ _2972_ u_input_buffer.fifo_mem\[49\]\[14\]
+ _2974_ VGND VGND VPWR VPWR _3594_ sky130_fd_sc_hd__a221o_1
Xhold653 u_input_buffer.fifo_mem\[44\]\[14\] VGND VGND VPWR VPWR net865 sky130_fd_sc_hd__dlygate4sd3_1
Xhold664 u_input_buffer.fifo_mem\[28\]\[6\] VGND VGND VPWR VPWR net876 sky130_fd_sc_hd__dlygate4sd3_1
Xhold686 u_input_buffer.fifo_mem\[63\]\[2\] VGND VGND VPWR VPWR net898 sky130_fd_sc_hd__dlygate4sd3_1
X_4499_ net587 _1710_ _1704_ VGND VGND VPWR VPWR _1711_ sky130_fd_sc_hd__mux2_1
Xhold675 u_input_buffer.fifo_mem\[37\]\[7\] VGND VGND VPWR VPWR net887 sky130_fd_sc_hd__dlygate4sd3_1
Xhold697 u_input_buffer.fifo_mem\[30\]\[12\] VGND VGND VPWR VPWR net909 sky130_fd_sc_hd__dlygate4sd3_1
X_7287_ u_input_buffer.fifo_mem\[8\]\[12\] _3003_ _3005_ u_input_buffer.fifo_mem\[19\]\[12\]
+ _3526_ VGND VGND VPWR VPWR _3527_ sky130_fd_sc_hd__a221o_1
X_6307_ _2710_ VGND VGND VPWR VPWR _0974_ sky130_fd_sc_hd__clkbuf_1
XFILLER_0_40_593 VGND VGND VPWR VPWR sky130_fd_sc_hd__fill_1
XFILLER_0_110_470 VGND VGND VPWR VPWR sky130_fd_sc_hd__fill_2
X_9026_ clknet_leaf_94_clk _1115_ net192 VGND VGND VPWR VPWR u_input_buffer.rd_ptr\[1\]
+ sky130_fd_sc_hd__dfrtp_4
X_6238_ net1045 _2520_ _2661_ VGND VGND VPWR VPWR _2674_ sky130_fd_sc_hd__mux2_1
XTAP_980 VGND VPWR sky130_fd_sc_hd__tapvpwrvgnd_1
X_6169_ net724 _2520_ _2624_ VGND VGND VPWR VPWR _2637_ sky130_fd_sc_hd__mux2_1
XFILLER_0_99_527 VGND VGND VPWR VPWR sky130_fd_sc_hd__fill_1
XFILLER_0_99_505 VGND VGND VPWR VPWR sky130_fd_sc_hd__decap_6
XTAP_991 VGND VPWR sky130_fd_sc_hd__tapvpwrvgnd_1
Xclkbuf_leaf_96_clk clknet_3_3__leaf_clk VGND VGND VPWR VPWR clknet_leaf_96_clk sky130_fd_sc_hd__clkbuf_16
XFILLER_0_67_457 VGND VGND VPWR VPWR sky130_fd_sc_hd__decap_4
Xclkbuf_leaf_20_clk clknet_3_4__leaf_clk VGND VGND VPWR VPWR clknet_leaf_20_clk sky130_fd_sc_hd__clkbuf_16
Xclkbuf_leaf_87_clk clknet_3_2__leaf_clk VGND VGND VPWR VPWR clknet_leaf_87_clk sky130_fd_sc_hd__clkbuf_16
XFILLER_0_85_221 VGND VGND VPWR VPWR sky130_fd_sc_hd__decap_3
XFILLER_0_14_21 VGND VGND VPWR VPWR sky130_fd_sc_hd__decap_6
XFILLER_0_14_65 VGND VGND VPWR VPWR sky130_fd_sc_hd__decap_6
XFILLER_0_109_570 VGND VGND VPWR VPWR sky130_fd_sc_hd__decap_3
X_5540_ _2292_ VGND VGND VPWR VPWR _0625_ sky130_fd_sc_hd__clkbuf_1
XFILLER_0_26_365 VGND VGND VPWR VPWR sky130_fd_sc_hd__decap_4
Xclkbuf_leaf_11_clk clknet_3_1__leaf_clk VGND VGND VPWR VPWR clknet_leaf_11_clk sky130_fd_sc_hd__clkbuf_16
X_5471_ net1091 _2250_ _2244_ VGND VGND VPWR VPWR _2251_ sky130_fd_sc_hd__mux2_1
X_4422_ _1665_ VGND VGND VPWR VPWR _0134_ sky130_fd_sc_hd__clkbuf_1
X_7210_ u_input_buffer.fifo_mem\[31\]\[10\] _3016_ _3019_ u_input_buffer.fifo_mem\[38\]\[10\]
+ VGND VGND VPWR VPWR _3452_ sky130_fd_sc_hd__a22o_1
X_8190_ clknet_leaf_16_clk _0279_ VGND VGND VPWR VPWR u_input_buffer.fifo_mem\[51\]\[4\]
+ sky130_fd_sc_hd__dfxtp_1
XFILLER_0_111_278 VGND VGND VPWR VPWR sky130_fd_sc_hd__fill_2
X_7141_ u_input_buffer.fifo_mem\[15\]\[8\] _3060_ _3062_ u_input_buffer.fifo_mem\[43\]\[8\]
+ VGND VGND VPWR VPWR _3385_ sky130_fd_sc_hd__a22o_1
X_4353_ u_input_buffer.data_in\[10\] VGND VGND VPWR VPWR _1622_ sky130_fd_sc_hd__clkbuf_4
X_7072_ u_analytics_engine.data_in\[6\] _2893_ _3316_ _3317_ VGND VGND VPWR VPWR _1132_
+ sky130_fd_sc_hd__a22o_1
X_4284_ u_analytics_engine.data_in\[4\] VGND VGND VPWR VPWR _1564_ sky130_fd_sc_hd__inv_2
XTAP_232 VGND VPWR sky130_fd_sc_hd__tapvpwrvgnd_1
X_6023_ net641 _2514_ _2549_ VGND VGND VPWR VPWR _2558_ sky130_fd_sc_hd__mux2_1
XTAP_243 VGND VPWR sky130_fd_sc_hd__tapvpwrvgnd_1
XTAP_265 VGND VPWR sky130_fd_sc_hd__tapvpwrvgnd_1
XTAP_254 VGND VPWR sky130_fd_sc_hd__tapvpwrvgnd_1
XTAP_298 VGND VPWR sky130_fd_sc_hd__tapvpwrvgnd_1
XTAP_287 VGND VPWR sky130_fd_sc_hd__tapvpwrvgnd_1
XTAP_276 VGND VPWR sky130_fd_sc_hd__tapvpwrvgnd_1
Xclkbuf_leaf_78_clk clknet_3_3__leaf_clk VGND VGND VPWR VPWR clknet_leaf_78_clk sky130_fd_sc_hd__clkbuf_16
X_7974_ clknet_leaf_102_clk _0064_ net184 VGND VGND VPWR VPWR u_input_buffer.data_in\[14\]
+ sky130_fd_sc_hd__dfrtp_1
X_6925_ u_input_buffer.fifo_mem\[14\]\[3\] _2958_ _2961_ u_input_buffer.fifo_mem\[42\]\[3\]
+ VGND VGND VPWR VPWR _3174_ sky130_fd_sc_hd__a22o_1
XTAP_1409 VGND VPWR sky130_fd_sc_hd__tapvpwrvgnd_1
XFILLER_0_12_3 VPWR VGND VPWR VGND sky130_ef_sc_hd__decap_12
XFILLER_0_76_265 VGND VGND VPWR VPWR sky130_fd_sc_hd__fill_2
X_6856_ _3091_ _3093_ _3097_ _3106_ VGND VGND VPWR VPWR _3107_ sky130_fd_sc_hd__or4_2
X_3999_ _1350_ VGND VGND VPWR VPWR _0026_ sky130_fd_sc_hd__clkbuf_1
X_5807_ net1111 _2264_ _2424_ VGND VGND VPWR VPWR _2436_ sky130_fd_sc_hd__mux2_1
X_6787_ _3038_ VGND VGND VPWR VPWR _3039_ sky130_fd_sc_hd__buf_4
X_8526_ clknet_leaf_59_clk _0615_ VGND VGND VPWR VPWR u_input_buffer.fifo_mem\[30\]\[4\]
+ sky130_fd_sc_hd__dfxtp_1
XFILLER_0_60_600 VGND VGND VPWR VPWR sky130_fd_sc_hd__decap_6
X_5738_ net483 _2264_ _2387_ VGND VGND VPWR VPWR _2399_ sky130_fd_sc_hd__mux2_1
XFILLER_0_60_633 VGND VGND VPWR VPWR sky130_fd_sc_hd__decap_8
XFILLER_0_32_324 VGND VGND VPWR VPWR sky130_fd_sc_hd__fill_2
X_5669_ _2362_ VGND VGND VPWR VPWR _0684_ sky130_fd_sc_hd__clkbuf_1
X_8457_ clknet_leaf_11_clk _0546_ VGND VGND VPWR VPWR u_input_buffer.fifo_mem\[35\]\[15\]
+ sky130_fd_sc_hd__dfxtp_1
X_8388_ clknet_leaf_71_clk _0477_ VGND VGND VPWR VPWR u_input_buffer.fifo_mem\[39\]\[10\]
+ sky130_fd_sc_hd__dfxtp_1
X_7408_ u_input_buffer.fifo_mem\[7\]\[15\] _3024_ _3026_ u_input_buffer.fifo_mem\[22\]\[15\]
+ _3644_ VGND VGND VPWR VPWR _3645_ sky130_fd_sc_hd__a221o_1
Xhold472 u_input_buffer.fifo_mem\[12\]\[1\] VGND VGND VPWR VPWR net684 sky130_fd_sc_hd__dlygate4sd3_1
Xhold461 u_input_buffer.fifo_mem\[30\]\[9\] VGND VGND VPWR VPWR net673 sky130_fd_sc_hd__dlygate4sd3_1
X_7339_ u_input_buffer.fifo_mem\[26\]\[13\] _3065_ _3067_ u_input_buffer.fifo_mem\[62\]\[13\]
+ _3577_ VGND VGND VPWR VPWR _3578_ sky130_fd_sc_hd__a221o_1
Xhold450 u_input_buffer.fifo_mem\[23\]\[13\] VGND VGND VPWR VPWR net662 sky130_fd_sc_hd__dlygate4sd3_1
XFILLER_0_102_289 VGND VGND VPWR VPWR sky130_fd_sc_hd__decap_3
Xhold494 u_input_buffer.fifo_mem\[47\]\[7\] VGND VGND VPWR VPWR net706 sky130_fd_sc_hd__dlygate4sd3_1
Xhold483 u_input_buffer.fifo_mem\[62\]\[13\] VGND VGND VPWR VPWR net695 sky130_fd_sc_hd__dlygate4sd3_1
X_9009_ clknet_leaf_48_clk _1098_ VGND VGND VPWR VPWR u_input_buffer.fifo_mem\[0\]\[7\]
+ sky130_fd_sc_hd__dfxtp_1
Xclkbuf_leaf_69_clk clknet_3_6__leaf_clk VGND VGND VPWR VPWR clknet_leaf_69_clk sky130_fd_sc_hd__clkbuf_16
XFILLER_0_87_519 VGND VGND VPWR VPWR sky130_fd_sc_hd__decap_4
XFILLER_0_95_552 VGND VGND VPWR VPWR sky130_fd_sc_hd__fill_1
XFILLER_0_27_107 VGND VGND VPWR VPWR sky130_fd_sc_hd__fill_2
XFILLER_0_23_335 VGND VGND VPWR VPWR sky130_fd_sc_hd__fill_1
XFILLER_0_76_49 VGND VGND VPWR VPWR sky130_fd_sc_hd__decap_3
XFILLER_0_76_27 VGND VGND VPWR VPWR sky130_fd_sc_hd__fill_1
XFILLER_0_92_15 VPWR VGND VPWR VGND sky130_ef_sc_hd__decap_12
Xclkbuf_leaf_0_clk clknet_3_0__leaf_clk VGND VGND VPWR VPWR clknet_leaf_0_clk sky130_fd_sc_hd__clkbuf_16
X_4971_ _1397_ net1241 _1971_ VGND VGND VPWR VPWR _1975_ sky130_fd_sc_hd__mux2_1
X_6710_ u_input_buffer.fifo_mem\[14\]\[0\] _2958_ _2961_ u_input_buffer.fifo_mem\[42\]\[0\]
+ VGND VGND VPWR VPWR _2962_ sky130_fd_sc_hd__a22o_1
X_7690_ u_register_bank.status_flags\[11\] _3814_ _3808_ u_register_bank.sensor_enable\[11\]
+ VGND VGND VPWR VPWR _3819_ sky130_fd_sc_hd__a22o_1
X_6641_ _2892_ VGND VGND VPWR VPWR _2893_ sky130_fd_sc_hd__clkbuf_4
XFILLER_0_46_427 VGND VGND VPWR VPWR sky130_fd_sc_hd__decap_3
XFILLER_0_6_524 VGND VGND VPWR VPWR sky130_fd_sc_hd__decap_8
X_6572_ _2851_ VGND VGND VPWR VPWR _1098_ sky130_fd_sc_hd__clkbuf_1
X_8311_ clknet_leaf_71_clk _0400_ VGND VGND VPWR VPWR u_input_buffer.fifo_mem\[44\]\[13\]
+ sky130_fd_sc_hd__dfxtp_1
XFILLER_0_6_557 VPWR VGND VPWR VGND sky130_ef_sc_hd__decap_12
X_5523_ net560 _2256_ _2277_ VGND VGND VPWR VPWR _2284_ sky130_fd_sc_hd__mux2_1
XFILLER_0_81_6 VPWR VGND VPWR VGND sky130_ef_sc_hd__decap_12
X_8242_ clknet_leaf_15_clk _0331_ VGND VGND VPWR VPWR u_input_buffer.fifo_mem\[48\]\[8\]
+ sky130_fd_sc_hd__dfxtp_1
X_5454_ _2238_ VGND VGND VPWR VPWR _0593_ sky130_fd_sc_hd__clkbuf_1
X_8173_ clknet_leaf_68_clk _0262_ VGND VGND VPWR VPWR u_input_buffer.fifo_mem\[52\]\[3\]
+ sky130_fd_sc_hd__dfxtp_1
XFILLER_0_1_251 VGND VGND VPWR VPWR sky130_fd_sc_hd__fill_1
X_4405_ _1457_ net1257 _1640_ VGND VGND VPWR VPWR _1655_ sky130_fd_sc_hd__mux2_1
X_5385_ net693 _2018_ _2186_ VGND VGND VPWR VPWR _2202_ sky130_fd_sc_hd__mux2_1
X_4336_ net347 _1610_ _1602_ VGND VGND VPWR VPWR _1611_ sky130_fd_sc_hd__mux2_1
X_7124_ u_input_buffer.fifo_mem\[2\]\[8\] _2984_ _2986_ u_input_buffer.fifo_mem\[32\]\[8\]
+ VGND VGND VPWR VPWR _3368_ sky130_fd_sc_hd__a22o_1
XFILLER_0_5_30 VGND VGND VPWR VPWR sky130_fd_sc_hd__decap_4
Xfanout204 net205 VGND VGND VPWR VPWR net204 sky130_fd_sc_hd__clkbuf_4
X_7055_ u_input_buffer.fifo_mem\[27\]\[6\] _3013_ _3015_ u_input_buffer.fifo_mem\[59\]\[6\]
+ _3300_ VGND VGND VPWR VPWR _3301_ sky130_fd_sc_hd__a221o_1
XFILLER_0_5_74 VGND VGND VPWR VPWR sky130_fd_sc_hd__fill_1
X_4267_ _1543_ u_analytics_engine.data_in\[10\] _1545_ VGND VGND VPWR VPWR _1547_
+ sky130_fd_sc_hd__o21ai_1
X_4198_ u_sample_counter.sample_count\[12\] net240 _1494_ VGND VGND VPWR VPWR _1497_
+ sky130_fd_sc_hd__nand3_1
X_6006_ _2548_ VGND VGND VPWR VPWR _2549_ sky130_fd_sc_hd__buf_4
XFILLER_0_89_390 VGND VGND VPWR VPWR sky130_fd_sc_hd__fill_2
XTAP_1239 VGND VPWR sky130_fd_sc_hd__tapvpwrvgnd_1
XTAP_1228 VGND VPWR sky130_fd_sc_hd__tapvpwrvgnd_1
XTAP_1217 VGND VPWR sky130_fd_sc_hd__tapvpwrvgnd_1
XTAP_1206 VGND VPWR sky130_fd_sc_hd__tapvpwrvgnd_1
X_7957_ clknet_leaf_104_clk _0047_ VGND VGND VPWR VPWR u_sensor_interface.sensor_array\[0\]\[13\]
+ sky130_fd_sc_hd__dfxtp_1
X_6908_ u_input_buffer.fifo_mem\[10\]\[2\] _3056_ _3058_ u_input_buffer.fifo_mem\[44\]\[2\]
+ _3157_ VGND VGND VPWR VPWR _3158_ sky130_fd_sc_hd__a221o_1
X_7888_ clknet_leaf_58_clk net218 net198 VGND VGND VPWR VPWR u_register_bank.status_flags\[8\]
+ sky130_fd_sc_hd__dfrtp_1
XFILLER_0_37_405 VGND VGND VPWR VPWR sky130_fd_sc_hd__fill_1
XFILLER_0_37_449 VGND VGND VPWR VPWR sky130_fd_sc_hd__decap_6
X_6839_ u_input_buffer.fifo_mem\[21\]\[1\] _2909_ _2913_ u_input_buffer.fifo_mem\[25\]\[1\]
+ VGND VGND VPWR VPWR _3090_ sky130_fd_sc_hd__a22o_1
XFILLER_0_52_419 VGND VGND VPWR VPWR sky130_fd_sc_hd__fill_1
X_8509_ clknet_leaf_68_clk _0598_ VGND VGND VPWR VPWR u_input_buffer.fifo_mem\[31\]\[3\]
+ sky130_fd_sc_hd__dfxtp_1
XFILLER_0_20_305 VGND VGND VPWR VPWR sky130_fd_sc_hd__decap_3
XFILLER_0_33_666 VGND VGND VPWR VPWR sky130_fd_sc_hd__decap_3
Xhold280 u_input_buffer.fifo_mem\[24\]\[7\] VGND VGND VPWR VPWR net492 sky130_fd_sc_hd__dlygate4sd3_1
Xhold291 u_sensor_interface.sensor_array\[1\]\[8\] VGND VGND VPWR VPWR net503 sky130_fd_sc_hd__dlygate4sd3_1
XFILLER_0_68_530 VGND VGND VPWR VPWR sky130_fd_sc_hd__fill_2
XFILLER_0_62_29 VGND VGND VPWR VPWR sky130_fd_sc_hd__fill_1
XFILLER_0_95_393 VGND VGND VPWR VPWR sky130_fd_sc_hd__fill_2
XFILLER_0_55_268 VGND VGND VPWR VPWR sky130_fd_sc_hd__fill_1
XFILLER_0_11_33 VPWR VGND VPWR VGND sky130_ef_sc_hd__decap_12
XFILLER_0_24_600 VGND VGND VPWR VPWR sky130_fd_sc_hd__decap_3
XFILLER_0_3_505 VPWR VGND VPWR VGND sky130_ef_sc_hd__decap_12
XFILLER_0_51_441 VGND VGND VPWR VPWR sky130_fd_sc_hd__decap_4
XFILLER_0_87_37 VPWR VGND VPWR VGND sky130_ef_sc_hd__decap_12
XFILLER_0_51_485 VGND VGND VPWR VPWR sky130_fd_sc_hd__fill_1
X_5170_ net507 _2008_ _2078_ VGND VGND VPWR VPWR _2088_ sky130_fd_sc_hd__mux2_1
X_4121_ _1438_ VGND VGND VPWR VPWR _1439_ sky130_fd_sc_hd__buf_2
X_4052_ _1378_ u_sensor_interface.sensor_array\[2\]\[0\] _1379_ VGND VGND VPWR VPWR
+ _1380_ sky130_fd_sc_hd__mux2_1
Xinput4 cfg_addr[3] VGND VGND VPWR VPWR net4 sky130_fd_sc_hd__buf_2
X_8860_ clknet_leaf_22_clk _0949_ VGND VGND VPWR VPWR u_input_buffer.fifo_mem\[9\]\[2\]
+ sky130_fd_sc_hd__dfxtp_1
X_7811_ _3903_ VGND VGND VPWR VPWR _1285_ sky130_fd_sc_hd__clkbuf_1
X_8791_ clknet_leaf_11_clk _0880_ VGND VGND VPWR VPWR u_input_buffer.fifo_mem\[14\]\[13\]
+ sky130_fd_sc_hd__dfxtp_1
X_4954_ net530 _1728_ _1951_ VGND VGND VPWR VPWR _1965_ sky130_fd_sc_hd__mux2_1
X_7742_ _3859_ VGND VGND VPWR VPWR _1260_ sky130_fd_sc_hd__clkbuf_1
XFILLER_0_74_533 VGND VGND VPWR VPWR sky130_fd_sc_hd__decap_6
XFILLER_0_19_449 VGND VGND VPWR VPWR sky130_fd_sc_hd__decap_3
X_7673_ u_register_bank.status_flags\[8\] _3775_ _3778_ u_register_bank.sensor_enable\[8\]
+ VGND VGND VPWR VPWR _3805_ sky130_fd_sc_hd__a22o_1
X_4885_ _1926_ VGND VGND VPWR VPWR _0336_ sky130_fd_sc_hd__clkbuf_1
XFILLER_0_46_235 VGND VGND VPWR VPWR sky130_fd_sc_hd__fill_1
XFILLER_0_46_268 VGND VGND VPWR VPWR sky130_fd_sc_hd__fill_1
XFILLER_0_6_343 VGND VGND VPWR VPWR sky130_fd_sc_hd__decap_4
XFILLER_0_6_321 VGND VGND VPWR VPWR sky130_fd_sc_hd__decap_8
X_6624_ _2861_ _2880_ _2882_ VGND VGND VPWR VPWR _2884_ sky130_fd_sc_hd__a21oi_1
XFILLER_0_104_307 VGND VGND VPWR VPWR sky130_fd_sc_hd__fill_1
XFILLER_0_15_655 VGND VGND VPWR VPWR sky130_fd_sc_hd__fill_1
X_6555_ _1910_ _2567_ VGND VGND VPWR VPWR _2842_ sky130_fd_sc_hd__nor2_2
X_5506_ _1468_ VGND VGND VPWR VPWR _2274_ sky130_fd_sc_hd__buf_2
XFILLER_0_42_474 VGND VGND VPWR VPWR sky130_fd_sc_hd__fill_2
X_8225_ clknet_leaf_17_clk _0314_ VGND VGND VPWR VPWR u_input_buffer.fifo_mem\[49\]\[7\]
+ sky130_fd_sc_hd__dfxtp_1
X_6486_ _2805_ VGND VGND VPWR VPWR _1058_ sky130_fd_sc_hd__clkbuf_1
X_5437_ net1071 _2002_ _2223_ VGND VGND VPWR VPWR _2230_ sky130_fd_sc_hd__mux2_1
X_5368_ _2193_ VGND VGND VPWR VPWR _0552_ sky130_fd_sc_hd__clkbuf_1
X_8156_ clknet_leaf_3_clk _0245_ VGND VGND VPWR VPWR u_input_buffer.fifo_mem\[53\]\[2\]
+ sky130_fd_sc_hd__dfxtp_1
X_5299_ net1215 _2000_ _2151_ VGND VGND VPWR VPWR _2157_ sky130_fd_sc_hd__mux2_1
X_7107_ u_input_buffer.fifo_mem\[63\]\[7\] _2887_ _3076_ u_input_buffer.fifo_mem\[55\]\[7\]
+ _3351_ VGND VGND VPWR VPWR _3352_ sky130_fd_sc_hd__a221o_1
X_8087_ clknet_leaf_85_clk _0176_ VGND VGND VPWR VPWR u_input_buffer.fifo_mem\[58\]\[13\]
+ sky130_fd_sc_hd__dfxtp_1
X_4319_ u_input_buffer.wr_ptr\[2\] VGND VGND VPWR VPWR _1598_ sky130_fd_sc_hd__buf_2
X_7038_ u_input_buffer.fifo_mem\[53\]\[6\] _2934_ _2936_ u_input_buffer.fifo_mem\[57\]\[6\]
+ VGND VGND VPWR VPWR _3284_ sky130_fd_sc_hd__a22o_1
XFILLER_0_69_305 VGND VGND VPWR VPWR sky130_fd_sc_hd__fill_2
XTAP_1003 VGND VPWR sky130_fd_sc_hd__tapvpwrvgnd_1
X_8989_ clknet_leaf_3_clk _1078_ VGND VGND VPWR VPWR u_input_buffer.fifo_mem\[1\]\[3\]
+ sky130_fd_sc_hd__dfxtp_1
XTAP_1047 VGND VPWR sky130_fd_sc_hd__tapvpwrvgnd_1
XTAP_1036 VGND VPWR sky130_fd_sc_hd__tapvpwrvgnd_1
XFILLER_0_65_500 VGND VGND VPWR VPWR sky130_fd_sc_hd__decap_4
XTAP_1025 VGND VPWR sky130_fd_sc_hd__tapvpwrvgnd_1
XTAP_1014 VGND VPWR sky130_fd_sc_hd__tapvpwrvgnd_1
XTAP_1069 VGND VPWR sky130_fd_sc_hd__tapvpwrvgnd_1
XTAP_1058 VGND VPWR sky130_fd_sc_hd__tapvpwrvgnd_1
XFILLER_0_92_363 VGND VGND VPWR VPWR sky130_fd_sc_hd__fill_1
XFILLER_0_18_471 VGND VGND VPWR VPWR sky130_fd_sc_hd__decap_4
XFILLER_0_107_167 VGND VGND VPWR VPWR sky130_fd_sc_hd__fill_1
XTAP_809 VGND VPWR sky130_fd_sc_hd__tapvpwrvgnd_1
XFILLER_0_88_636 VGND VGND VPWR VPWR sky130_fd_sc_hd__fill_2
XFILLER_0_87_146 VGND VGND VPWR VPWR sky130_fd_sc_hd__fill_1
XFILLER_0_87_113 VGND VGND VPWR VPWR sky130_fd_sc_hd__fill_2
XTAP_1592 VGND VPWR sky130_fd_sc_hd__tapvpwrvgnd_1
XTAP_1581 VGND VPWR sky130_fd_sc_hd__tapvpwrvgnd_1
XTAP_1570 VGND VPWR sky130_fd_sc_hd__tapvpwrvgnd_1
XFILLER_0_7_129 VGND VGND VPWR VPWR sky130_fd_sc_hd__decap_6
X_4670_ net998 _1726_ _1797_ VGND VGND VPWR VPWR _1810_ sky130_fd_sc_hd__mux2_1
XFILLER_0_113_137 VPWR VGND VPWR VGND sky130_ef_sc_hd__decap_12
XFILLER_0_24_452 VGND VGND VPWR VPWR sky130_fd_sc_hd__decap_8
X_6340_ _2728_ VGND VGND VPWR VPWR _0989_ sky130_fd_sc_hd__clkbuf_1
XFILLER_0_11_113 VGND VGND VPWR VPWR sky130_fd_sc_hd__fill_1
X_6271_ _2691_ VGND VGND VPWR VPWR _0957_ sky130_fd_sc_hd__clkbuf_1
X_5222_ _2116_ VGND VGND VPWR VPWR _0483_ sky130_fd_sc_hd__clkbuf_1
X_8010_ clknet_leaf_44_clk _0099_ VGND VGND VPWR VPWR u_input_buffer.fifo_mem\[62\]\[0\]
+ sky130_fd_sc_hd__dfxtp_1
XFILLER_0_11_179 VGND VGND VPWR VPWR sky130_fd_sc_hd__decap_6
X_5153_ _2079_ VGND VGND VPWR VPWR _0451_ sky130_fd_sc_hd__clkbuf_1
X_4104_ _1421_ _1424_ _0000_ VGND VGND VPWR VPWR _1425_ sky130_fd_sc_hd__mux2_1
X_5084_ net535 _1988_ _2042_ VGND VGND VPWR VPWR _2043_ sky130_fd_sc_hd__mux2_1
X_4035_ _1369_ VGND VGND VPWR VPWR _0043_ sky130_fd_sc_hd__clkbuf_1
X_8912_ clknet_leaf_52_clk _1001_ VGND VGND VPWR VPWR u_input_buffer.fifo_mem\[6\]\[6\]
+ sky130_fd_sc_hd__dfxtp_1
XFILLER_0_79_614 VGND VGND VPWR VPWR sky130_fd_sc_hd__fill_2
X_8843_ clknet_leaf_35_clk _0932_ VGND VGND VPWR VPWR u_input_buffer.fifo_mem\[10\]\[1\]
+ sky130_fd_sc_hd__dfxtp_1
XFILLER_0_2_53 VPWR VGND VPWR VGND sky130_ef_sc_hd__decap_12
XFILLER_0_94_639 VGND VGND VPWR VPWR sky130_fd_sc_hd__decap_4
XFILLER_0_93_116 VGND VGND VPWR VPWR sky130_fd_sc_hd__fill_2
XPHY_119 VGND VGND VPWR VPWR sky130_fd_sc_hd__decap_3
X_5986_ _2538_ VGND VGND VPWR VPWR _0825_ sky130_fd_sc_hd__clkbuf_1
X_8774_ clknet_leaf_96_clk _0863_ VGND VGND VPWR VPWR u_input_buffer.fifo_mem\[15\]\[12\]
+ sky130_fd_sc_hd__dfxtp_1
XPHY_108 VGND VGND VPWR VPWR sky130_fd_sc_hd__decap_3
XFILLER_0_93_149 VGND VGND VPWR VPWR sky130_fd_sc_hd__fill_1
XFILLER_0_74_330 VGND VGND VPWR VPWR sky130_fd_sc_hd__fill_2
X_4937_ _1956_ VGND VGND VPWR VPWR _0358_ sky130_fd_sc_hd__clkbuf_1
X_7725_ _3845_ net124 _3817_ VGND VGND VPWR VPWR _3846_ sky130_fd_sc_hd__mux2_1
X_4868_ net906 _1714_ _1912_ VGND VGND VPWR VPWR _1918_ sky130_fd_sc_hd__mux2_1
XFILLER_0_74_363 VGND VGND VPWR VPWR sky130_fd_sc_hd__fill_1
XFILLER_0_62_525 VGND VGND VPWR VPWR sky130_fd_sc_hd__decap_6
XFILLER_0_7_641 VPWR VGND VPWR VGND sky130_ef_sc_hd__decap_12
XANTENNA_31 net71 VGND VGND VPWR VPWR sky130_fd_sc_hd__diode_2
XANTENNA_20 net19 VGND VGND VPWR VPWR sky130_fd_sc_hd__diode_2
X_7656_ _3792_ VGND VGND VPWR VPWR _1241_ sky130_fd_sc_hd__clkbuf_1
XANTENNA_53 u_sensor_interface.sensor_array\[2\]\[4\] VGND VGND VPWR VPWR sky130_fd_sc_hd__diode_2
XFILLER_0_7_685 VGND VGND VPWR VPWR sky130_fd_sc_hd__fill_1
X_6607_ _2871_ VGND VGND VPWR VPWR _1113_ sky130_fd_sc_hd__clkbuf_1
XANTENNA_42 _2528_ VGND VGND VPWR VPWR sky130_fd_sc_hd__diode_2
X_4799_ _1880_ VGND VGND VPWR VPWR _0296_ sky130_fd_sc_hd__clkbuf_1
X_7587_ net13 u_analytics_engine.threshold\[10\] _3748_ VGND VGND VPWR VPWR _3749_
+ sky130_fd_sc_hd__mux2_1
X_6538_ _2833_ VGND VGND VPWR VPWR _1082_ sky130_fd_sc_hd__clkbuf_1
XFILLER_0_113_671 VGND VGND VPWR VPWR sky130_fd_sc_hd__fill_1
X_6469_ net779 _1420_ _2789_ VGND VGND VPWR VPWR _2797_ sky130_fd_sc_hd__mux2_1
XFILLER_0_100_321 VGND VGND VPWR VPWR sky130_fd_sc_hd__fill_1
X_8208_ clknet_leaf_36_clk _0297_ VGND VGND VPWR VPWR u_input_buffer.fifo_mem\[50\]\[6\]
+ sky130_fd_sc_hd__dfxtp_1
X_9188_ clknet_leaf_86_clk _1276_ net189 VGND VGND VPWR VPWR net160 sky130_fd_sc_hd__dfrtp_1
Xoutput160 net160 VGND VGND VPWR VPWR processed_data_out[6] sky130_fd_sc_hd__clkbuf_4
XFILLER_0_100_365 VGND VGND VPWR VPWR sky130_fd_sc_hd__fill_2
X_8139_ clknet_leaf_36_clk _0228_ VGND VGND VPWR VPWR u_input_buffer.fifo_mem\[54\]\[1\]
+ sky130_fd_sc_hd__dfxtp_1
XFILLER_0_69_113 VGND VGND VPWR VPWR sky130_fd_sc_hd__fill_1
XFILLER_0_85_606 VGND VGND VPWR VPWR sky130_fd_sc_hd__fill_2
XFILLER_0_57_319 VGND VGND VPWR VPWR sky130_fd_sc_hd__decap_3
XFILLER_0_38_533 VGND VGND VPWR VPWR sky130_fd_sc_hd__fill_2
XFILLER_0_108_421 VGND VGND VPWR VPWR sky130_fd_sc_hd__fill_2
XFILLER_0_53_503 VGND VGND VPWR VPWR sky130_fd_sc_hd__fill_1
XFILLER_0_104_9 VPWR VGND VPWR VGND sky130_ef_sc_hd__decap_12
XFILLER_0_111_608 VGND VGND VPWR VPWR sky130_fd_sc_hd__decap_8
XFILLER_0_0_349 VGND VGND VPWR VPWR sky130_fd_sc_hd__decap_8
XTAP_606 VGND VPWR sky130_fd_sc_hd__tapvpwrvgnd_1
XTAP_617 VGND VPWR sky130_fd_sc_hd__tapvpwrvgnd_1
XTAP_628 VGND VPWR sky130_fd_sc_hd__tapvpwrvgnd_1
XTAP_639 VGND VPWR sky130_fd_sc_hd__tapvpwrvgnd_1
XFILLER_0_84_27 VGND VGND VPWR VPWR sky130_fd_sc_hd__fill_1
XFILLER_0_88_400 VGND VGND VPWR VPWR sky130_fd_sc_hd__fill_2
XFILLER_0_17_54 VGND VGND VPWR VPWR sky130_fd_sc_hd__fill_2
X_5840_ _2453_ VGND VGND VPWR VPWR _0764_ sky130_fd_sc_hd__clkbuf_1
X_5771_ net433 _2262_ _2407_ VGND VGND VPWR VPWR _2417_ sky130_fd_sc_hd__mux2_1
XFILLER_0_29_544 VGND VGND VPWR VPWR sky130_fd_sc_hd__fill_1
X_4722_ net337 _1708_ _1836_ VGND VGND VPWR VPWR _1839_ sky130_fd_sc_hd__mux2_1
X_7510_ _3707_ VGND VGND VPWR VPWR _1180_ sky130_fd_sc_hd__clkbuf_1
X_8490_ clknet_leaf_26_clk _0579_ VGND VGND VPWR VPWR u_input_buffer.fifo_mem\[32\]\[0\]
+ sky130_fd_sc_hd__dfxtp_1
XFILLER_0_90_119 VGND VGND VPWR VPWR sky130_fd_sc_hd__decap_4
XFILLER_0_56_363 VGND VGND VPWR VPWR sky130_fd_sc_hd__fill_1
XFILLER_0_16_205 VGND VGND VPWR VPWR sky130_fd_sc_hd__decap_3
X_7441_ net326 net97 _3662_ VGND VGND VPWR VPWR _3669_ sky130_fd_sc_hd__mux2_1
Xinput40 cfg_wdata[6] VGND VGND VPWR VPWR net40 sky130_fd_sc_hd__buf_2
X_4653_ _1801_ VGND VGND VPWR VPWR _0229_ sky130_fd_sc_hd__clkbuf_1
Xinput51 sensor_data_in[14] VGND VGND VPWR VPWR net51 sky130_fd_sc_hd__clkbuf_1
X_4584_ _1762_ VGND VGND VPWR VPWR _0199_ sky130_fd_sc_hd__clkbuf_1
Xinput73 sensor_data_in[34] VGND VGND VPWR VPWR net73 sky130_fd_sc_hd__clkbuf_1
Xhold802 u_input_buffer.fifo_mem\[11\]\[3\] VGND VGND VPWR VPWR net1014 sky130_fd_sc_hd__dlygate4sd3_1
X_7372_ _3603_ _3605_ _3607_ _3609_ VGND VGND VPWR VPWR _3610_ sky130_fd_sc_hd__or4_1
Xinput62 sensor_data_in[24] VGND VGND VPWR VPWR net62 sky130_fd_sc_hd__clkbuf_2
Xinput95 sensor_data_in[54] VGND VGND VPWR VPWR net95 sky130_fd_sc_hd__buf_1
Xinput84 sensor_data_in[44] VGND VGND VPWR VPWR net84 sky130_fd_sc_hd__clkbuf_1
X_6323_ net1185 _2502_ _2717_ VGND VGND VPWR VPWR _2720_ sky130_fd_sc_hd__mux2_1
Xhold846 u_sensor_interface.sensor_array\[2\]\[1\] VGND VGND VPWR VPWR net1058 sky130_fd_sc_hd__dlygate4sd3_1
X_9111_ net178 _1199_ net209 VGND VGND VPWR VPWR u_register_bank.window_cfg\[25\]
+ sky130_fd_sc_hd__dfrtp_1
Xhold835 u_input_buffer.fifo_mem\[37\]\[9\] VGND VGND VPWR VPWR net1047 sky130_fd_sc_hd__dlygate4sd3_1
Xhold813 u_input_buffer.fifo_mem\[56\]\[9\] VGND VGND VPWR VPWR net1025 sky130_fd_sc_hd__dlygate4sd3_1
Xhold824 u_input_buffer.fifo_mem\[44\]\[11\] VGND VGND VPWR VPWR net1036 sky130_fd_sc_hd__dlygate4sd3_1
X_9042_ clknet_leaf_47_clk _1131_ VGND VGND VPWR VPWR u_analytics_engine.data_in\[5\]
+ sky130_fd_sc_hd__dfxtp_1
Xhold857 u_input_buffer.fifo_mem\[27\]\[1\] VGND VGND VPWR VPWR net1069 sky130_fd_sc_hd__dlygate4sd3_1
Xhold868 u_input_buffer.fifo_mem\[59\]\[4\] VGND VGND VPWR VPWR net1080 sky130_fd_sc_hd__dlygate4sd3_1
X_6254_ _1606_ net1033 _2680_ VGND VGND VPWR VPWR _2683_ sky130_fd_sc_hd__mux2_1
Xhold879 u_input_buffer.fifo_mem\[31\]\[3\] VGND VGND VPWR VPWR net1091 sky130_fd_sc_hd__dlygate4sd3_1
XFILLER_0_110_685 VGND VGND VPWR VPWR sky130_fd_sc_hd__fill_1
X_5205_ net758 _2008_ _2097_ VGND VGND VPWR VPWR _2107_ sky130_fd_sc_hd__mux2_1
X_6185_ _2646_ VGND VGND VPWR VPWR _0916_ sky130_fd_sc_hd__clkbuf_1
X_5136_ _1433_ net1213 _2060_ VGND VGND VPWR VPWR _2070_ sky130_fd_sc_hd__mux2_1
X_5067_ _2033_ VGND VGND VPWR VPWR _0411_ sky130_fd_sc_hd__clkbuf_1
X_4018_ _1360_ VGND VGND VPWR VPWR _0035_ sky130_fd_sc_hd__clkbuf_1
X_8826_ clknet_leaf_37_clk _0915_ VGND VGND VPWR VPWR u_input_buffer.fifo_mem\[11\]\[0\]
+ sky130_fd_sc_hd__dfxtp_1
XFILLER_0_94_458 VGND VGND VPWR VPWR sky130_fd_sc_hd__decap_4
XFILLER_0_90_70 VGND VGND VPWR VPWR sky130_fd_sc_hd__decap_6
XFILLER_0_66_149 VGND VGND VPWR VPWR sky130_fd_sc_hd__decap_6
X_8757_ clknet_leaf_107_clk _0846_ VGND VGND VPWR VPWR u_input_buffer.fifo_mem\[16\]\[11\]
+ sky130_fd_sc_hd__dfxtp_1
X_5969_ net409 _2528_ _2497_ VGND VGND VPWR VPWR _2529_ sky130_fd_sc_hd__mux2_1
X_7708_ _3832_ net120 _3817_ VGND VGND VPWR VPWR _3833_ sky130_fd_sc_hd__mux2_1
XFILLER_0_35_503 VGND VGND VPWR VPWR sky130_fd_sc_hd__fill_1
X_8688_ clknet_leaf_47_clk _0777_ VGND VGND VPWR VPWR u_input_buffer.fifo_mem\[20\]\[6\]
+ sky130_fd_sc_hd__dfxtp_1
X_7639_ u_register_bank.status_flags\[0\] _3775_ _3778_ u_register_bank.sensor_enable\[0\]
+ VGND VGND VPWR VPWR _3779_ sky130_fd_sc_hd__a22o_1
XFILLER_0_105_446 VGND VGND VPWR VPWR sky130_fd_sc_hd__fill_2
XFILLER_0_62_399 VGND VGND VPWR VPWR sky130_fd_sc_hd__fill_1
XFILLER_0_43_591 VGND VGND VPWR VPWR sky130_fd_sc_hd__fill_2
XFILLER_0_101_685 VGND VGND VPWR VPWR sky130_fd_sc_hd__fill_1
XFILLER_0_58_639 VGND VGND VPWR VPWR sky130_fd_sc_hd__decap_4
XFILLER_0_26_525 VGND VGND VPWR VPWR sky130_fd_sc_hd__decap_4
XFILLER_0_53_322 VGND VGND VPWR VPWR sky130_fd_sc_hd__fill_2
XFILLER_0_108_273 VGND VGND VPWR VPWR sky130_fd_sc_hd__decap_3
XFILLER_0_81_653 VGND VGND VPWR VPWR sky130_fd_sc_hd__fill_1
XFILLER_0_80_141 VGND VGND VPWR VPWR sky130_fd_sc_hd__fill_1
Xhold109 u_input_buffer.fifo_mem\[18\]\[5\] VGND VGND VPWR VPWR net321 sky130_fd_sc_hd__dlygate4sd3_1
XFILLER_0_21_263 VGND VGND VPWR VPWR sky130_fd_sc_hd__fill_1
XFILLER_0_95_15 VPWR VGND VPWR VGND sky130_ef_sc_hd__decap_12
XTAP_403 VGND VPWR sky130_fd_sc_hd__tapvpwrvgnd_1
XTAP_414 VGND VPWR sky130_fd_sc_hd__tapvpwrvgnd_1
XTAP_425 VGND VPWR sky130_fd_sc_hd__tapvpwrvgnd_1
XTAP_436 VGND VPWR sky130_fd_sc_hd__tapvpwrvgnd_1
XTAP_447 VGND VPWR sky130_fd_sc_hd__tapvpwrvgnd_1
XTAP_458 VGND VPWR sky130_fd_sc_hd__tapvpwrvgnd_1
XTAP_469 VGND VPWR sky130_fd_sc_hd__tapvpwrvgnd_1
X_7990_ clknet_leaf_82_clk _0079_ net187 VGND VGND VPWR VPWR u_sample_counter.sample_count\[13\]
+ sky130_fd_sc_hd__dfrtp_1
X_6941_ u_input_buffer.fifo_mem\[52\]\[3\] _3039_ _3041_ u_input_buffer.fifo_mem\[56\]\[3\]
+ VGND VGND VPWR VPWR _3190_ sky130_fd_sc_hd__a22o_1
X_6872_ u_input_buffer.fifo_mem\[54\]\[1\] _3078_ _3080_ u_input_buffer.fifo_mem\[46\]\[1\]
+ VGND VGND VPWR VPWR _3123_ sky130_fd_sc_hd__a22o_1
XFILLER_0_44_74 VGND VGND VPWR VPWR sky130_fd_sc_hd__fill_1
XFILLER_0_49_617 VGND VGND VPWR VPWR sky130_fd_sc_hd__decap_4
X_5823_ _1604_ net1196 _2443_ VGND VGND VPWR VPWR _2445_ sky130_fd_sc_hd__mux2_1
X_8611_ clknet_leaf_5_clk _0700_ VGND VGND VPWR VPWR u_input_buffer.fifo_mem\[25\]\[9\]
+ sky130_fd_sc_hd__dfxtp_1
X_8542_ clknet_leaf_2_clk _0631_ VGND VGND VPWR VPWR u_input_buffer.fifo_mem\[29\]\[4\]
+ sky130_fd_sc_hd__dfxtp_1
X_5754_ _2408_ VGND VGND VPWR VPWR _0723_ sky130_fd_sc_hd__clkbuf_1
XFILLER_0_60_73 VGND VGND VPWR VPWR sky130_fd_sc_hd__fill_1
X_4705_ _1445_ net1216 _1816_ VGND VGND VPWR VPWR _1829_ sky130_fd_sc_hd__mux2_1
X_8473_ clknet_leaf_98_clk _0562_ VGND VGND VPWR VPWR u_input_buffer.fifo_mem\[34\]\[15\]
+ sky130_fd_sc_hd__dfxtp_1
X_5685_ _2371_ VGND VGND VPWR VPWR _0691_ sky130_fd_sc_hd__clkbuf_1
XFILLER_0_114_221 VPWR VGND VPWR VGND sky130_ef_sc_hd__decap_12
X_7424_ net269 net88 _1367_ VGND VGND VPWR VPWR _3660_ sky130_fd_sc_hd__mux2_1
XFILLER_0_8_41 VPWR VGND VPWR VGND sky130_ef_sc_hd__decap_12
XFILLER_0_4_452 VPWR VGND VPWR VGND sky130_ef_sc_hd__decap_12
X_4636_ net498 _1728_ _1777_ VGND VGND VPWR VPWR _1791_ sky130_fd_sc_hd__mux2_1
XFILLER_0_32_528 VGND VGND VPWR VPWR sky130_fd_sc_hd__decap_4
Xhold621 u_input_buffer.fifo_mem\[10\]\[6\] VGND VGND VPWR VPWR net833 sky130_fd_sc_hd__dlygate4sd3_1
Xhold610 u_input_buffer.fifo_mem\[27\]\[0\] VGND VGND VPWR VPWR net822 sky130_fd_sc_hd__dlygate4sd3_1
XFILLER_0_8_63 VGND VGND VPWR VPWR sky130_fd_sc_hd__fill_1
X_7355_ u_input_buffer.fifo_mem\[36\]\[14\] _2950_ _2954_ u_input_buffer.fifo_mem\[35\]\[14\]
+ _3592_ VGND VGND VPWR VPWR _3593_ sky130_fd_sc_hd__a221o_1
Xhold654 u_input_buffer.fifo_mem\[8\]\[3\] VGND VGND VPWR VPWR net866 sky130_fd_sc_hd__dlygate4sd3_1
X_4567_ _1752_ VGND VGND VPWR VPWR _0192_ sky130_fd_sc_hd__clkbuf_1
XFILLER_0_8_85 VGND VGND VPWR VPWR sky130_fd_sc_hd__decap_6
Xhold632 u_input_buffer.fifo_mem\[55\]\[11\] VGND VGND VPWR VPWR net844 sky130_fd_sc_hd__dlygate4sd3_1
Xhold643 u_input_buffer.fifo_mem\[45\]\[11\] VGND VGND VPWR VPWR net855 sky130_fd_sc_hd__dlygate4sd3_1
X_6306_ net928 _2520_ _2697_ VGND VGND VPWR VPWR _2710_ sky130_fd_sc_hd__mux2_1
X_4498_ _1396_ VGND VGND VPWR VPWR _1710_ sky130_fd_sc_hd__clkbuf_4
Xhold676 u_input_buffer.fifo_mem\[39\]\[10\] VGND VGND VPWR VPWR net888 sky130_fd_sc_hd__dlygate4sd3_1
Xhold687 u_input_buffer.fifo_mem\[1\]\[14\] VGND VGND VPWR VPWR net899 sky130_fd_sc_hd__dlygate4sd3_1
Xhold665 u_input_buffer.fifo_mem\[17\]\[10\] VGND VGND VPWR VPWR net877 sky130_fd_sc_hd__dlygate4sd3_1
X_7286_ u_input_buffer.fifo_mem\[47\]\[12\] _2879_ _2917_ _3008_ u_input_buffer.fifo_mem\[24\]\[12\]
+ VGND VGND VPWR VPWR _3526_ sky130_fd_sc_hd__a32o_1
X_6237_ _2673_ VGND VGND VPWR VPWR _0941_ sky130_fd_sc_hd__clkbuf_1
Xhold698 u_input_buffer.fifo_mem\[26\]\[13\] VGND VGND VPWR VPWR net910 sky130_fd_sc_hd__dlygate4sd3_1
X_9025_ clknet_leaf_94_clk _1114_ net185 VGND VGND VPWR VPWR u_input_buffer.rd_ptr\[0\]
+ sky130_fd_sc_hd__dfrtp_4
XTAP_970 VGND VPWR sky130_fd_sc_hd__tapvpwrvgnd_1
X_6168_ _2636_ VGND VGND VPWR VPWR _0909_ sky130_fd_sc_hd__clkbuf_1
X_5119_ _2061_ VGND VGND VPWR VPWR _0435_ sky130_fd_sc_hd__clkbuf_1
XTAP_992 VGND VPWR sky130_fd_sc_hd__tapvpwrvgnd_1
XTAP_981 VGND VPWR sky130_fd_sc_hd__tapvpwrvgnd_1
X_6099_ net395 _2520_ _2586_ VGND VGND VPWR VPWR _2599_ sky130_fd_sc_hd__mux2_1
XFILLER_0_67_447 VGND VGND VPWR VPWR sky130_fd_sc_hd__fill_1
X_8809_ clknet_leaf_104_clk _0898_ VGND VGND VPWR VPWR u_input_buffer.fifo_mem\[13\]\[15\]
+ sky130_fd_sc_hd__dfxtp_1
XFILLER_0_48_650 VGND VGND VPWR VPWR sky130_fd_sc_hd__decap_8
XFILLER_0_90_472 VGND VGND VPWR VPWR sky130_fd_sc_hd__decap_4
XFILLER_0_62_152 VGND VGND VPWR VPWR sky130_fd_sc_hd__fill_2
XFILLER_0_98_583 VGND VGND VPWR VPWR sky130_fd_sc_hd__fill_2
XFILLER_0_105_57 VPWR VGND VPWR VGND sky130_ef_sc_hd__decap_12
XFILLER_0_73_439 VGND VGND VPWR VPWR sky130_fd_sc_hd__fill_1
XFILLER_0_26_300 VGND VGND VPWR VPWR sky130_fd_sc_hd__fill_1
XFILLER_0_54_642 VGND VGND VPWR VPWR sky130_fd_sc_hd__fill_2
X_5470_ _1396_ VGND VGND VPWR VPWR _2250_ sky130_fd_sc_hd__clkbuf_4
XFILLER_0_30_54 VGND VGND VPWR VPWR sky130_fd_sc_hd__fill_1
XFILLER_0_76_9 VGND VGND VPWR VPWR sky130_fd_sc_hd__fill_2
X_4421_ net320 _1608_ _1661_ VGND VGND VPWR VPWR _1665_ sky130_fd_sc_hd__mux2_1
XFILLER_0_53_185 VGND VGND VPWR VPWR sky130_fd_sc_hd__fill_1
X_7140_ u_input_buffer.fifo_mem\[23\]\[8\] _3046_ _3048_ u_input_buffer.fifo_mem\[20\]\[8\]
+ _3383_ VGND VGND VPWR VPWR _3384_ sky130_fd_sc_hd__a221o_1
X_4352_ _1621_ VGND VGND VPWR VPWR _0108_ sky130_fd_sc_hd__clkbuf_1
X_4283_ u_analytics_engine.data_in\[5\] VGND VGND VPWR VPWR _1563_ sky130_fd_sc_hd__inv_2
X_7071_ net263 _3086_ _3088_ VGND VGND VPWR VPWR _3317_ sky130_fd_sc_hd__o21a_1
XTAP_233 VGND VPWR sky130_fd_sc_hd__tapvpwrvgnd_1
X_6022_ _2557_ VGND VGND VPWR VPWR _0842_ sky130_fd_sc_hd__clkbuf_1
XTAP_244 VGND VPWR sky130_fd_sc_hd__tapvpwrvgnd_1
XTAP_266 VGND VPWR sky130_fd_sc_hd__tapvpwrvgnd_1
XTAP_255 VGND VPWR sky130_fd_sc_hd__tapvpwrvgnd_1
XTAP_299 VGND VPWR sky130_fd_sc_hd__tapvpwrvgnd_1
XTAP_288 VGND VPWR sky130_fd_sc_hd__tapvpwrvgnd_1
XTAP_277 VGND VPWR sky130_fd_sc_hd__tapvpwrvgnd_1
X_7973_ clknet_leaf_109_clk _0063_ net184 VGND VGND VPWR VPWR u_input_buffer.data_in\[13\]
+ sky130_fd_sc_hd__dfrtp_1
X_6924_ u_input_buffer.fifo_mem\[1\]\[3\] _2932_ _3170_ _3172_ VGND VGND VPWR VPWR
+ _3173_ sky130_fd_sc_hd__a211o_1
X_6855_ _3099_ _3101_ _3103_ _3105_ VGND VGND VPWR VPWR _3106_ sky130_fd_sc_hd__or4_1
X_3998_ net503 net62 _1345_ VGND VGND VPWR VPWR _1350_ sky130_fd_sc_hd__mux2_1
XFILLER_0_71_94 VGND VGND VPWR VPWR sky130_fd_sc_hd__decap_4
X_5806_ _2435_ VGND VGND VPWR VPWR _0748_ sky130_fd_sc_hd__clkbuf_1
XFILLER_0_17_300 VGND VGND VPWR VPWR sky130_fd_sc_hd__fill_1
XFILLER_0_17_322 VGND VGND VPWR VPWR sky130_fd_sc_hd__decap_6
X_6786_ _2900_ _2949_ VGND VGND VPWR VPWR _3038_ sky130_fd_sc_hd__nor2_2
X_8525_ clknet_leaf_66_clk _0614_ VGND VGND VPWR VPWR u_input_buffer.fifo_mem\[30\]\[3\]
+ sky130_fd_sc_hd__dfxtp_1
X_5737_ _2398_ VGND VGND VPWR VPWR _0716_ sky130_fd_sc_hd__clkbuf_1
XFILLER_0_115_541 VGND VGND VPWR VPWR sky130_fd_sc_hd__fill_1
XFILLER_0_17_388 VGND VGND VPWR VPWR sky130_fd_sc_hd__decap_4
X_8456_ clknet_leaf_12_clk _0545_ VGND VGND VPWR VPWR u_input_buffer.fifo_mem\[35\]\[14\]
+ sky130_fd_sc_hd__dfxtp_1
XFILLER_0_115_574 VGND VGND VPWR VPWR sky130_fd_sc_hd__decap_3
X_5668_ net1134 _2262_ _2352_ VGND VGND VPWR VPWR _2362_ sky130_fd_sc_hd__mux2_1
XFILLER_0_60_645 VGND VGND VPWR VPWR sky130_fd_sc_hd__decap_8
X_7407_ u_input_buffer.fifo_mem\[30\]\[15\] _3028_ _3030_ u_input_buffer.fifo_mem\[58\]\[15\]
+ VGND VGND VPWR VPWR _3644_ sky130_fd_sc_hd__a22o_1
X_8387_ clknet_leaf_52_clk _0476_ VGND VGND VPWR VPWR u_input_buffer.fifo_mem\[39\]\[9\]
+ sky130_fd_sc_hd__dfxtp_1
X_4619_ _1782_ VGND VGND VPWR VPWR _0214_ sky130_fd_sc_hd__clkbuf_1
X_5599_ net399 _2262_ _2315_ VGND VGND VPWR VPWR _2325_ sky130_fd_sc_hd__mux2_1
XFILLER_0_13_561 VPWR VGND VPWR VGND sky130_ef_sc_hd__decap_12
Xhold462 u_input_buffer.fifo_mem\[10\]\[9\] VGND VGND VPWR VPWR net674 sky130_fd_sc_hd__dlygate4sd3_1
X_7338_ u_input_buffer.fifo_mem\[3\]\[13\] _3069_ _3071_ u_input_buffer.fifo_mem\[60\]\[13\]
+ VGND VGND VPWR VPWR _3577_ sky130_fd_sc_hd__a22o_1
Xhold440 u_input_buffer.fifo_mem\[40\]\[11\] VGND VGND VPWR VPWR net652 sky130_fd_sc_hd__dlygate4sd3_1
Xhold451 u_input_buffer.fifo_mem\[53\]\[3\] VGND VGND VPWR VPWR net663 sky130_fd_sc_hd__dlygate4sd3_1
Xhold495 u_input_buffer.fifo_mem\[28\]\[1\] VGND VGND VPWR VPWR net707 sky130_fd_sc_hd__dlygate4sd3_1
Xhold473 u_input_buffer.fifo_mem\[14\]\[4\] VGND VGND VPWR VPWR net685 sky130_fd_sc_hd__dlygate4sd3_1
Xhold484 u_input_buffer.fifo_mem\[58\]\[5\] VGND VGND VPWR VPWR net696 sky130_fd_sc_hd__dlygate4sd3_1
X_7269_ u_input_buffer.fifo_mem\[33\]\[12\] _2897_ _2903_ u_input_buffer.fifo_mem\[61\]\[12\]
+ _3508_ VGND VGND VPWR VPWR _3509_ sky130_fd_sc_hd__a221o_1
X_9008_ clknet_leaf_47_clk _1097_ VGND VGND VPWR VPWR u_input_buffer.fifo_mem\[0\]\[6\]
+ sky130_fd_sc_hd__dfxtp_1
XFILLER_0_50_188 VGND VGND VPWR VPWR sky130_fd_sc_hd__fill_1
XFILLER_0_92_27 VGND VGND VPWR VPWR sky130_fd_sc_hd__fill_1
X_4970_ _1974_ VGND VGND VPWR VPWR _0373_ sky130_fd_sc_hd__clkbuf_1
XFILLER_0_25_87 VGND VGND VPWR VPWR sky130_fd_sc_hd__decap_4
XFILLER_0_86_597 VGND VGND VPWR VPWR sky130_fd_sc_hd__fill_2
XFILLER_0_86_586 VGND VGND VPWR VPWR sky130_fd_sc_hd__fill_2
X_6640_ net192 _2860_ VGND VGND VPWR VPWR _2892_ sky130_fd_sc_hd__nand2_2
X_6571_ net249 _1420_ _2843_ VGND VGND VPWR VPWR _2851_ sky130_fd_sc_hd__mux2_1
X_5522_ _2283_ VGND VGND VPWR VPWR _0616_ sky130_fd_sc_hd__clkbuf_1
XFILLER_0_6_569 VGND VGND VPWR VPWR sky130_fd_sc_hd__decap_6
X_8310_ clknet_leaf_71_clk _0399_ VGND VGND VPWR VPWR u_input_buffer.fifo_mem\[44\]\[12\]
+ sky130_fd_sc_hd__dfxtp_1
XFILLER_0_112_511 VGND VGND VPWR VPWR sky130_fd_sc_hd__decap_8
X_8241_ clknet_leaf_38_clk _0330_ VGND VGND VPWR VPWR u_input_buffer.fifo_mem\[48\]\[7\]
+ sky130_fd_sc_hd__dfxtp_1
X_5453_ net360 _2018_ _2222_ VGND VGND VPWR VPWR _2238_ sky130_fd_sc_hd__mux2_1
X_8172_ clknet_leaf_56_clk _0261_ VGND VGND VPWR VPWR u_input_buffer.fifo_mem\[52\]\[2\]
+ sky130_fd_sc_hd__dfxtp_1
X_4404_ _1654_ VGND VGND VPWR VPWR _0127_ sky130_fd_sc_hd__clkbuf_1
X_5384_ _2201_ VGND VGND VPWR VPWR _0560_ sky130_fd_sc_hd__clkbuf_1
XFILLER_0_41_199 VGND VGND VPWR VPWR sky130_fd_sc_hd__fill_1
X_4335_ u_input_buffer.data_in\[4\] VGND VGND VPWR VPWR _1610_ sky130_fd_sc_hd__buf_4
X_7123_ u_input_buffer.fifo_mem\[34\]\[8\] _2966_ _2969_ u_input_buffer.fifo_mem\[48\]\[8\]
+ _3366_ VGND VGND VPWR VPWR _3367_ sky130_fd_sc_hd__a221o_1
Xfanout205 net11 VGND VGND VPWR VPWR net205 sky130_fd_sc_hd__buf_2
XFILLER_0_5_53 VGND VGND VPWR VPWR sky130_fd_sc_hd__decap_3
X_7054_ u_input_buffer.fifo_mem\[31\]\[6\] _3017_ _3020_ u_input_buffer.fifo_mem\[38\]\[6\]
+ VGND VGND VPWR VPWR _3300_ sky130_fd_sc_hd__a22o_1
X_4266_ u_analytics_engine.data_in\[9\] VGND VGND VPWR VPWR _1546_ sky130_fd_sc_hd__inv_2
X_4197_ net241 _1494_ VGND VGND VPWR VPWR _0078_ sky130_fd_sc_hd__xor2_1
X_6005_ _1910_ _2242_ VGND VGND VPWR VPWR _2548_ sky130_fd_sc_hd__nor2_4
XFILLER_0_96_339 VGND VGND VPWR VPWR sky130_fd_sc_hd__decap_3
XTAP_1229 VGND VPWR sky130_fd_sc_hd__tapvpwrvgnd_1
XTAP_1218 VGND VPWR sky130_fd_sc_hd__tapvpwrvgnd_1
XTAP_1207 VGND VPWR sky130_fd_sc_hd__tapvpwrvgnd_1
XFILLER_0_77_542 VGND VGND VPWR VPWR sky130_fd_sc_hd__fill_1
X_7956_ clknet_leaf_109_clk _0046_ VGND VGND VPWR VPWR u_sensor_interface.sensor_array\[0\]\[12\]
+ sky130_fd_sc_hd__dfxtp_1
X_6907_ u_input_buffer.fifo_mem\[15\]\[2\] _3060_ _3062_ u_input_buffer.fifo_mem\[43\]\[2\]
+ VGND VGND VPWR VPWR _3157_ sky130_fd_sc_hd__a22o_1
X_7887_ clknet_leaf_58_clk net235 net198 VGND VGND VPWR VPWR u_register_bank.status_flags\[7\]
+ sky130_fd_sc_hd__dfrtp_1
X_6838_ net1310 _2893_ _3084_ _3089_ VGND VGND VPWR VPWR _1126_ sky130_fd_sc_hd__a22o_1
XFILLER_0_18_653 VPWR VGND VPWR VGND sky130_ef_sc_hd__decap_12
X_6769_ u_input_buffer.fifo_mem\[31\]\[0\] _3017_ _3020_ u_input_buffer.fifo_mem\[38\]\[0\]
+ VGND VGND VPWR VPWR _3021_ sky130_fd_sc_hd__a22o_1
X_8508_ clknet_leaf_46_clk _0597_ VGND VGND VPWR VPWR u_input_buffer.fifo_mem\[31\]\[2\]
+ sky130_fd_sc_hd__dfxtp_1
XFILLER_0_32_133 VGND VGND VPWR VPWR sky130_fd_sc_hd__fill_2
XFILLER_0_115_393 VGND VGND VPWR VPWR sky130_fd_sc_hd__fill_1
X_8439_ clknet_leaf_11_clk _0528_ VGND VGND VPWR VPWR u_input_buffer.fifo_mem\[36\]\[13\]
+ sky130_fd_sc_hd__dfxtp_1
XFILLER_0_60_497 VPWR VGND VPWR VGND sky130_ef_sc_hd__decap_12
Xhold270 u_input_buffer.fifo_mem\[46\]\[0\] VGND VGND VPWR VPWR net482 sky130_fd_sc_hd__dlygate4sd3_1
XFILLER_0_13_391 VGND VGND VPWR VPWR sky130_fd_sc_hd__fill_1
Xhold292 u_input_buffer.fifo_mem\[30\]\[11\] VGND VGND VPWR VPWR net504 sky130_fd_sc_hd__dlygate4sd3_1
Xhold281 u_input_buffer.fifo_mem\[39\]\[15\] VGND VGND VPWR VPWR net493 sky130_fd_sc_hd__dlygate4sd3_1
XFILLER_0_87_306 VGND VGND VPWR VPWR sky130_fd_sc_hd__fill_2
XFILLER_0_68_564 VGND VGND VPWR VPWR sky130_fd_sc_hd__decap_3
XFILLER_0_68_597 VGND VGND VPWR VPWR sky130_fd_sc_hd__fill_2
XFILLER_0_70_217 VGND VGND VPWR VPWR sky130_fd_sc_hd__fill_1
XFILLER_0_11_45 VGND VGND VPWR VPWR sky130_fd_sc_hd__decap_8
XFILLER_0_3_517 VPWR VGND VPWR VGND sky130_ef_sc_hd__decap_12
XFILLER_0_23_111 VGND VGND VPWR VPWR sky130_fd_sc_hd__fill_1
XFILLER_0_24_645 VGND VGND VPWR VPWR sky130_fd_sc_hd__fill_1
XFILLER_0_11_89 VGND VGND VPWR VPWR sky130_fd_sc_hd__decap_4
XFILLER_0_87_49 VGND VGND VPWR VPWR sky130_fd_sc_hd__decap_6
XFILLER_0_23_177 VGND VGND VPWR VPWR sky130_fd_sc_hd__decap_4
X_4120_ u_input_buffer.data_in\[10\] VGND VGND VPWR VPWR _1438_ sky130_fd_sc_hd__buf_4
X_4051_ net112 VGND VGND VPWR VPWR _1379_ sky130_fd_sc_hd__clkbuf_8
Xinput5 cfg_addr[4] VGND VGND VPWR VPWR net5 sky130_fd_sc_hd__buf_1
X_7810_ net1323 u_analytics_engine.data_in\[15\] _3893_ VGND VGND VPWR VPWR _3903_
+ sky130_fd_sc_hd__mux2_1
X_8790_ clknet_leaf_11_clk _0879_ VGND VGND VPWR VPWR u_input_buffer.fifo_mem\[14\]\[12\]
+ sky130_fd_sc_hd__dfxtp_1
XFILLER_0_59_542 VGND VGND VPWR VPWR sky130_fd_sc_hd__fill_2
X_4953_ _1964_ VGND VGND VPWR VPWR _0366_ sky130_fd_sc_hd__clkbuf_1
X_7741_ _3858_ net128 _3852_ VGND VGND VPWR VPWR _3859_ sky130_fd_sc_hd__mux2_1
X_7672_ _3804_ VGND VGND VPWR VPWR _1245_ sky130_fd_sc_hd__clkbuf_1
XFILLER_0_74_501 VGND VGND VPWR VPWR sky130_fd_sc_hd__decap_8
X_4884_ net357 _1730_ _1911_ VGND VGND VPWR VPWR _1926_ sky130_fd_sc_hd__mux2_1
X_6623_ _2882_ _2860_ _2880_ VGND VGND VPWR VPWR _2883_ sky130_fd_sc_hd__and3_1
XFILLER_0_61_217 VGND VGND VPWR VPWR sky130_fd_sc_hd__fill_1
X_6554_ _2841_ VGND VGND VPWR VPWR _1090_ sky130_fd_sc_hd__clkbuf_1
XFILLER_0_15_623 VGND VGND VPWR VPWR sky130_fd_sc_hd__fill_1
X_6485_ net791 _1468_ _2788_ VGND VGND VPWR VPWR _2805_ sky130_fd_sc_hd__mux2_1
X_5505_ _2273_ VGND VGND VPWR VPWR _0609_ sky130_fd_sc_hd__clkbuf_1
XFILLER_0_112_330 VGND VGND VPWR VPWR sky130_fd_sc_hd__fill_1
X_5436_ _2229_ VGND VGND VPWR VPWR _0584_ sky130_fd_sc_hd__clkbuf_1
X_8224_ clknet_leaf_17_clk _0313_ VGND VGND VPWR VPWR u_input_buffer.fifo_mem\[49\]\[6\]
+ sky130_fd_sc_hd__dfxtp_1
XFILLER_0_100_525 VGND VGND VPWR VPWR sky130_fd_sc_hd__fill_2
X_5367_ net555 _2000_ _2187_ VGND VGND VPWR VPWR _2193_ sky130_fd_sc_hd__mux2_1
X_8155_ clknet_leaf_4_clk _0244_ VGND VGND VPWR VPWR u_input_buffer.fifo_mem\[53\]\[1\]
+ sky130_fd_sc_hd__dfxtp_1
X_5298_ _2156_ VGND VGND VPWR VPWR _0519_ sky130_fd_sc_hd__clkbuf_1
X_7106_ u_input_buffer.fifo_mem\[54\]\[7\] _3078_ _3080_ u_input_buffer.fifo_mem\[46\]\[7\]
+ VGND VGND VPWR VPWR _3351_ sky130_fd_sc_hd__a22o_1
XFILLER_0_77_93 VGND VGND VPWR VPWR sky130_fd_sc_hd__fill_1
X_8086_ clknet_leaf_85_clk _0175_ VGND VGND VPWR VPWR u_input_buffer.fifo_mem\[58\]\[12\]
+ sky130_fd_sc_hd__dfxtp_1
X_4318_ u_input_buffer.wr_ptr\[3\] VGND VGND VPWR VPWR _1597_ sky130_fd_sc_hd__buf_2
X_7037_ u_input_buffer.fifo_mem\[41\]\[6\] _2919_ _2921_ u_input_buffer.fifo_mem\[45\]\[6\]
+ _3282_ VGND VGND VPWR VPWR _3283_ sky130_fd_sc_hd__a221o_1
X_4249_ u_sample_counter.sample_count\[30\] net165 _1529_ VGND VGND VPWR VPWR _1531_
+ sky130_fd_sc_hd__and3_1
XFILLER_0_97_637 VGND VGND VPWR VPWR sky130_fd_sc_hd__fill_2
XTAP_1004 VGND VPWR sky130_fd_sc_hd__tapvpwrvgnd_1
X_8988_ clknet_leaf_4_clk _1077_ VGND VGND VPWR VPWR u_input_buffer.fifo_mem\[1\]\[2\]
+ sky130_fd_sc_hd__dfxtp_1
XTAP_1037 VGND VPWR sky130_fd_sc_hd__tapvpwrvgnd_1
XTAP_1026 VGND VPWR sky130_fd_sc_hd__tapvpwrvgnd_1
XTAP_1015 VGND VPWR sky130_fd_sc_hd__tapvpwrvgnd_1
X_7939_ clknet_leaf_84_clk _0029_ VGND VGND VPWR VPWR u_sensor_interface.sensor_array\[1\]\[11\]
+ sky130_fd_sc_hd__dfxtp_2
XTAP_1059 VGND VPWR sky130_fd_sc_hd__tapvpwrvgnd_1
XTAP_1048 VGND VPWR sky130_fd_sc_hd__tapvpwrvgnd_1
XFILLER_0_107_102 VGND VGND VPWR VPWR sky130_fd_sc_hd__decap_3
XFILLER_0_25_409 VGND VGND VPWR VPWR sky130_fd_sc_hd__fill_2
XFILLER_0_92_397 VGND VGND VPWR VPWR sky130_fd_sc_hd__decap_4
XFILLER_0_33_497 VGND VGND VPWR VPWR sky130_fd_sc_hd__fill_2
XTAP_1560 VGND VPWR sky130_fd_sc_hd__tapvpwrvgnd_1
XFILLER_0_28_214 VGND VGND VPWR VPWR sky130_fd_sc_hd__decap_6
XTAP_1593 VGND VPWR sky130_fd_sc_hd__tapvpwrvgnd_1
XTAP_1582 VGND VPWR sky130_fd_sc_hd__tapvpwrvgnd_1
XTAP_1571 VGND VPWR sky130_fd_sc_hd__tapvpwrvgnd_1
XFILLER_0_113_57 VGND VGND VPWR VPWR sky130_fd_sc_hd__decap_8
XFILLER_0_98_15 VPWR VGND VPWR VGND sky130_ef_sc_hd__decap_12
XFILLER_0_71_559 VGND VGND VPWR VPWR sky130_fd_sc_hd__fill_1
XFILLER_0_71_537 VGND VGND VPWR VPWR sky130_fd_sc_hd__decap_4
XFILLER_0_22_99 VGND VGND VPWR VPWR sky130_fd_sc_hd__decap_3
XFILLER_0_24_442 VGND VGND VPWR VPWR sky130_fd_sc_hd__decap_6
XFILLER_0_113_149 VPWR VGND VPWR VGND sky130_ef_sc_hd__decap_12
X_6270_ _1622_ net1199 _2679_ VGND VGND VPWR VPWR _2691_ sky130_fd_sc_hd__mux2_1
X_5221_ net1081 _1988_ _2115_ VGND VGND VPWR VPWR _2116_ sky130_fd_sc_hd__mux2_1
X_5152_ net424 _1988_ _2078_ VGND VGND VPWR VPWR _2079_ sky130_fd_sc_hd__mux2_1
XFILLER_0_20_681 VGND VGND VPWR VPWR sky130_fd_sc_hd__decap_4
X_4103_ _1423_ u_sensor_interface.sensor_array\[3\]\[7\] _1381_ VGND VGND VPWR VPWR
+ _1424_ sky130_fd_sc_hd__mux2_1
X_5083_ _2041_ VGND VGND VPWR VPWR _2042_ sky130_fd_sc_hd__buf_4
X_4034_ net311 net109 _1367_ VGND VGND VPWR VPWR _1369_ sky130_fd_sc_hd__mux2_1
X_8911_ clknet_leaf_52_clk _1000_ VGND VGND VPWR VPWR u_input_buffer.fifo_mem\[6\]\[5\]
+ sky130_fd_sc_hd__dfxtp_1
X_8842_ clknet_leaf_34_clk _0931_ VGND VGND VPWR VPWR u_input_buffer.fifo_mem\[10\]\[0\]
+ sky130_fd_sc_hd__dfxtp_1
XFILLER_0_2_65 VPWR VGND VPWR VGND sky130_ef_sc_hd__decap_12
X_8773_ clknet_leaf_95_clk _0862_ VGND VGND VPWR VPWR u_input_buffer.fifo_mem\[15\]\[11\]
+ sky130_fd_sc_hd__dfxtp_1
X_5985_ _1614_ net1084 _2531_ VGND VGND VPWR VPWR _2538_ sky130_fd_sc_hd__mux2_1
X_7724_ u_register_bank.window_cfg\[19\] _3812_ _3813_ u_register_bank.threshold_cfg\[19\]
+ _3844_ VGND VGND VPWR VPWR _3845_ sky130_fd_sc_hd__a221o_1
XPHY_109 VGND VGND VPWR VPWR sky130_fd_sc_hd__decap_3
X_4936_ net740 _1710_ _1952_ VGND VGND VPWR VPWR _1956_ sky130_fd_sc_hd__mux2_1
XFILLER_0_19_225 VGND VGND VPWR VPWR sky130_fd_sc_hd__fill_2
XFILLER_0_19_236 VGND VGND VPWR VPWR sky130_fd_sc_hd__fill_2
XFILLER_0_47_545 VGND VGND VPWR VPWR sky130_fd_sc_hd__fill_1
XANTENNA_10 u_sensor_interface.sensor_array\[2\]\[7\] VGND VGND VPWR VPWR sky130_fd_sc_hd__diode_2
X_4867_ _1917_ VGND VGND VPWR VPWR _0327_ sky130_fd_sc_hd__clkbuf_1
XANTENNA_32 net71 VGND VGND VPWR VPWR sky130_fd_sc_hd__diode_2
XANTENNA_21 net19 VGND VGND VPWR VPWR sky130_fd_sc_hd__diode_2
X_7655_ _3791_ net139 _3782_ VGND VGND VPWR VPWR _3792_ sky130_fd_sc_hd__mux2_1
XFILLER_0_105_617 VGND VGND VPWR VPWR sky130_fd_sc_hd__decap_4
XANTENNA_54 u_sensor_interface.sensor_array\[2\]\[8\] VGND VGND VPWR VPWR sky130_fd_sc_hd__diode_2
XFILLER_0_62_537 VGND VGND VPWR VPWR sky130_fd_sc_hd__fill_1
XFILLER_0_7_653 VPWR VGND VPWR VGND sky130_ef_sc_hd__decap_12
X_6606_ u_input_buffer.count\[6\] _1594_ VGND VGND VPWR VPWR _2871_ sky130_fd_sc_hd__and2_1
XANTENNA_43 _2606_ VGND VGND VPWR VPWR sky130_fd_sc_hd__diode_2
X_7586_ _3736_ VGND VGND VPWR VPWR _3748_ sky130_fd_sc_hd__buf_4
X_4798_ net769 _1714_ _1874_ VGND VGND VPWR VPWR _1880_ sky130_fd_sc_hd__mux2_1
X_6537_ _1616_ net1247 _2825_ VGND VGND VPWR VPWR _2833_ sky130_fd_sc_hd__mux2_1
XFILLER_0_104_138 VGND VGND VPWR VPWR sky130_fd_sc_hd__fill_2
XFILLER_0_112_160 VPWR VGND VPWR VGND sky130_ef_sc_hd__decap_12
X_6468_ _2796_ VGND VGND VPWR VPWR _1049_ sky130_fd_sc_hd__clkbuf_1
Xoutput161 net161 VGND VGND VPWR VPWR processed_data_out[7] sky130_fd_sc_hd__clkbuf_4
X_9187_ clknet_leaf_51_clk _1275_ net199 VGND VGND VPWR VPWR net159 sky130_fd_sc_hd__dfrtp_1
Xoutput150 net150 VGND VGND VPWR VPWR processed_data_out[11] sky130_fd_sc_hd__clkbuf_4
X_8207_ clknet_leaf_37_clk _0296_ VGND VGND VPWR VPWR u_input_buffer.fifo_mem\[50\]\[5\]
+ sky130_fd_sc_hd__dfxtp_1
X_5419_ _1463_ net812 _2204_ VGND VGND VPWR VPWR _2220_ sky130_fd_sc_hd__mux2_1
X_6399_ _1614_ net1126 _2753_ VGND VGND VPWR VPWR _2760_ sky130_fd_sc_hd__mux2_1
X_8138_ clknet_leaf_35_clk _0227_ VGND VGND VPWR VPWR u_input_buffer.fifo_mem\[54\]\[0\]
+ sky130_fd_sc_hd__dfxtp_1
X_8069_ clknet_leaf_91_clk _0158_ VGND VGND VPWR VPWR u_input_buffer.fifo_mem\[59\]\[11\]
+ sky130_fd_sc_hd__dfxtp_1
XFILLER_0_69_103 VGND VGND VPWR VPWR sky130_fd_sc_hd__fill_1
XFILLER_0_93_673 VPWR VGND VPWR VGND sky130_ef_sc_hd__decap_12
XFILLER_0_25_217 VGND VGND VPWR VPWR sky130_fd_sc_hd__fill_1
XFILLER_0_80_389 VGND VGND VPWR VPWR sky130_fd_sc_hd__fill_1
XFILLER_0_0_317 VPWR VGND VPWR VGND sky130_ef_sc_hd__decap_12
XTAP_607 VGND VPWR sky130_fd_sc_hd__tapvpwrvgnd_1
XTAP_618 VGND VPWR sky130_fd_sc_hd__tapvpwrvgnd_1
XTAP_629 VGND VPWR sky130_fd_sc_hd__tapvpwrvgnd_1
XFILLER_0_17_66 VPWR VGND VPWR VGND sky130_ef_sc_hd__decap_12
X_5770_ _2416_ VGND VGND VPWR VPWR _0731_ sky130_fd_sc_hd__clkbuf_1
X_4721_ _1838_ VGND VGND VPWR VPWR _0260_ sky130_fd_sc_hd__clkbuf_1
XTAP_1390 VGND VPWR sky130_fd_sc_hd__tapvpwrvgnd_1
XFILLER_0_84_662 VGND VGND VPWR VPWR sky130_fd_sc_hd__decap_3
X_4652_ net476 _1708_ _1798_ VGND VGND VPWR VPWR _1801_ sky130_fd_sc_hd__mux2_1
XFILLER_0_4_601 VPWR VGND VPWR VGND sky130_ef_sc_hd__decap_12
X_7440_ _3668_ VGND VGND VPWR VPWR _1149_ sky130_fd_sc_hd__clkbuf_1
XFILLER_0_16_217 VGND VGND VPWR VPWR sky130_fd_sc_hd__fill_1
XFILLER_0_71_367 VGND VGND VPWR VPWR sky130_fd_sc_hd__decap_4
Xinput30 cfg_wdata[26] VGND VGND VPWR VPWR net30 sky130_fd_sc_hd__dlymetal6s2s_1
Xinput63 sensor_data_in[25] VGND VGND VPWR VPWR net63 sky130_fd_sc_hd__clkbuf_1
Xinput41 cfg_wdata[7] VGND VGND VPWR VPWR net41 sky130_fd_sc_hd__clkbuf_4
X_4583_ net925 _1712_ _1757_ VGND VGND VPWR VPWR _1762_ sky130_fd_sc_hd__mux2_1
Xinput52 sensor_data_in[15] VGND VGND VPWR VPWR net52 sky130_fd_sc_hd__clkbuf_4
XFILLER_0_71_389 VGND VGND VPWR VPWR sky130_fd_sc_hd__decap_3
X_9110_ net175 _1198_ net207 VGND VGND VPWR VPWR u_register_bank.window_cfg\[24\]
+ sky130_fd_sc_hd__dfrtp_1
XFILLER_0_4_645 VPWR VGND VPWR VGND sky130_ef_sc_hd__decap_12
Xhold803 u_input_buffer.fifo_mem\[20\]\[13\] VGND VGND VPWR VPWR net1015 sky130_fd_sc_hd__dlygate4sd3_1
X_7371_ u_input_buffer.fifo_mem\[6\]\[14\] _3034_ _3036_ u_input_buffer.fifo_mem\[28\]\[14\]
+ _3608_ VGND VGND VPWR VPWR _3609_ sky130_fd_sc_hd__a221o_1
X_6322_ _2719_ VGND VGND VPWR VPWR _0980_ sky130_fd_sc_hd__clkbuf_1
Xinput74 sensor_data_in[35] VGND VGND VPWR VPWR net74 sky130_fd_sc_hd__clkbuf_1
XFILLER_0_3_166 VGND VGND VPWR VPWR sky130_fd_sc_hd__fill_2
Xinput96 sensor_data_in[55] VGND VGND VPWR VPWR net96 sky130_fd_sc_hd__buf_1
Xhold836 u_input_buffer.fifo_mem\[27\]\[14\] VGND VGND VPWR VPWR net1048 sky130_fd_sc_hd__dlygate4sd3_1
Xhold814 u_input_buffer.fifo_mem\[37\]\[15\] VGND VGND VPWR VPWR net1026 sky130_fd_sc_hd__dlygate4sd3_1
Xinput85 sensor_data_in[45] VGND VGND VPWR VPWR net85 sky130_fd_sc_hd__buf_1
Xhold825 u_input_buffer.fifo_mem\[21\]\[4\] VGND VGND VPWR VPWR net1037 sky130_fd_sc_hd__dlygate4sd3_1
Xhold869 u_input_buffer.fifo_mem\[38\]\[0\] VGND VGND VPWR VPWR net1081 sky130_fd_sc_hd__dlygate4sd3_1
X_9041_ clknet_leaf_48_clk _1130_ VGND VGND VPWR VPWR u_analytics_engine.data_in\[4\]
+ sky130_fd_sc_hd__dfxtp_2
X_6253_ _2682_ VGND VGND VPWR VPWR _0948_ sky130_fd_sc_hd__clkbuf_1
Xhold858 u_input_buffer.fifo_mem\[1\]\[12\] VGND VGND VPWR VPWR net1070 sky130_fd_sc_hd__dlygate4sd3_1
Xhold847 u_input_buffer.fifo_mem\[45\]\[15\] VGND VGND VPWR VPWR net1059 sky130_fd_sc_hd__dlygate4sd3_1
X_5204_ _2106_ VGND VGND VPWR VPWR _0475_ sky130_fd_sc_hd__clkbuf_1
X_6184_ net759 _2500_ _2644_ VGND VGND VPWR VPWR _2646_ sky130_fd_sc_hd__mux2_1
X_5135_ _2069_ VGND VGND VPWR VPWR _0443_ sky130_fd_sc_hd__clkbuf_1
XFILLER_0_35_3 VGND VGND VPWR VPWR sky130_fd_sc_hd__decap_8
X_5066_ net698 _2006_ _2024_ VGND VGND VPWR VPWR _2033_ sky130_fd_sc_hd__mux2_1
XFILLER_0_74_83 VGND VGND VPWR VPWR sky130_fd_sc_hd__fill_1
X_4017_ u_sensor_interface.sensor_array\[0\]\[1\] net57 _1356_ VGND VGND VPWR VPWR
+ _1360_ sky130_fd_sc_hd__mux2_1
X_8825_ clknet_leaf_12_clk _0914_ VGND VGND VPWR VPWR u_input_buffer.fifo_mem\[12\]\[15\]
+ sky130_fd_sc_hd__dfxtp_1
X_8756_ clknet_leaf_99_clk _0845_ VGND VGND VPWR VPWR u_input_buffer.fifo_mem\[16\]\[10\]
+ sky130_fd_sc_hd__dfxtp_1
X_5968_ _1468_ VGND VGND VPWR VPWR _2528_ sky130_fd_sc_hd__clkbuf_4
X_7707_ u_register_bank.window_cfg\[15\] _3812_ _3813_ u_analytics_engine.threshold\[15\]
+ _3831_ VGND VGND VPWR VPWR _3832_ sky130_fd_sc_hd__a221o_1
X_4919_ _1946_ VGND VGND VPWR VPWR _0350_ sky130_fd_sc_hd__clkbuf_1
XFILLER_0_47_342 VGND VGND VPWR VPWR sky130_fd_sc_hd__fill_2
XFILLER_0_47_364 VGND VGND VPWR VPWR sky130_fd_sc_hd__fill_1
X_8687_ clknet_leaf_53_clk _0776_ VGND VGND VPWR VPWR u_input_buffer.fifo_mem\[20\]\[5\]
+ sky130_fd_sc_hd__dfxtp_1
X_5899_ net540 _2254_ _2479_ VGND VGND VPWR VPWR _2485_ sky130_fd_sc_hd__mux2_1
X_7638_ _3777_ VGND VGND VPWR VPWR _3778_ sky130_fd_sc_hd__clkbuf_4
X_7569_ _3739_ VGND VGND VPWR VPWR _1207_ sky130_fd_sc_hd__clkbuf_1
XFILLER_0_43_570 VGND VGND VPWR VPWR sky130_fd_sc_hd__decap_4
XFILLER_0_65_150 VGND VGND VPWR VPWR sky130_fd_sc_hd__fill_1
XFILLER_0_1_615 VGND VGND VPWR VPWR sky130_fd_sc_hd__fill_1
XFILLER_0_0_125 VGND VGND VPWR VPWR sky130_fd_sc_hd__decap_8
XFILLER_0_95_27 VPWR VGND VPWR VGND sky130_ef_sc_hd__decap_12
XTAP_404 VGND VPWR sky130_fd_sc_hd__tapvpwrvgnd_1
XTAP_415 VGND VPWR sky130_fd_sc_hd__tapvpwrvgnd_1
XTAP_426 VGND VPWR sky130_fd_sc_hd__tapvpwrvgnd_1
XTAP_437 VGND VPWR sky130_fd_sc_hd__tapvpwrvgnd_1
XTAP_448 VGND VPWR sky130_fd_sc_hd__tapvpwrvgnd_1
XTAP_459 VGND VPWR sky130_fd_sc_hd__tapvpwrvgnd_1
X_6940_ u_input_buffer.fifo_mem\[7\]\[3\] _3025_ _3027_ u_input_buffer.fifo_mem\[22\]\[3\]
+ _3188_ VGND VGND VPWR VPWR _3189_ sky130_fd_sc_hd__a221o_1
X_6871_ u_input_buffer.fifo_mem\[26\]\[1\] _3066_ _3068_ u_input_buffer.fifo_mem\[62\]\[1\]
+ _3121_ VGND VGND VPWR VPWR _3122_ sky130_fd_sc_hd__a221o_1
X_5822_ _2444_ VGND VGND VPWR VPWR _0755_ sky130_fd_sc_hd__clkbuf_1
X_8610_ clknet_leaf_6_clk _0699_ VGND VGND VPWR VPWR u_input_buffer.fifo_mem\[25\]\[8\]
+ sky130_fd_sc_hd__dfxtp_1
X_5753_ net471 _2240_ _2407_ VGND VGND VPWR VPWR _2408_ sky130_fd_sc_hd__mux2_1
XFILLER_0_8_225 VGND VGND VPWR VPWR sky130_fd_sc_hd__fill_2
X_8541_ clknet_leaf_3_clk _0630_ VGND VGND VPWR VPWR u_input_buffer.fifo_mem\[29\]\[3\]
+ sky130_fd_sc_hd__dfxtp_1
X_4704_ _1828_ VGND VGND VPWR VPWR _0253_ sky130_fd_sc_hd__clkbuf_1
XFILLER_0_8_247 VGND VGND VPWR VPWR sky130_fd_sc_hd__fill_1
XFILLER_0_29_386 VGND VGND VPWR VPWR sky130_fd_sc_hd__fill_2
XFILLER_0_44_301 VGND VGND VPWR VPWR sky130_fd_sc_hd__fill_1
XFILLER_0_72_643 VGND VGND VPWR VPWR sky130_fd_sc_hd__fill_1
XFILLER_0_17_559 VGND VGND VPWR VPWR sky130_fd_sc_hd__fill_1
X_8472_ clknet_leaf_98_clk _0561_ VGND VGND VPWR VPWR u_input_buffer.fifo_mem\[34\]\[14\]
+ sky130_fd_sc_hd__dfxtp_1
X_5684_ _1588_ net1056 _2370_ VGND VGND VPWR VPWR _2371_ sky130_fd_sc_hd__mux2_1
XFILLER_0_114_233 VGND VGND VPWR VPWR sky130_fd_sc_hd__fill_2
X_4635_ _1790_ VGND VGND VPWR VPWR _0222_ sky130_fd_sc_hd__clkbuf_1
X_7423_ u_analytics_engine.data_in\[15\] _2892_ _3658_ _3659_ VGND VGND VPWR VPWR
+ _1141_ sky130_fd_sc_hd__a22o_1
Xhold611 u_input_buffer.fifo_mem\[19\]\[4\] VGND VGND VPWR VPWR net823 sky130_fd_sc_hd__dlygate4sd3_1
X_4566_ _1457_ net1004 _1737_ VGND VGND VPWR VPWR _1752_ sky130_fd_sc_hd__mux2_1
XFILLER_0_8_53 VGND VGND VPWR VPWR sky130_fd_sc_hd__fill_1
XFILLER_0_4_464 VPWR VGND VPWR VGND sky130_ef_sc_hd__decap_12
Xhold600 u_input_buffer.fifo_mem\[33\]\[14\] VGND VGND VPWR VPWR net812 sky130_fd_sc_hd__dlygate4sd3_1
X_7354_ u_input_buffer.fifo_mem\[14\]\[14\] _2957_ _2960_ u_input_buffer.fifo_mem\[42\]\[14\]
+ VGND VGND VPWR VPWR _3592_ sky130_fd_sc_hd__a22o_1
Xhold633 u_input_buffer.fifo_mem\[40\]\[5\] VGND VGND VPWR VPWR net845 sky130_fd_sc_hd__dlygate4sd3_1
Xhold622 u_input_buffer.fifo_mem\[36\]\[8\] VGND VGND VPWR VPWR net834 sky130_fd_sc_hd__dlygate4sd3_1
Xhold644 u_input_buffer.fifo_mem\[10\]\[10\] VGND VGND VPWR VPWR net856 sky130_fd_sc_hd__dlygate4sd3_1
X_6305_ _2709_ VGND VGND VPWR VPWR _0973_ sky130_fd_sc_hd__clkbuf_1
Xhold666 u_input_buffer.fifo_mem\[30\]\[7\] VGND VGND VPWR VPWR net878 sky130_fd_sc_hd__dlygate4sd3_1
X_4497_ _1709_ VGND VGND VPWR VPWR _0165_ sky130_fd_sc_hd__clkbuf_1
Xhold655 u_input_buffer.fifo_mem\[12\]\[6\] VGND VGND VPWR VPWR net867 sky130_fd_sc_hd__dlygate4sd3_1
X_9024_ clknet_leaf_87_clk _1113_ net189 VGND VGND VPWR VPWR u_input_buffer.count\[6\]
+ sky130_fd_sc_hd__dfrtp_1
X_7285_ _3509_ _3511_ _3515_ _3524_ VGND VGND VPWR VPWR _3525_ sky130_fd_sc_hd__or4_2
Xhold688 u_input_buffer.fifo_mem\[2\]\[12\] VGND VGND VPWR VPWR net900 sky130_fd_sc_hd__dlygate4sd3_1
Xhold677 u_input_buffer.fifo_mem\[35\]\[11\] VGND VGND VPWR VPWR net889 sky130_fd_sc_hd__dlygate4sd3_1
X_6236_ net856 _2518_ _2661_ VGND VGND VPWR VPWR _2673_ sky130_fd_sc_hd__mux2_1
Xhold699 u_input_buffer.fifo_mem\[15\]\[11\] VGND VGND VPWR VPWR net911 sky130_fd_sc_hd__dlygate4sd3_1
XTAP_960 VGND VPWR sky130_fd_sc_hd__tapvpwrvgnd_1
XTAP_971 VGND VPWR sky130_fd_sc_hd__tapvpwrvgnd_1
X_6167_ net1043 _2518_ _2624_ VGND VGND VPWR VPWR _2636_ sky130_fd_sc_hd__mux2_1
X_5118_ _1377_ net1106 _2060_ VGND VGND VPWR VPWR _2061_ sky130_fd_sc_hd__mux2_1
XTAP_993 VGND VPWR sky130_fd_sc_hd__tapvpwrvgnd_1
XTAP_982 VGND VPWR sky130_fd_sc_hd__tapvpwrvgnd_1
X_6098_ _2598_ VGND VGND VPWR VPWR _0877_ sky130_fd_sc_hd__clkbuf_1
X_5049_ _2023_ VGND VGND VPWR VPWR _2024_ sky130_fd_sc_hd__buf_4
XFILLER_0_94_201 VGND VGND VPWR VPWR sky130_fd_sc_hd__fill_1
X_8808_ clknet_leaf_103_clk _0897_ VGND VGND VPWR VPWR u_input_buffer.fifo_mem\[13\]\[14\]
+ sky130_fd_sc_hd__dfxtp_1
XFILLER_0_82_418 VGND VGND VPWR VPWR sky130_fd_sc_hd__fill_2
X_8739_ clknet_leaf_0_clk _0828_ VGND VGND VPWR VPWR u_input_buffer.fifo_mem\[17\]\[9\]
+ sky130_fd_sc_hd__dfxtp_1
XFILLER_0_62_131 VGND VGND VPWR VPWR sky130_fd_sc_hd__fill_1
XFILLER_0_50_304 VGND VGND VPWR VPWR sky130_fd_sc_hd__decap_4
XFILLER_0_105_277 VGND VGND VPWR VPWR sky130_fd_sc_hd__decap_3
XFILLER_0_81_18 VPWR VGND VPWR VGND sky130_ef_sc_hd__decap_12
XFILLER_0_85_234 VGND VGND VPWR VPWR sky130_fd_sc_hd__decap_6
XFILLER_0_58_437 VGND VGND VPWR VPWR sky130_fd_sc_hd__fill_2
XFILLER_0_105_69 VGND VGND VPWR VPWR sky130_fd_sc_hd__decap_4
XFILLER_0_85_289 VGND VGND VPWR VPWR sky130_fd_sc_hd__fill_2
XFILLER_0_81_440 VGND VGND VPWR VPWR sky130_fd_sc_hd__fill_1
XFILLER_0_5_206 VGND VGND VPWR VPWR sky130_fd_sc_hd__fill_2
XFILLER_0_38_194 VGND VGND VPWR VPWR sky130_fd_sc_hd__fill_2
XFILLER_0_53_131 VPWR VGND VPWR VGND sky130_ef_sc_hd__decap_12
XFILLER_0_81_484 VGND VGND VPWR VPWR sky130_fd_sc_hd__fill_2
XFILLER_0_54_676 VGND VGND VPWR VPWR sky130_fd_sc_hd__decap_4
X_4420_ _1664_ VGND VGND VPWR VPWR _0133_ sky130_fd_sc_hd__clkbuf_1
XFILLER_0_22_562 VGND VGND VPWR VPWR sky130_fd_sc_hd__fill_2
X_4351_ net1027 _1620_ _1602_ VGND VGND VPWR VPWR _1621_ sky130_fd_sc_hd__mux2_1
XFILLER_0_22_584 VGND VGND VPWR VPWR sky130_fd_sc_hd__decap_4
X_4282_ u_analytics_engine.threshold\[7\] _1559_ VGND VGND VPWR VPWR _1562_ sky130_fd_sc_hd__and2_1
X_7070_ _3297_ _3306_ _3315_ VGND VGND VPWR VPWR _3316_ sky130_fd_sc_hd__or3_1
X_6021_ net697 _2512_ _2549_ VGND VGND VPWR VPWR _2557_ sky130_fd_sc_hd__mux2_1
XTAP_234 VGND VPWR sky130_fd_sc_hd__tapvpwrvgnd_1
XTAP_256 VGND VPWR sky130_fd_sc_hd__tapvpwrvgnd_1
XTAP_245 VGND VPWR sky130_fd_sc_hd__tapvpwrvgnd_1
XTAP_289 VGND VPWR sky130_fd_sc_hd__tapvpwrvgnd_1
XTAP_267 VGND VPWR sky130_fd_sc_hd__tapvpwrvgnd_1
XTAP_278 VGND VPWR sky130_fd_sc_hd__tapvpwrvgnd_1
X_7972_ clknet_leaf_105_clk _0062_ net184 VGND VGND VPWR VPWR u_input_buffer.data_in\[12\]
+ sky130_fd_sc_hd__dfrtp_1
X_6923_ u_input_buffer.fifo_mem\[29\]\[3\] _2939_ _2941_ u_input_buffer.fifo_mem\[13\]\[3\]
+ _3171_ VGND VGND VPWR VPWR _3172_ sky130_fd_sc_hd__a221o_1
XFILLER_0_76_212 VGND VGND VPWR VPWR sky130_fd_sc_hd__decap_3
X_6854_ u_input_buffer.fifo_mem\[51\]\[1\] _2990_ _2993_ u_input_buffer.fifo_mem\[11\]\[1\]
+ _3104_ VGND VGND VPWR VPWR _3105_ sky130_fd_sc_hd__a221o_1
X_5805_ net829 _2262_ _2425_ VGND VGND VPWR VPWR _2435_ sky130_fd_sc_hd__mux2_1
X_3997_ _1349_ VGND VGND VPWR VPWR _0025_ sky130_fd_sc_hd__clkbuf_1
X_6785_ _3036_ VGND VGND VPWR VPWR _3037_ sky130_fd_sc_hd__clkbuf_4
X_8524_ clknet_leaf_59_clk _0613_ VGND VGND VPWR VPWR u_input_buffer.fifo_mem\[30\]\[2\]
+ sky130_fd_sc_hd__dfxtp_1
X_5736_ net542 _2262_ _2388_ VGND VGND VPWR VPWR _2398_ sky130_fd_sc_hd__mux2_1
XFILLER_0_115_531 VGND VGND VPWR VPWR sky130_fd_sc_hd__fill_1
XFILLER_0_72_462 VGND VGND VPWR VPWR sky130_fd_sc_hd__fill_2
X_5667_ _2361_ VGND VGND VPWR VPWR _0683_ sky130_fd_sc_hd__clkbuf_1
XFILLER_0_60_624 VGND VGND VPWR VPWR sky130_fd_sc_hd__decap_3
X_8455_ clknet_leaf_15_clk _0544_ VGND VGND VPWR VPWR u_input_buffer.fifo_mem\[35\]\[13\]
+ sky130_fd_sc_hd__dfxtp_1
XFILLER_0_17_378 VGND VGND VPWR VPWR sky130_fd_sc_hd__fill_1
XFILLER_0_32_315 VGND VGND VPWR VPWR sky130_fd_sc_hd__decap_3
X_4618_ net475 _1710_ _1778_ VGND VGND VPWR VPWR _1782_ sky130_fd_sc_hd__mux2_1
X_7406_ u_input_buffer.fifo_mem\[27\]\[15\] _3012_ _3014_ u_input_buffer.fifo_mem\[59\]\[15\]
+ _3642_ VGND VGND VPWR VPWR _3643_ sky130_fd_sc_hd__a221o_1
XFILLER_0_115_597 VGND VGND VPWR VPWR sky130_fd_sc_hd__fill_1
X_8386_ clknet_leaf_50_clk _0475_ VGND VGND VPWR VPWR u_input_buffer.fifo_mem\[39\]\[8\]
+ sky130_fd_sc_hd__dfxtp_1
X_5598_ _2324_ VGND VGND VPWR VPWR _0651_ sky130_fd_sc_hd__clkbuf_1
XFILLER_0_4_261 VGND VGND VPWR VPWR sky130_fd_sc_hd__decap_3
Xhold430 u_input_buffer.fifo_mem\[35\]\[5\] VGND VGND VPWR VPWR net642 sky130_fd_sc_hd__dlygate4sd3_1
Xhold452 u_input_buffer.fifo_mem\[32\]\[8\] VGND VGND VPWR VPWR net664 sky130_fd_sc_hd__dlygate4sd3_1
X_7337_ u_input_buffer.fifo_mem\[10\]\[13\] _3055_ _3057_ u_input_buffer.fifo_mem\[44\]\[13\]
+ _3575_ VGND VGND VPWR VPWR _3576_ sky130_fd_sc_hd__a221o_1
XFILLER_0_13_573 VPWR VGND VPWR VGND sky130_ef_sc_hd__decap_12
Xhold441 u_input_buffer.fifo_mem\[58\]\[12\] VGND VGND VPWR VPWR net653 sky130_fd_sc_hd__dlygate4sd3_1
X_4549_ _1743_ VGND VGND VPWR VPWR _0183_ sky130_fd_sc_hd__clkbuf_1
Xhold463 u_input_buffer.fifo_mem\[15\]\[14\] VGND VGND VPWR VPWR net675 sky130_fd_sc_hd__dlygate4sd3_1
Xhold485 u_input_buffer.fifo_mem\[16\]\[7\] VGND VGND VPWR VPWR net697 sky130_fd_sc_hd__dlygate4sd3_1
Xhold474 u_input_buffer.fifo_mem\[30\]\[3\] VGND VGND VPWR VPWR net686 sky130_fd_sc_hd__dlygate4sd3_1
X_7268_ u_input_buffer.fifo_mem\[21\]\[12\] _2908_ _2912_ u_input_buffer.fifo_mem\[25\]\[12\]
+ VGND VGND VPWR VPWR _3508_ sky130_fd_sc_hd__a22o_1
Xhold496 u_analytics_engine.data_in\[14\] VGND VGND VPWR VPWR net708 sky130_fd_sc_hd__dlygate4sd3_1
X_6219_ _2664_ VGND VGND VPWR VPWR _0932_ sky130_fd_sc_hd__clkbuf_1
X_9007_ clknet_leaf_47_clk _1096_ VGND VGND VPWR VPWR u_input_buffer.fifo_mem\[0\]\[5\]
+ sky130_fd_sc_hd__dfxtp_1
X_7199_ u_input_buffer.fifo_mem\[36\]\[10\] _2950_ _2954_ u_input_buffer.fifo_mem\[35\]\[10\]
+ _3440_ VGND VGND VPWR VPWR _3441_ sky130_fd_sc_hd__a221o_1
XTAP_790 VGND VPWR sky130_fd_sc_hd__tapvpwrvgnd_1
XFILLER_0_67_234 VGND VGND VPWR VPWR sky130_fd_sc_hd__fill_1
XFILLER_0_67_223 VGND VGND VPWR VPWR sky130_fd_sc_hd__fill_1
XFILLER_0_95_587 VGND VGND VPWR VPWR sky130_fd_sc_hd__fill_1
XFILLER_0_106_531 VGND VGND VPWR VPWR sky130_fd_sc_hd__fill_1
XFILLER_0_23_337 VGND VGND VPWR VPWR sky130_fd_sc_hd__decap_4
XFILLER_0_50_167 VGND VGND VPWR VPWR sky130_fd_sc_hd__decap_3
XFILLER_0_51_668 VGND VGND VPWR VPWR sky130_fd_sc_hd__decap_4
XFILLER_0_76_29 VGND VGND VPWR VPWR sky130_fd_sc_hd__decap_4
XFILLER_0_25_66 VGND VGND VPWR VPWR sky130_fd_sc_hd__fill_2
XFILLER_0_18_109 VGND VGND VPWR VPWR sky130_fd_sc_hd__fill_2
X_6570_ _2850_ VGND VGND VPWR VPWR _1097_ sky130_fd_sc_hd__clkbuf_1
XFILLER_0_109_391 VGND VGND VPWR VPWR sky130_fd_sc_hd__fill_1
X_5521_ net761 _2254_ _2277_ VGND VGND VPWR VPWR _2283_ sky130_fd_sc_hd__mux2_1
X_8240_ clknet_leaf_38_clk _0329_ VGND VGND VPWR VPWR u_input_buffer.fifo_mem\[48\]\[6\]
+ sky130_fd_sc_hd__dfxtp_1
XFILLER_0_14_326 VGND VGND VPWR VPWR sky130_fd_sc_hd__decap_3
XFILLER_0_26_197 VGND VGND VPWR VPWR sky130_fd_sc_hd__fill_1
XFILLER_0_42_668 VGND VGND VPWR VPWR sky130_fd_sc_hd__fill_2
X_5452_ _2237_ VGND VGND VPWR VPWR _0592_ sky130_fd_sc_hd__clkbuf_1
X_8171_ clknet_leaf_56_clk _0260_ VGND VGND VPWR VPWR u_input_buffer.fifo_mem\[52\]\[1\]
+ sky130_fd_sc_hd__dfxtp_1
XFILLER_0_10_521 VGND VGND VPWR VPWR sky130_fd_sc_hd__decap_8
X_4403_ _1451_ net1122 _1640_ VGND VGND VPWR VPWR _1654_ sky130_fd_sc_hd__mux2_1
X_5383_ net1237 _2016_ _2186_ VGND VGND VPWR VPWR _2201_ sky130_fd_sc_hd__mux2_1
XFILLER_0_41_178 VGND VGND VPWR VPWR sky130_fd_sc_hd__fill_2
XFILLER_0_112_589 VGND VGND VPWR VPWR sky130_fd_sc_hd__decap_8
X_4334_ _1609_ VGND VGND VPWR VPWR _0102_ sky130_fd_sc_hd__clkbuf_1
X_7122_ u_input_buffer.fifo_mem\[16\]\[8\] _2971_ _2973_ u_input_buffer.fifo_mem\[49\]\[8\]
+ _2975_ VGND VGND VPWR VPWR _3366_ sky130_fd_sc_hd__a221o_1
X_7053_ u_input_buffer.fifo_mem\[8\]\[6\] _3004_ _3006_ u_input_buffer.fifo_mem\[19\]\[6\]
+ _3298_ VGND VGND VPWR VPWR _3299_ sky130_fd_sc_hd__a221o_1
Xfanout206 net207 VGND VGND VPWR VPWR net206 sky130_fd_sc_hd__clkbuf_4
XFILLER_0_10_587 VGND VGND VPWR VPWR sky130_fd_sc_hd__fill_1
X_6004_ _2547_ VGND VGND VPWR VPWR _0834_ sky130_fd_sc_hd__clkbuf_1
X_4265_ _1542_ u_analytics_engine.data_in\[11\] VGND VGND VPWR VPWR _1545_ sky130_fd_sc_hd__or2_1
XFILLER_0_5_98 VGND VGND VPWR VPWR sky130_fd_sc_hd__fill_1
X_4196_ _1496_ VGND VGND VPWR VPWR _0077_ sky130_fd_sc_hd__clkbuf_1
XFILLER_0_82_50 VGND VGND VPWR VPWR sky130_fd_sc_hd__fill_1
XTAP_1219 VGND VPWR sky130_fd_sc_hd__tapvpwrvgnd_1
XTAP_1208 VGND VPWR sky130_fd_sc_hd__tapvpwrvgnd_1
X_7955_ clknet_leaf_110_clk _0045_ VGND VGND VPWR VPWR u_sensor_interface.sensor_array\[0\]\[11\]
+ sky130_fd_sc_hd__dfxtp_1
XFILLER_0_49_212 VGND VGND VPWR VPWR sky130_fd_sc_hd__fill_1
X_7886_ clknet_leaf_58_clk net229 net198 VGND VGND VPWR VPWR u_register_bank.status_flags\[6\]
+ sky130_fd_sc_hd__dfrtp_1
X_6906_ u_input_buffer.fifo_mem\[23\]\[2\] _3046_ _3048_ u_input_buffer.fifo_mem\[20\]\[2\]
+ _3155_ VGND VGND VPWR VPWR _3156_ sky130_fd_sc_hd__a221o_1
X_6837_ net683 _3086_ _3088_ VGND VGND VPWR VPWR _3089_ sky130_fd_sc_hd__o21a_1
XFILLER_0_37_429 VPWR VGND VPWR VGND sky130_ef_sc_hd__decap_12
XFILLER_0_9_353 VGND VGND VPWR VPWR sky130_fd_sc_hd__fill_2
X_8507_ clknet_leaf_45_clk _0596_ VGND VGND VPWR VPWR u_input_buffer.fifo_mem\[31\]\[1\]
+ sky130_fd_sc_hd__dfxtp_1
X_6768_ _3019_ VGND VGND VPWR VPWR _3020_ sky130_fd_sc_hd__clkbuf_4
XFILLER_0_18_665 VGND VGND VPWR VPWR sky130_fd_sc_hd__decap_4
X_6699_ _2950_ VGND VGND VPWR VPWR _2951_ sky130_fd_sc_hd__clkbuf_4
X_5719_ _2389_ VGND VGND VPWR VPWR _0707_ sky130_fd_sc_hd__clkbuf_1
XFILLER_0_72_281 VGND VGND VPWR VPWR sky130_fd_sc_hd__fill_2
XFILLER_0_60_421 VGND VGND VPWR VPWR sky130_fd_sc_hd__decap_4
XFILLER_0_103_501 VGND VGND VPWR VPWR sky130_fd_sc_hd__decap_3
X_8438_ clknet_leaf_10_clk _0527_ VGND VGND VPWR VPWR u_input_buffer.fifo_mem\[36\]\[12\]
+ sky130_fd_sc_hd__dfxtp_1
X_8369_ clknet_leaf_50_clk _0458_ VGND VGND VPWR VPWR u_input_buffer.fifo_mem\[40\]\[7\]
+ sky130_fd_sc_hd__dfxtp_1
Xhold260 u_input_buffer.fifo_mem\[32\]\[3\] VGND VGND VPWR VPWR net472 sky130_fd_sc_hd__dlygate4sd3_1
Xhold271 u_input_buffer.fifo_mem\[24\]\[10\] VGND VGND VPWR VPWR net483 sky130_fd_sc_hd__dlygate4sd3_1
Xhold293 u_input_buffer.fifo_mem\[42\]\[6\] VGND VGND VPWR VPWR net505 sky130_fd_sc_hd__dlygate4sd3_1
Xhold282 u_input_buffer.fifo_mem\[31\]\[4\] VGND VGND VPWR VPWR net494 sky130_fd_sc_hd__dlygate4sd3_1
XFILLER_0_95_362 VGND VGND VPWR VPWR sky130_fd_sc_hd__fill_2
XFILLER_0_68_587 VGND VGND VPWR VPWR sky130_fd_sc_hd__fill_1
XFILLER_0_55_204 VGND VGND VPWR VPWR sky130_fd_sc_hd__fill_2
XFILLER_0_102_15 VPWR VGND VPWR VGND sky130_ef_sc_hd__decap_12
XFILLER_0_63_292 VGND VGND VPWR VPWR sky130_fd_sc_hd__decap_4
XFILLER_0_11_57 VGND VGND VPWR VPWR sky130_fd_sc_hd__fill_2
XFILLER_0_11_68 VGND VGND VPWR VPWR sky130_fd_sc_hd__decap_4
XFILLER_0_3_529 VPWR VGND VPWR VGND sky130_ef_sc_hd__decap_12
XFILLER_0_11_318 VGND VGND VPWR VPWR sky130_fd_sc_hd__fill_1
X_4050_ u_sensor_interface.sensor_array\[0\]\[0\] u_sensor_interface.sensor_array\[1\]\[0\]
+ _1318_ VGND VGND VPWR VPWR _1378_ sky130_fd_sc_hd__mux2_1
Xinput6 cfg_addr[5] VGND VGND VPWR VPWR net6 sky130_fd_sc_hd__buf_2
XFILLER_0_78_329 VGND VGND VPWR VPWR sky130_fd_sc_hd__fill_2
XFILLER_0_86_351 VGND VGND VPWR VPWR sky130_fd_sc_hd__decap_4
X_7740_ u_register_bank.window_cfg\[22\] _3847_ _3848_ u_register_bank.threshold_cfg\[22\]
+ _3857_ VGND VGND VPWR VPWR _3858_ sky130_fd_sc_hd__a221o_1
X_4952_ net1138 _1726_ _1951_ VGND VGND VPWR VPWR _1964_ sky130_fd_sc_hd__mux2_1
X_7671_ _3803_ net143 _3782_ VGND VGND VPWR VPWR _3804_ sky130_fd_sc_hd__mux2_1
X_4883_ _1925_ VGND VGND VPWR VPWR _0335_ sky130_fd_sc_hd__clkbuf_1
X_6622_ u_input_buffer.rd_ptr\[4\] VGND VGND VPWR VPWR _2882_ sky130_fd_sc_hd__buf_2
XFILLER_0_104_309 VGND VGND VPWR VPWR sky130_fd_sc_hd__fill_1
X_6553_ _1632_ net846 _2824_ VGND VGND VPWR VPWR _2841_ sky130_fd_sc_hd__mux2_1
X_6484_ _2804_ VGND VGND VPWR VPWR _1057_ sky130_fd_sc_hd__clkbuf_1
X_5504_ net527 _2272_ _2243_ VGND VGND VPWR VPWR _2273_ sky130_fd_sc_hd__mux2_1
X_5435_ net288 _2000_ _2223_ VGND VGND VPWR VPWR _2229_ sky130_fd_sc_hd__mux2_1
X_8223_ clknet_leaf_23_clk _0312_ VGND VGND VPWR VPWR u_input_buffer.fifo_mem\[49\]\[5\]
+ sky130_fd_sc_hd__dfxtp_1
X_5366_ _2192_ VGND VGND VPWR VPWR _0551_ sky130_fd_sc_hd__clkbuf_1
X_8154_ clknet_leaf_1_clk _0243_ VGND VGND VPWR VPWR u_input_buffer.fifo_mem\[53\]\[0\]
+ sky130_fd_sc_hd__dfxtp_1
X_5297_ net292 _1998_ _2151_ VGND VGND VPWR VPWR _2156_ sky130_fd_sc_hd__mux2_1
X_7105_ u_input_buffer.fifo_mem\[26\]\[7\] _3066_ _3068_ u_input_buffer.fifo_mem\[62\]\[7\]
+ _3349_ VGND VGND VPWR VPWR _3350_ sky130_fd_sc_hd__a221o_1
X_4317_ u_input_buffer.wr_ptr\[0\] u_input_buffer.wr_ptr\[1\] _1595_ VGND VGND VPWR
+ VPWR _1596_ sky130_fd_sc_hd__and3b_4
X_8085_ clknet_leaf_81_clk _0174_ VGND VGND VPWR VPWR u_input_buffer.fifo_mem\[58\]\[11\]
+ sky130_fd_sc_hd__dfxtp_1
X_4248_ net164 _1529_ _1530_ VGND VGND VPWR VPWR _0095_ sky130_fd_sc_hd__a21oi_1
X_7036_ u_input_buffer.fifo_mem\[37\]\[6\] _2923_ _2926_ u_input_buffer.fifo_mem\[9\]\[6\]
+ VGND VGND VPWR VPWR _3282_ sky130_fd_sc_hd__a22o_1
X_4179_ u_sample_counter.sample_count\[6\] _1483_ VGND VGND VPWR VPWR _1485_ sky130_fd_sc_hd__or2_1
XFILLER_0_96_137 VGND VGND VPWR VPWR sky130_fd_sc_hd__decap_3
X_8987_ clknet_leaf_4_clk _1076_ VGND VGND VPWR VPWR u_input_buffer.fifo_mem\[1\]\[1\]
+ sky130_fd_sc_hd__dfxtp_1
XFILLER_0_77_351 VGND VGND VPWR VPWR sky130_fd_sc_hd__fill_2
XTAP_1038 VGND VPWR sky130_fd_sc_hd__tapvpwrvgnd_1
XTAP_1027 VGND VPWR sky130_fd_sc_hd__tapvpwrvgnd_1
XTAP_1016 VGND VPWR sky130_fd_sc_hd__tapvpwrvgnd_1
XTAP_1005 VGND VPWR sky130_fd_sc_hd__tapvpwrvgnd_1
X_7938_ clknet_leaf_104_clk _0028_ VGND VGND VPWR VPWR u_sensor_interface.sensor_array\[1\]\[10\]
+ sky130_fd_sc_hd__dfxtp_1
XTAP_1049 VGND VPWR sky130_fd_sc_hd__tapvpwrvgnd_1
X_7869_ _3934_ VGND VGND VPWR VPWR _1312_ sky130_fd_sc_hd__clkbuf_1
XFILLER_0_92_376 VGND VGND VPWR VPWR sky130_fd_sc_hd__fill_2
XFILLER_0_9_194 VGND VGND VPWR VPWR sky130_fd_sc_hd__fill_1
Xclkbuf_3_3__f_clk clknet_0_clk VGND VGND VPWR VPWR clknet_3_3__leaf_clk sky130_fd_sc_hd__clkbuf_16
XFILLER_0_45_270 VGND VGND VPWR VPWR sky130_fd_sc_hd__fill_1
XFILLER_0_115_191 VGND VGND VPWR VPWR sky130_fd_sc_hd__decap_4
XFILLER_0_103_353 VGND VGND VPWR VPWR sky130_fd_sc_hd__decap_8
XTAP_1550 VGND VPWR sky130_fd_sc_hd__tapvpwrvgnd_1
XFILLER_0_68_384 VGND VGND VPWR VPWR sky130_fd_sc_hd__decap_8
XTAP_1594 VGND VPWR sky130_fd_sc_hd__tapvpwrvgnd_1
XTAP_1583 VGND VPWR sky130_fd_sc_hd__tapvpwrvgnd_1
XTAP_1572 VGND VPWR sky130_fd_sc_hd__tapvpwrvgnd_1
XTAP_1561 VGND VPWR sky130_fd_sc_hd__tapvpwrvgnd_1
XFILLER_0_22_23 VGND VGND VPWR VPWR sky130_fd_sc_hd__decap_4
XPHY_90 VGND VGND VPWR VPWR sky130_fd_sc_hd__decap_3
XFILLER_0_36_281 VGND VGND VPWR VPWR sky130_fd_sc_hd__fill_1
XFILLER_0_98_27 VGND VGND VPWR VPWR sky130_fd_sc_hd__fill_1
XFILLER_0_51_240 VGND VGND VPWR VPWR sky130_fd_sc_hd__fill_2
XFILLER_0_3_337 VPWR VGND VPWR VGND sky130_ef_sc_hd__decap_12
X_5220_ _2114_ VGND VGND VPWR VPWR _2115_ sky130_fd_sc_hd__buf_4
X_5151_ _2077_ VGND VGND VPWR VPWR _2078_ sky130_fd_sc_hd__clkbuf_4
XFILLER_0_51_9 VGND VGND VPWR VPWR sky130_fd_sc_hd__decap_4
X_4102_ _1422_ u_sensor_interface.sensor_array\[2\]\[7\] _1379_ VGND VGND VPWR VPWR
+ _1423_ sky130_fd_sc_hd__mux2_1
X_5082_ _1702_ _1930_ VGND VGND VPWR VPWR _2041_ sky130_fd_sc_hd__nor2_4
X_4033_ _1368_ VGND VGND VPWR VPWR _0042_ sky130_fd_sc_hd__clkbuf_1
X_8910_ clknet_leaf_55_clk _0999_ VGND VGND VPWR VPWR u_input_buffer.fifo_mem\[6\]\[4\]
+ sky130_fd_sc_hd__dfxtp_1
XFILLER_0_47_86 VGND VGND VPWR VPWR sky130_fd_sc_hd__fill_2
XFILLER_0_47_97 VGND VGND VPWR VPWR sky130_fd_sc_hd__decap_4
XFILLER_0_79_605 VGND VGND VPWR VPWR sky130_fd_sc_hd__decap_6
X_8841_ clknet_leaf_98_clk _0930_ VGND VGND VPWR VPWR u_input_buffer.fifo_mem\[11\]\[15\]
+ sky130_fd_sc_hd__dfxtp_1
X_8772_ clknet_leaf_71_clk _0861_ VGND VGND VPWR VPWR u_input_buffer.fifo_mem\[15\]\[10\]
+ sky130_fd_sc_hd__dfxtp_1
XFILLER_0_2_77 VGND VGND VPWR VPWR sky130_fd_sc_hd__decap_6
XFILLER_0_87_671 VGND VGND VPWR VPWR sky130_fd_sc_hd__fill_1
X_5984_ _2537_ VGND VGND VPWR VPWR _0824_ sky130_fd_sc_hd__clkbuf_1
X_7723_ u_register_bank.status_flags\[19\] _3814_ _3843_ u_register_bank.sensor_enable\[19\]
+ VGND VGND VPWR VPWR _3844_ sky130_fd_sc_hd__a22o_1
X_4935_ _1955_ VGND VGND VPWR VPWR _0357_ sky130_fd_sc_hd__clkbuf_1
XANTENNA_11 u_sensor_interface.sensor_array\[2\]\[8\] VGND VGND VPWR VPWR sky130_fd_sc_hd__diode_2
X_4866_ net851 _1712_ _1912_ VGND VGND VPWR VPWR _1917_ sky130_fd_sc_hd__mux2_1
XFILLER_0_74_365 VGND VGND VPWR VPWR sky130_fd_sc_hd__fill_1
X_7654_ u_register_bank.window_cfg\[3\] _3772_ _3773_ u_analytics_engine.threshold\[3\]
+ _3790_ VGND VGND VPWR VPWR _3791_ sky130_fd_sc_hd__a221o_1
XANTENNA_22 net19 VGND VGND VPWR VPWR sky130_fd_sc_hd__diode_2
XANTENNA_33 net82 VGND VGND VPWR VPWR sky130_fd_sc_hd__diode_2
X_4797_ _1879_ VGND VGND VPWR VPWR _0295_ sky130_fd_sc_hd__clkbuf_1
X_7585_ _3747_ VGND VGND VPWR VPWR _1215_ sky130_fd_sc_hd__clkbuf_1
X_6605_ _2870_ _2868_ _1594_ VGND VGND VPWR VPWR _1112_ sky130_fd_sc_hd__o21ai_1
XFILLER_0_7_665 VGND VGND VPWR VPWR sky130_fd_sc_hd__decap_6
XFILLER_0_6_153 VGND VGND VPWR VPWR sky130_fd_sc_hd__fill_1
XANTENNA_44 _2897_ VGND VGND VPWR VPWR sky130_fd_sc_hd__diode_2
XANTENNA_55 net137 VGND VGND VPWR VPWR sky130_fd_sc_hd__diode_2
XFILLER_0_104_128 VGND VGND VPWR VPWR sky130_fd_sc_hd__fill_1
X_6536_ _2832_ VGND VGND VPWR VPWR _1081_ sky130_fd_sc_hd__clkbuf_1
XFILLER_0_113_673 VGND VGND VPWR VPWR sky130_fd_sc_hd__decap_4
X_6467_ net874 _1414_ _2789_ VGND VGND VPWR VPWR _2796_ sky130_fd_sc_hd__mux2_1
Xoutput140 net140 VGND VGND VPWR VPWR cfg_rdata[4] sky130_fd_sc_hd__clkbuf_4
XFILLER_0_112_172 VGND VGND VPWR VPWR sky130_fd_sc_hd__decap_6
X_9186_ clknet_leaf_39_clk _1274_ net194 VGND VGND VPWR VPWR net158 sky130_fd_sc_hd__dfrtp_2
X_8206_ clknet_leaf_39_clk _0295_ VGND VGND VPWR VPWR u_input_buffer.fifo_mem\[50\]\[4\]
+ sky130_fd_sc_hd__dfxtp_1
X_5418_ _2219_ VGND VGND VPWR VPWR _0576_ sky130_fd_sc_hd__clkbuf_1
Xoutput151 net151 VGND VGND VPWR VPWR processed_data_out[12] sky130_fd_sc_hd__buf_2
X_6398_ _2759_ VGND VGND VPWR VPWR _1016_ sky130_fd_sc_hd__clkbuf_1
X_5349_ net933 _2016_ _2168_ VGND VGND VPWR VPWR _2183_ sky130_fd_sc_hd__mux2_1
Xoutput162 net162 VGND VGND VPWR VPWR processed_data_out[8] sky130_fd_sc_hd__clkbuf_4
XFILLER_0_11_682 VGND VGND VPWR VPWR sky130_fd_sc_hd__decap_4
X_8137_ clknet_leaf_101_clk _0226_ VGND VGND VPWR VPWR u_input_buffer.fifo_mem\[55\]\[15\]
+ sky130_fd_sc_hd__dfxtp_1
X_8068_ clknet_leaf_86_clk _0157_ VGND VGND VPWR VPWR u_input_buffer.fifo_mem\[59\]\[10\]
+ sky130_fd_sc_hd__dfxtp_1
X_7019_ u_input_buffer.fifo_mem\[52\]\[5\] _3039_ _3041_ u_input_buffer.fifo_mem\[56\]\[5\]
+ VGND VGND VPWR VPWR _3266_ sky130_fd_sc_hd__a22o_1
Xclkbuf_leaf_50_clk clknet_3_7__leaf_clk VGND VGND VPWR VPWR clknet_leaf_50_clk sky130_fd_sc_hd__clkbuf_16
XFILLER_0_93_685 VGND VGND VPWR VPWR sky130_fd_sc_hd__fill_1
XFILLER_0_80_379 VGND VGND VPWR VPWR sky130_fd_sc_hd__fill_1
XFILLER_0_33_262 VGND VGND VPWR VPWR sky130_fd_sc_hd__fill_2
XFILLER_0_0_307 VGND VGND VPWR VPWR sky130_fd_sc_hd__fill_1
XFILLER_0_0_329 VGND VGND VPWR VPWR sky130_fd_sc_hd__decap_6
XTAP_608 VGND VPWR sky130_fd_sc_hd__tapvpwrvgnd_1
XTAP_619 VGND VPWR sky130_fd_sc_hd__tapvpwrvgnd_1
XFILLER_0_84_29 VPWR VGND VPWR VGND sky130_ef_sc_hd__decap_12
XFILLER_0_17_78 VGND VGND VPWR VPWR sky130_fd_sc_hd__decap_8
XFILLER_0_69_671 VGND VGND VPWR VPWR sky130_fd_sc_hd__fill_1
XFILLER_0_33_44 VGND VGND VPWR VPWR sky130_fd_sc_hd__decap_3
X_4720_ net882 _1706_ _1836_ VGND VGND VPWR VPWR _1838_ sky130_fd_sc_hd__mux2_1
XTAP_1391 VGND VPWR sky130_fd_sc_hd__tapvpwrvgnd_1
XTAP_1380 VGND VPWR sky130_fd_sc_hd__tapvpwrvgnd_1
Xclkbuf_leaf_41_clk clknet_3_4__leaf_clk VGND VGND VPWR VPWR clknet_leaf_41_clk sky130_fd_sc_hd__clkbuf_16
XFILLER_0_56_365 VGND VGND VPWR VPWR sky130_fd_sc_hd__fill_2
XFILLER_0_29_557 VGND VGND VPWR VPWR sky130_fd_sc_hd__decap_3
X_4651_ _1800_ VGND VGND VPWR VPWR _0228_ sky130_fd_sc_hd__clkbuf_1
Xinput20 cfg_wdata[17] VGND VGND VPWR VPWR net20 sky130_fd_sc_hd__clkbuf_4
XFILLER_0_71_335 VGND VGND VPWR VPWR sky130_fd_sc_hd__fill_1
Xinput31 cfg_wdata[27] VGND VGND VPWR VPWR net31 sky130_fd_sc_hd__buf_2
XFILLER_0_4_613 VPWR VGND VPWR VGND sky130_ef_sc_hd__decap_12
Xinput42 cfg_wdata[8] VGND VGND VPWR VPWR net42 sky130_fd_sc_hd__clkbuf_2
Xinput53 sensor_data_in[16] VGND VGND VPWR VPWR net53 sky130_fd_sc_hd__clkbuf_1
X_4582_ _1761_ VGND VGND VPWR VPWR _0198_ sky130_fd_sc_hd__clkbuf_1
XFILLER_0_4_657 VPWR VGND VPWR VGND sky130_ef_sc_hd__decap_12
Xinput64 sensor_data_in[26] VGND VGND VPWR VPWR net64 sky130_fd_sc_hd__clkbuf_1
X_7370_ u_input_buffer.fifo_mem\[52\]\[14\] _3038_ _3040_ u_input_buffer.fifo_mem\[56\]\[14\]
+ VGND VGND VPWR VPWR _3608_ sky130_fd_sc_hd__a22o_1
Xinput97 sensor_data_in[56] VGND VGND VPWR VPWR net97 sky130_fd_sc_hd__clkbuf_2
X_6321_ net1208 _2500_ _2717_ VGND VGND VPWR VPWR _2719_ sky130_fd_sc_hd__mux2_1
Xhold804 u_input_buffer.fifo_mem\[18\]\[1\] VGND VGND VPWR VPWR net1016 sky130_fd_sc_hd__dlygate4sd3_1
Xhold826 u_input_buffer.fifo_mem\[26\]\[5\] VGND VGND VPWR VPWR net1038 sky130_fd_sc_hd__dlygate4sd3_1
Xhold837 u_input_buffer.fifo_mem\[37\]\[8\] VGND VGND VPWR VPWR net1049 sky130_fd_sc_hd__dlygate4sd3_1
Xhold815 u_input_buffer.fifo_mem\[62\]\[9\] VGND VGND VPWR VPWR net1027 sky130_fd_sc_hd__dlygate4sd3_1
Xinput86 sensor_data_in[46] VGND VGND VPWR VPWR net86 sky130_fd_sc_hd__clkbuf_1
Xinput75 sensor_data_in[36] VGND VGND VPWR VPWR net75 sky130_fd_sc_hd__clkbuf_1
Xhold859 u_input_buffer.fifo_mem\[32\]\[6\] VGND VGND VPWR VPWR net1071 sky130_fd_sc_hd__dlygate4sd3_1
X_9040_ clknet_leaf_70_clk _1129_ VGND VGND VPWR VPWR u_analytics_engine.data_in\[3\]
+ sky130_fd_sc_hd__dfxtp_2
X_6252_ _1604_ net1265 _2680_ VGND VGND VPWR VPWR _2682_ sky130_fd_sc_hd__mux2_1
Xhold848 u_input_buffer.fifo_mem\[1\]\[13\] VGND VGND VPWR VPWR net1060 sky130_fd_sc_hd__dlygate4sd3_1
X_5203_ net817 _2006_ _2097_ VGND VGND VPWR VPWR _2106_ sky130_fd_sc_hd__mux2_1
X_6183_ _2645_ VGND VGND VPWR VPWR _0915_ sky130_fd_sc_hd__clkbuf_1
X_5134_ _1427_ net975 _2060_ VGND VGND VPWR VPWR _2069_ sky130_fd_sc_hd__mux2_1
X_5065_ _2032_ VGND VGND VPWR VPWR _0410_ sky130_fd_sc_hd__clkbuf_1
X_4016_ _1359_ VGND VGND VPWR VPWR _0034_ sky130_fd_sc_hd__clkbuf_1
XFILLER_0_28_3 VGND VGND VPWR VPWR sky130_fd_sc_hd__decap_6
XFILLER_0_79_446 VGND VGND VPWR VPWR sky130_fd_sc_hd__fill_2
XFILLER_0_67_608 VGND VGND VPWR VPWR sky130_fd_sc_hd__decap_3
X_8824_ clknet_leaf_12_clk _0913_ VGND VGND VPWR VPWR u_input_buffer.fifo_mem\[12\]\[14\]
+ sky130_fd_sc_hd__dfxtp_1
XFILLER_0_75_641 VGND VGND VPWR VPWR sky130_fd_sc_hd__decap_8
X_8755_ clknet_leaf_15_clk _0844_ VGND VGND VPWR VPWR u_input_buffer.fifo_mem\[16\]\[9\]
+ sky130_fd_sc_hd__dfxtp_1
XFILLER_0_47_332 VGND VGND VPWR VPWR sky130_fd_sc_hd__fill_1
X_5967_ _2527_ VGND VGND VPWR VPWR _0817_ sky130_fd_sc_hd__clkbuf_1
Xclkbuf_leaf_32_clk clknet_3_5__leaf_clk VGND VGND VPWR VPWR clknet_leaf_32_clk sky130_fd_sc_hd__clkbuf_16
X_8686_ clknet_leaf_49_clk _0775_ VGND VGND VPWR VPWR u_input_buffer.fifo_mem\[20\]\[4\]
+ sky130_fd_sc_hd__dfxtp_1
XFILLER_0_74_151 VGND VGND VPWR VPWR sky130_fd_sc_hd__fill_1
X_7706_ u_register_bank.status_flags\[15\] _3814_ _3808_ u_register_bank.sensor_enable\[15\]
+ VGND VGND VPWR VPWR _3831_ sky130_fd_sc_hd__a22o_1
X_4918_ net564 _1726_ _1933_ VGND VGND VPWR VPWR _1946_ sky130_fd_sc_hd__mux2_1
X_5898_ _2484_ VGND VGND VPWR VPWR _0791_ sky130_fd_sc_hd__clkbuf_1
X_7637_ _3776_ VGND VGND VPWR VPWR _3777_ sky130_fd_sc_hd__clkbuf_2
X_4849_ _1457_ net1198 _1892_ VGND VGND VPWR VPWR _1907_ sky130_fd_sc_hd__mux2_1
X_7568_ net23 u_analytics_engine.threshold\[1\] _3737_ VGND VGND VPWR VPWR _3739_
+ sky130_fd_sc_hd__mux2_1
X_7499_ net23 u_register_bank.window_cfg\[1\] _3700_ VGND VGND VPWR VPWR _3702_ sky130_fd_sc_hd__mux2_1
X_6519_ net340 _1468_ _2806_ VGND VGND VPWR VPWR _2823_ sky130_fd_sc_hd__mux2_1
X_9169_ net168 _1257_ VGND VGND VPWR VPWR net124 sky130_fd_sc_hd__dfxtp_1
Xclkbuf_leaf_99_clk clknet_3_0__leaf_clk VGND VGND VPWR VPWR clknet_leaf_99_clk sky130_fd_sc_hd__clkbuf_16
XFILLER_0_100_197 VGND VGND VPWR VPWR sky130_fd_sc_hd__decap_4
XFILLER_0_97_210 VGND VGND VPWR VPWR sky130_fd_sc_hd__decap_4
XFILLER_0_85_449 VGND VGND VPWR VPWR sky130_fd_sc_hd__decap_4
XFILLER_0_38_321 VGND VGND VPWR VPWR sky130_fd_sc_hd__decap_3
Xclkbuf_leaf_23_clk clknet_3_4__leaf_clk VGND VGND VPWR VPWR clknet_leaf_23_clk sky130_fd_sc_hd__clkbuf_16
XFILLER_0_108_253 VGND VGND VPWR VPWR sky130_fd_sc_hd__decap_4
XFILLER_0_65_195 VGND VGND VPWR VPWR sky130_fd_sc_hd__fill_1
XFILLER_0_80_154 VGND VGND VPWR VPWR sky130_fd_sc_hd__decap_3
XFILLER_0_34_593 VGND VGND VPWR VPWR sky130_fd_sc_hd__fill_1
XFILLER_0_95_39 VPWR VGND VPWR VGND sky130_ef_sc_hd__decap_12
XTAP_405 VGND VPWR sky130_fd_sc_hd__tapvpwrvgnd_1
XFILLER_0_0_137 VGND VGND VPWR VPWR sky130_fd_sc_hd__decap_3
XTAP_416 VGND VPWR sky130_fd_sc_hd__tapvpwrvgnd_1
XTAP_427 VGND VPWR sky130_fd_sc_hd__tapvpwrvgnd_1
XTAP_438 VGND VPWR sky130_fd_sc_hd__tapvpwrvgnd_1
XTAP_449 VGND VPWR sky130_fd_sc_hd__tapvpwrvgnd_1
XFILLER_0_28_22 VGND VGND VPWR VPWR sky130_fd_sc_hd__decap_6
XFILLER_0_14_9 VPWR VGND VPWR VGND sky130_ef_sc_hd__decap_12
X_6870_ u_input_buffer.fifo_mem\[3\]\[1\] _3070_ _3072_ u_input_buffer.fifo_mem\[60\]\[1\]
+ VGND VGND VPWR VPWR _3121_ sky130_fd_sc_hd__a22o_1
X_5821_ _1588_ net1203 _2443_ VGND VGND VPWR VPWR _2444_ sky130_fd_sc_hd__mux2_1
X_5752_ _2406_ VGND VGND VPWR VPWR _2407_ sky130_fd_sc_hd__buf_4
X_8540_ clknet_leaf_3_clk _0629_ VGND VGND VPWR VPWR u_input_buffer.fifo_mem\[29\]\[2\]
+ sky130_fd_sc_hd__dfxtp_1
Xclkbuf_leaf_14_clk clknet_3_4__leaf_clk VGND VGND VPWR VPWR clknet_leaf_14_clk sky130_fd_sc_hd__clkbuf_16
X_4703_ _1439_ net987 _1816_ VGND VGND VPWR VPWR _1828_ sky130_fd_sc_hd__mux2_1
XFILLER_0_17_538 VGND VGND VPWR VPWR sky130_fd_sc_hd__fill_1
XFILLER_0_84_493 VGND VGND VPWR VPWR sky130_fd_sc_hd__decap_3
X_5683_ _2369_ VGND VGND VPWR VPWR _2370_ sky130_fd_sc_hd__buf_4
X_8471_ clknet_leaf_8_clk _0560_ VGND VGND VPWR VPWR u_input_buffer.fifo_mem\[34\]\[13\]
+ sky130_fd_sc_hd__dfxtp_1
X_4634_ net844 _1726_ _1777_ VGND VGND VPWR VPWR _1790_ sky130_fd_sc_hd__mux2_1
X_7422_ net280 _3085_ _3087_ VGND VGND VPWR VPWR _3659_ sky130_fd_sc_hd__o21a_1
X_4565_ _1751_ VGND VGND VPWR VPWR _0191_ sky130_fd_sc_hd__clkbuf_1
X_7353_ u_input_buffer.fifo_mem\[1\]\[14\] _2931_ _3588_ _3590_ VGND VGND VPWR VPWR
+ _3591_ sky130_fd_sc_hd__a211o_1
XFILLER_0_25_582 VGND VGND VPWR VPWR sky130_fd_sc_hd__decap_6
Xhold612 u_input_buffer.fifo_mem\[1\]\[0\] VGND VGND VPWR VPWR net824 sky130_fd_sc_hd__dlygate4sd3_1
Xhold601 u_input_buffer.fifo_mem\[1\]\[9\] VGND VGND VPWR VPWR net813 sky130_fd_sc_hd__dlygate4sd3_1
Xhold645 u_input_buffer.fifo_mem\[56\]\[2\] VGND VGND VPWR VPWR net857 sky130_fd_sc_hd__dlygate4sd3_1
Xhold634 u_input_buffer.fifo_mem\[1\]\[15\] VGND VGND VPWR VPWR net846 sky130_fd_sc_hd__dlygate4sd3_1
Xhold623 u_input_buffer.fifo_mem\[11\]\[15\] VGND VGND VPWR VPWR net835 sky130_fd_sc_hd__dlygate4sd3_1
X_6304_ net313 _2518_ _2697_ VGND VGND VPWR VPWR _2709_ sky130_fd_sc_hd__mux2_1
X_4496_ net806 _1708_ _1704_ VGND VGND VPWR VPWR _1709_ sky130_fd_sc_hd__mux2_1
Xhold667 u_input_buffer.fifo_mem\[27\]\[6\] VGND VGND VPWR VPWR net879 sky130_fd_sc_hd__dlygate4sd3_1
X_9023_ clknet_leaf_87_clk _1112_ net189 VGND VGND VPWR VPWR u_input_buffer.count\[5\]
+ sky130_fd_sc_hd__dfrtp_1
Xhold656 u_input_buffer.fifo_mem\[61\]\[15\] VGND VGND VPWR VPWR net868 sky130_fd_sc_hd__dlygate4sd3_1
Xhold678 u_input_buffer.fifo_mem\[8\]\[14\] VGND VGND VPWR VPWR net890 sky130_fd_sc_hd__dlygate4sd3_1
X_7284_ _3517_ _3519_ _3521_ _3523_ VGND VGND VPWR VPWR _3524_ sky130_fd_sc_hd__or4_1
X_6235_ _2672_ VGND VGND VPWR VPWR _0940_ sky130_fd_sc_hd__clkbuf_1
XFILLER_0_0_671 VGND VGND VPWR VPWR sky130_fd_sc_hd__fill_1
Xhold689 u_input_buffer.fifo_mem\[7\]\[12\] VGND VGND VPWR VPWR net901 sky130_fd_sc_hd__dlygate4sd3_1
XFILLER_0_85_50 VGND VGND VPWR VPWR sky130_fd_sc_hd__decap_3
X_6166_ _2635_ VGND VGND VPWR VPWR _0908_ sky130_fd_sc_hd__clkbuf_1
XTAP_961 VGND VPWR sky130_fd_sc_hd__tapvpwrvgnd_1
XTAP_950 VGND VPWR sky130_fd_sc_hd__tapvpwrvgnd_1
XFILLER_0_85_94 VGND VGND VPWR VPWR sky130_fd_sc_hd__fill_1
XTAP_994 VGND VPWR sky130_fd_sc_hd__tapvpwrvgnd_1
XTAP_983 VGND VPWR sky130_fd_sc_hd__tapvpwrvgnd_1
XTAP_972 VGND VPWR sky130_fd_sc_hd__tapvpwrvgnd_1
X_6097_ net1202 _2518_ _2586_ VGND VGND VPWR VPWR _2598_ sky130_fd_sc_hd__mux2_1
X_5117_ _2059_ VGND VGND VPWR VPWR _2060_ sky130_fd_sc_hd__buf_4
X_5048_ _2022_ VGND VGND VPWR VPWR _2023_ sky130_fd_sc_hd__clkbuf_4
XFILLER_0_79_210 VGND VGND VPWR VPWR sky130_fd_sc_hd__decap_6
X_8807_ clknet_leaf_109_clk _0896_ VGND VGND VPWR VPWR u_input_buffer.fifo_mem\[13\]\[13\]
+ sky130_fd_sc_hd__dfxtp_1
XFILLER_0_82_408 VGND VGND VPWR VPWR sky130_fd_sc_hd__fill_1
X_8738_ clknet_leaf_0_clk _0827_ VGND VGND VPWR VPWR u_input_buffer.fifo_mem\[17\]\[8\]
+ sky130_fd_sc_hd__dfxtp_1
X_6999_ u_input_buffer.fifo_mem\[53\]\[5\] _2934_ _2936_ u_input_buffer.fifo_mem\[57\]\[5\]
+ VGND VGND VPWR VPWR _3246_ sky130_fd_sc_hd__a22o_1
X_8669_ clknet_leaf_5_clk _0758_ VGND VGND VPWR VPWR u_input_buffer.fifo_mem\[21\]\[3\]
+ sky130_fd_sc_hd__dfxtp_1
XFILLER_0_23_519 VGND VGND VPWR VPWR sky130_fd_sc_hd__fill_1
XFILLER_0_98_541 VGND VGND VPWR VPWR sky130_fd_sc_hd__fill_2
XFILLER_0_105_15 VPWR VGND VPWR VGND sky130_ef_sc_hd__decap_12
XFILLER_0_58_405 VGND VGND VPWR VPWR sky130_fd_sc_hd__fill_1
XFILLER_0_85_279 VGND VGND VPWR VPWR sky130_fd_sc_hd__fill_1
XFILLER_0_39_685 VGND VGND VPWR VPWR sky130_fd_sc_hd__fill_1
XFILLER_0_54_622 VGND VGND VPWR VPWR sky130_fd_sc_hd__fill_1
XFILLER_0_53_143 VGND VGND VPWR VPWR sky130_fd_sc_hd__fill_2
XFILLER_0_53_154 VGND VGND VPWR VPWR sky130_fd_sc_hd__fill_2
X_4350_ u_input_buffer.data_in\[9\] VGND VGND VPWR VPWR _1620_ sky130_fd_sc_hd__clkbuf_4
XFILLER_0_1_402 VPWR VGND VPWR VGND sky130_ef_sc_hd__decap_12
XFILLER_0_111_259 VGND VGND VPWR VPWR sky130_fd_sc_hd__fill_2
XFILLER_0_111_237 VGND VGND VPWR VPWR sky130_fd_sc_hd__fill_2
XFILLER_0_22_596 VGND VGND VPWR VPWR sky130_fd_sc_hd__decap_4
X_4281_ u_analytics_engine.threshold\[7\] _1559_ _1560_ u_analytics_engine.threshold\[6\]
+ VGND VGND VPWR VPWR _1561_ sky130_fd_sc_hd__o22a_1
X_6020_ _2556_ VGND VGND VPWR VPWR _0841_ sky130_fd_sc_hd__clkbuf_1
XTAP_235 VGND VPWR sky130_fd_sc_hd__tapvpwrvgnd_1
XTAP_257 VGND VPWR sky130_fd_sc_hd__tapvpwrvgnd_1
XTAP_246 VGND VPWR sky130_fd_sc_hd__tapvpwrvgnd_1
Xclkbuf_leaf_3_clk clknet_3_1__leaf_clk VGND VGND VPWR VPWR clknet_leaf_3_clk sky130_fd_sc_hd__clkbuf_16
XTAP_268 VGND VPWR sky130_fd_sc_hd__tapvpwrvgnd_1
XTAP_279 VGND VPWR sky130_fd_sc_hd__tapvpwrvgnd_1
X_7971_ clknet_leaf_108_clk _0061_ net184 VGND VGND VPWR VPWR u_input_buffer.data_in\[11\]
+ sky130_fd_sc_hd__dfrtp_1
X_6922_ u_input_buffer.fifo_mem\[17\]\[3\] _2943_ _2945_ u_input_buffer.fifo_mem\[5\]\[3\]
+ VGND VGND VPWR VPWR _3171_ sky130_fd_sc_hd__a22o_1
X_6853_ u_input_buffer.fifo_mem\[50\]\[1\] _2995_ _2997_ u_input_buffer.fifo_mem\[4\]\[1\]
+ VGND VGND VPWR VPWR _3104_ sky130_fd_sc_hd__a22o_1
XFILLER_0_64_408 VGND VGND VPWR VPWR sky130_fd_sc_hd__decap_3
X_5804_ _2434_ VGND VGND VPWR VPWR _0747_ sky130_fd_sc_hd__clkbuf_1
X_3996_ u_sensor_interface.sensor_array\[1\]\[7\] net61 _1345_ VGND VGND VPWR VPWR
+ _1349_ sky130_fd_sc_hd__mux2_1
X_6784_ _2906_ _2978_ VGND VGND VPWR VPWR _3036_ sky130_fd_sc_hd__nor2_2
X_8523_ clknet_leaf_54_clk _0612_ VGND VGND VPWR VPWR u_input_buffer.fifo_mem\[30\]\[1\]
+ sky130_fd_sc_hd__dfxtp_1
X_5735_ _2397_ VGND VGND VPWR VPWR _0715_ sky130_fd_sc_hd__clkbuf_1
XFILLER_0_115_510 VGND VGND VPWR VPWR sky130_fd_sc_hd__decap_8
XFILLER_0_95_3 VPWR VGND VPWR VGND sky130_ef_sc_hd__decap_12
X_5666_ net999 _2260_ _2352_ VGND VGND VPWR VPWR _2361_ sky130_fd_sc_hd__mux2_1
X_8454_ clknet_leaf_11_clk _0543_ VGND VGND VPWR VPWR u_input_buffer.fifo_mem\[35\]\[12\]
+ sky130_fd_sc_hd__dfxtp_1
X_4617_ _1781_ VGND VGND VPWR VPWR _0213_ sky130_fd_sc_hd__clkbuf_1
X_7405_ u_input_buffer.fifo_mem\[31\]\[15\] _3016_ _3019_ u_input_buffer.fifo_mem\[38\]\[15\]
+ VGND VGND VPWR VPWR _3642_ sky130_fd_sc_hd__a22o_1
X_8385_ clknet_leaf_50_clk _0474_ VGND VGND VPWR VPWR u_input_buffer.fifo_mem\[39\]\[7\]
+ sky130_fd_sc_hd__dfxtp_1
X_5597_ net794 _2260_ _2315_ VGND VGND VPWR VPWR _2324_ sky130_fd_sc_hd__mux2_1
Xhold420 u_input_buffer.fifo_mem\[12\]\[14\] VGND VGND VPWR VPWR net632 sky130_fd_sc_hd__dlygate4sd3_1
Xhold453 u_input_buffer.fifo_mem\[14\]\[7\] VGND VGND VPWR VPWR net665 sky130_fd_sc_hd__dlygate4sd3_1
Xhold431 u_input_buffer.fifo_mem\[8\]\[0\] VGND VGND VPWR VPWR net643 sky130_fd_sc_hd__dlygate4sd3_1
XFILLER_0_13_585 VGND VGND VPWR VPWR sky130_fd_sc_hd__decap_8
Xhold442 u_input_buffer.fifo_mem\[24\]\[11\] VGND VGND VPWR VPWR net654 sky130_fd_sc_hd__dlygate4sd3_1
X_4548_ _1403_ net1146 _1738_ VGND VGND VPWR VPWR _1743_ sky130_fd_sc_hd__mux2_1
X_7336_ u_input_buffer.fifo_mem\[15\]\[13\] _3059_ _3061_ u_input_buffer.fifo_mem\[43\]\[13\]
+ VGND VGND VPWR VPWR _3575_ sky130_fd_sc_hd__a22o_1
Xhold475 u_input_buffer.fifo_mem\[35\]\[8\] VGND VGND VPWR VPWR net687 sky130_fd_sc_hd__dlygate4sd3_1
Xhold486 u_input_buffer.fifo_mem\[43\]\[8\] VGND VGND VPWR VPWR net698 sky130_fd_sc_hd__dlygate4sd3_1
Xhold464 u_input_buffer.fifo_mem\[27\]\[3\] VGND VGND VPWR VPWR net676 sky130_fd_sc_hd__dlygate4sd3_1
X_4479_ net1315 _1628_ _1682_ VGND VGND VPWR VPWR _1697_ sky130_fd_sc_hd__mux2_1
X_7267_ net713 _2892_ _3506_ _3507_ VGND VGND VPWR VPWR _1137_ sky130_fd_sc_hd__a22o_1
XFILLER_0_110_270 VGND VGND VPWR VPWR sky130_fd_sc_hd__fill_2
X_6218_ net351 _2500_ _2662_ VGND VGND VPWR VPWR _2664_ sky130_fd_sc_hd__mux2_1
X_9006_ clknet_leaf_48_clk _1095_ VGND VGND VPWR VPWR u_input_buffer.fifo_mem\[0\]\[4\]
+ sky130_fd_sc_hd__dfxtp_1
Xhold497 u_input_buffer.fifo_mem\[3\]\[1\] VGND VGND VPWR VPWR net709 sky130_fd_sc_hd__dlygate4sd3_1
X_7198_ u_input_buffer.fifo_mem\[14\]\[10\] _2957_ _2960_ u_input_buffer.fifo_mem\[42\]\[10\]
+ VGND VGND VPWR VPWR _3440_ sky130_fd_sc_hd__a22o_1
X_6149_ net684 _2500_ _2625_ VGND VGND VPWR VPWR _2627_ sky130_fd_sc_hd__mux2_1
XTAP_780 VGND VPWR sky130_fd_sc_hd__tapvpwrvgnd_1
XTAP_791 VGND VPWR sky130_fd_sc_hd__tapvpwrvgnd_1
XFILLER_0_36_600 VGND VGND VPWR VPWR sky130_fd_sc_hd__fill_1
XFILLER_0_36_611 VGND VGND VPWR VPWR sky130_fd_sc_hd__fill_1
XFILLER_0_51_603 VPWR VGND VPWR VGND sky130_ef_sc_hd__decap_12
XFILLER_0_106_587 VGND VGND VPWR VPWR sky130_fd_sc_hd__fill_1
XFILLER_0_51_658 VGND VGND VPWR VPWR sky130_fd_sc_hd__fill_1
XFILLER_0_31_382 VGND VGND VPWR VPWR sky130_fd_sc_hd__fill_2
XFILLER_0_92_29 VPWR VGND VPWR VGND sky130_ef_sc_hd__decap_12
XFILLER_0_46_419 VGND VGND VPWR VPWR sky130_fd_sc_hd__fill_1
XFILLER_0_41_33 VGND VGND VPWR VPWR sky130_fd_sc_hd__fill_1
XFILLER_0_41_44 VGND VGND VPWR VPWR sky130_fd_sc_hd__fill_2
XFILLER_0_41_55 VGND VGND VPWR VPWR sky130_fd_sc_hd__fill_1
XFILLER_0_41_66 VGND VGND VPWR VPWR sky130_fd_sc_hd__fill_1
XFILLER_0_109_370 VGND VGND VPWR VPWR sky130_fd_sc_hd__fill_2
X_5520_ _2282_ VGND VGND VPWR VPWR _0615_ sky130_fd_sc_hd__clkbuf_1
XFILLER_0_54_474 VGND VGND VPWR VPWR sky130_fd_sc_hd__fill_2
XFILLER_0_41_135 VGND VGND VPWR VPWR sky130_fd_sc_hd__fill_1
X_5451_ net386 _2016_ _2222_ VGND VGND VPWR VPWR _2237_ sky130_fd_sc_hd__mux2_1
X_8170_ clknet_leaf_52_clk _0259_ VGND VGND VPWR VPWR u_input_buffer.fifo_mem\[52\]\[0\]
+ sky130_fd_sc_hd__dfxtp_1
X_4402_ _1653_ VGND VGND VPWR VPWR _0126_ sky130_fd_sc_hd__clkbuf_1
X_5382_ _2200_ VGND VGND VPWR VPWR _0559_ sky130_fd_sc_hd__clkbuf_1
X_7121_ u_input_buffer.fifo_mem\[36\]\[8\] _2951_ _2955_ u_input_buffer.fifo_mem\[35\]\[8\]
+ _3364_ VGND VGND VPWR VPWR _3365_ sky130_fd_sc_hd__a221o_1
X_4333_ net298 _1608_ _1602_ VGND VGND VPWR VPWR _1609_ sky130_fd_sc_hd__mux2_1
XFILLER_0_10_533 VPWR VGND VPWR VGND sky130_ef_sc_hd__decap_12
XFILLER_0_22_382 VGND VGND VPWR VPWR sky130_fd_sc_hd__fill_1
X_7052_ u_input_buffer.fifo_mem\[47\]\[6\] _2880_ _3007_ _3009_ u_input_buffer.fifo_mem\[24\]\[6\]
+ VGND VGND VPWR VPWR _3298_ sky130_fd_sc_hd__a32o_1
X_4264_ _1542_ u_analytics_engine.data_in\[11\] u_analytics_engine.data_in\[10\] _1543_
+ VGND VGND VPWR VPWR _1544_ sky130_fd_sc_hd__a22o_1
Xfanout207 net212 VGND VGND VPWR VPWR net207 sky130_fd_sc_hd__clkbuf_4
X_6003_ _1632_ net1167 _2530_ VGND VGND VPWR VPWR _2547_ sky130_fd_sc_hd__mux2_1
XFILLER_0_66_85 VGND VGND VPWR VPWR sky130_fd_sc_hd__decap_6
X_4195_ _1494_ _1495_ VGND VGND VPWR VPWR _1496_ sky130_fd_sc_hd__and2b_1
X_7954_ clknet_leaf_32_clk _0044_ VGND VGND VPWR VPWR u_sensor_interface.sensor_array\[0\]\[10\]
+ sky130_fd_sc_hd__dfxtp_2
X_6905_ u_input_buffer.fifo_mem\[39\]\[2\] _3050_ _3052_ u_input_buffer.fifo_mem\[40\]\[2\]
+ VGND VGND VPWR VPWR _3155_ sky130_fd_sc_hd__a22o_1
XTAP_1209 VGND VPWR sky130_fd_sc_hd__tapvpwrvgnd_1
XFILLER_0_10_3 VPWR VGND VPWR VGND sky130_ef_sc_hd__decap_12
X_7885_ clknet_leaf_58_clk net214 net198 VGND VGND VPWR VPWR u_register_bank.status_flags\[5\]
+ sky130_fd_sc_hd__dfrtp_1
X_6836_ _3087_ VGND VGND VPWR VPWR _3088_ sky130_fd_sc_hd__clkbuf_4
XFILLER_0_92_558 VGND VGND VPWR VPWR sky130_fd_sc_hd__fill_2
X_6767_ _2917_ _3018_ VGND VGND VPWR VPWR _3019_ sky130_fd_sc_hd__and2_2
X_8506_ clknet_leaf_53_clk _0595_ VGND VGND VPWR VPWR u_input_buffer.fifo_mem\[31\]\[0\]
+ sky130_fd_sc_hd__dfxtp_1
X_5718_ net394 _2240_ _2388_ VGND VGND VPWR VPWR _2389_ sky130_fd_sc_hd__mux2_1
X_3979_ net621 net87 _1334_ VGND VGND VPWR VPWR _1340_ sky130_fd_sc_hd__mux2_1
XFILLER_0_17_198 VGND VGND VPWR VPWR sky130_fd_sc_hd__fill_2
X_6698_ _2896_ _2949_ VGND VGND VPWR VPWR _2950_ sky130_fd_sc_hd__nor2_4
XFILLER_0_103_513 VGND VGND VPWR VPWR sky130_fd_sc_hd__decap_3
X_5649_ _2351_ VGND VGND VPWR VPWR _2352_ sky130_fd_sc_hd__clkbuf_4
XFILLER_0_32_157 VGND VGND VPWR VPWR sky130_fd_sc_hd__fill_2
XFILLER_0_33_658 VGND VGND VPWR VPWR sky130_fd_sc_hd__decap_8
X_8437_ clknet_leaf_10_clk _0526_ VGND VGND VPWR VPWR u_input_buffer.fifo_mem\[36\]\[11\]
+ sky130_fd_sc_hd__dfxtp_1
X_8368_ clknet_leaf_51_clk _0457_ VGND VGND VPWR VPWR u_input_buffer.fifo_mem\[40\]\[6\]
+ sky130_fd_sc_hd__dfxtp_1
Xhold250 u_input_buffer.fifo_mem\[58\]\[10\] VGND VGND VPWR VPWR net462 sky130_fd_sc_hd__dlygate4sd3_1
Xhold261 u_input_buffer.fifo_mem\[50\]\[11\] VGND VGND VPWR VPWR net473 sky130_fd_sc_hd__dlygate4sd3_1
X_7319_ u_input_buffer.fifo_mem\[2\]\[13\] _2983_ _2985_ u_input_buffer.fifo_mem\[32\]\[13\]
+ VGND VGND VPWR VPWR _3558_ sky130_fd_sc_hd__a22o_1
X_8299_ clknet_leaf_33_clk _0388_ VGND VGND VPWR VPWR u_input_buffer.fifo_mem\[44\]\[1\]
+ sky130_fd_sc_hd__dfxtp_1
Xhold283 u_input_buffer.fifo_mem\[45\]\[0\] VGND VGND VPWR VPWR net495 sky130_fd_sc_hd__dlygate4sd3_1
XFILLER_0_1_6 VPWR VGND VPWR VGND sky130_ef_sc_hd__decap_12
Xhold294 u_input_buffer.fifo_mem\[38\]\[12\] VGND VGND VPWR VPWR net506 sky130_fd_sc_hd__dlygate4sd3_1
Xhold272 u_input_buffer.fifo_mem\[56\]\[13\] VGND VGND VPWR VPWR net484 sky130_fd_sc_hd__dlygate4sd3_1
XFILLER_0_83_558 VGND VGND VPWR VPWR sky130_fd_sc_hd__fill_2
XFILLER_0_102_27 VGND VGND VPWR VPWR sky130_fd_sc_hd__fill_1
Xinput7 cfg_addr[6] VGND VGND VPWR VPWR net7 sky130_fd_sc_hd__clkbuf_4
X_4951_ _1963_ VGND VGND VPWR VPWR _0365_ sky130_fd_sc_hd__clkbuf_1
X_7670_ u_register_bank.window_cfg\[7\] _3772_ _3773_ u_analytics_engine.threshold\[7\]
+ _3802_ VGND VGND VPWR VPWR _3803_ sky130_fd_sc_hd__a221o_1
X_4882_ net941 _1728_ _1911_ VGND VGND VPWR VPWR _1925_ sky130_fd_sc_hd__mux2_1
X_6621_ _2861_ _2880_ _2881_ _2877_ VGND VGND VPWR VPWR _1117_ sky130_fd_sc_hd__o2bb2a_1
XFILLER_0_27_463 VGND VGND VPWR VPWR sky130_fd_sc_hd__fill_2
X_6552_ _2840_ VGND VGND VPWR VPWR _1089_ sky130_fd_sc_hd__clkbuf_1
XFILLER_0_15_614 VGND VGND VPWR VPWR sky130_fd_sc_hd__fill_2
X_5503_ _1462_ VGND VGND VPWR VPWR _2272_ sky130_fd_sc_hd__clkbuf_4
X_6483_ net1182 _1462_ _2788_ VGND VGND VPWR VPWR _2804_ sky130_fd_sc_hd__mux2_1
XFILLER_0_15_647 VGND VGND VPWR VPWR sky130_fd_sc_hd__fill_1
X_5434_ _2228_ VGND VGND VPWR VPWR _0583_ sky130_fd_sc_hd__clkbuf_1
X_8222_ clknet_leaf_23_clk _0311_ VGND VGND VPWR VPWR u_input_buffer.fifo_mem\[49\]\[4\]
+ sky130_fd_sc_hd__dfxtp_1
XFILLER_0_2_530 VGND VGND VPWR VPWR sky130_fd_sc_hd__fill_2
XFILLER_0_112_365 VGND VGND VPWR VPWR sky130_fd_sc_hd__decap_6
X_8153_ clknet_leaf_102_clk _0242_ VGND VGND VPWR VPWR u_input_buffer.fifo_mem\[54\]\[15\]
+ sky130_fd_sc_hd__dfxtp_1
X_7104_ u_input_buffer.fifo_mem\[3\]\[7\] _3070_ _3072_ u_input_buffer.fifo_mem\[60\]\[7\]
+ VGND VGND VPWR VPWR _3349_ sky130_fd_sc_hd__a22o_1
X_5365_ net599 _1998_ _2187_ VGND VGND VPWR VPWR _2192_ sky130_fd_sc_hd__mux2_1
X_5296_ _2155_ VGND VGND VPWR VPWR _0518_ sky130_fd_sc_hd__clkbuf_1
XFILLER_0_10_385 VGND VGND VPWR VPWR sky130_fd_sc_hd__fill_2
XFILLER_0_10_374 VGND VGND VPWR VPWR sky130_fd_sc_hd__fill_2
X_8084_ clknet_leaf_85_clk _0173_ VGND VGND VPWR VPWR u_input_buffer.fifo_mem\[58\]\[10\]
+ sky130_fd_sc_hd__dfxtp_1
X_4316_ u_analytics_engine.data_valid _1594_ VGND VGND VPWR VPWR _1595_ sky130_fd_sc_hd__and2_1
X_4247_ net237 net164 net224 VGND VGND VPWR VPWR _1530_ sky130_fd_sc_hd__a21oi_1
X_7035_ u_input_buffer.fifo_mem\[33\]\[6\] _2898_ _2904_ u_input_buffer.fifo_mem\[61\]\[6\]
+ _3280_ VGND VGND VPWR VPWR _3281_ sky130_fd_sc_hd__a221o_1
X_4178_ u_sample_counter.sample_count\[6\] _1483_ VGND VGND VPWR VPWR _1484_ sky130_fd_sc_hd__nand2_1
X_8986_ clknet_leaf_2_clk _1075_ VGND VGND VPWR VPWR u_input_buffer.fifo_mem\[1\]\[0\]
+ sky130_fd_sc_hd__dfxtp_1
X_7937_ clknet_leaf_56_clk _0027_ VGND VGND VPWR VPWR u_sensor_interface.sensor_array\[1\]\[9\]
+ sky130_fd_sc_hd__dfxtp_1
XTAP_1028 VGND VPWR sky130_fd_sc_hd__tapvpwrvgnd_1
XTAP_1017 VGND VPWR sky130_fd_sc_hd__tapvpwrvgnd_1
XTAP_1006 VGND VPWR sky130_fd_sc_hd__tapvpwrvgnd_1
XTAP_1039 VGND VPWR sky130_fd_sc_hd__tapvpwrvgnd_1
X_7868_ net30 u_register_bank.sensor_enable\[26\] _3927_ VGND VGND VPWR VPWR _3934_
+ sky130_fd_sc_hd__mux2_1
X_6819_ _2900_ _2978_ VGND VGND VPWR VPWR _3071_ sky130_fd_sc_hd__nor2_4
XFILLER_0_65_569 VGND VGND VPWR VPWR sky130_fd_sc_hd__fill_1
X_7799_ _3897_ VGND VGND VPWR VPWR _1279_ sky130_fd_sc_hd__clkbuf_1
XFILLER_0_115_181 VGND VGND VPWR VPWR sky130_fd_sc_hd__decap_4
XFILLER_0_60_274 VGND VGND VPWR VPWR sky130_fd_sc_hd__decap_4
XFILLER_0_21_617 VGND VGND VPWR VPWR sky130_fd_sc_hd__fill_1
XFILLER_0_20_116 VGND VGND VPWR VPWR sky130_fd_sc_hd__fill_1
XFILLER_0_20_138 VGND VGND VPWR VPWR sky130_fd_sc_hd__fill_2
XFILLER_0_88_606 VPWR VGND VPWR VGND sky130_ef_sc_hd__decap_12
XFILLER_0_87_127 VGND VGND VPWR VPWR sky130_fd_sc_hd__decap_3
XTAP_1551 VGND VPWR sky130_fd_sc_hd__tapvpwrvgnd_1
XTAP_1540 VGND VPWR sky130_fd_sc_hd__tapvpwrvgnd_1
XFILLER_0_113_15 VPWR VGND VPWR VGND sky130_ef_sc_hd__decap_12
XTAP_1584 VGND VPWR sky130_fd_sc_hd__tapvpwrvgnd_1
XTAP_1573 VGND VPWR sky130_fd_sc_hd__tapvpwrvgnd_1
XTAP_1562 VGND VPWR sky130_fd_sc_hd__tapvpwrvgnd_1
XPHY_80 VGND VGND VPWR VPWR sky130_fd_sc_hd__decap_3
XPHY_91 VGND VGND VPWR VPWR sky130_fd_sc_hd__decap_3
XTAP_1595 VGND VPWR sky130_fd_sc_hd__tapvpwrvgnd_1
XFILLER_0_107_671 VGND VGND VPWR VPWR sky130_fd_sc_hd__fill_1
XFILLER_0_3_316 VGND VGND VPWR VPWR sky130_fd_sc_hd__fill_1
XFILLER_0_12_606 VPWR VGND VPWR VGND sky130_ef_sc_hd__decap_12
XFILLER_0_3_349 VGND VGND VPWR VPWR sky130_fd_sc_hd__fill_2
X_5150_ _1755_ _1930_ VGND VGND VPWR VPWR _2077_ sky130_fd_sc_hd__nor2_4
X_4101_ u_sensor_interface.sensor_array\[0\]\[7\] u_sensor_interface.sensor_array\[1\]\[7\]
+ _1318_ VGND VGND VPWR VPWR _1422_ sky130_fd_sc_hd__mux2_1
X_5081_ _2040_ VGND VGND VPWR VPWR _0418_ sky130_fd_sc_hd__clkbuf_1
X_4032_ net922 net108 _1367_ VGND VGND VPWR VPWR _1368_ sky130_fd_sc_hd__mux2_1
X_8840_ clknet_leaf_97_clk _0929_ VGND VGND VPWR VPWR u_input_buffer.fifo_mem\[11\]\[14\]
+ sky130_fd_sc_hd__dfxtp_1
X_8771_ clknet_leaf_39_clk _0860_ VGND VGND VPWR VPWR u_input_buffer.fifo_mem\[15\]\[9\]
+ sky130_fd_sc_hd__dfxtp_1
XFILLER_0_78_149 VGND VGND VPWR VPWR sky130_fd_sc_hd__decap_6
XFILLER_0_78_138 VGND VGND VPWR VPWR sky130_fd_sc_hd__fill_2
XFILLER_0_63_53 VGND VGND VPWR VPWR sky130_fd_sc_hd__decap_3
XFILLER_0_2_89 VGND VGND VPWR VPWR sky130_fd_sc_hd__fill_1
X_5983_ _1612_ net1217 _2531_ VGND VGND VPWR VPWR _2537_ sky130_fd_sc_hd__mux2_1
X_4934_ net397 _1708_ _1952_ VGND VGND VPWR VPWR _1955_ sky130_fd_sc_hd__mux2_1
X_7722_ _3777_ VGND VGND VPWR VPWR _3843_ sky130_fd_sc_hd__clkbuf_4
XFILLER_0_7_600 VPWR VGND VPWR VGND sky130_ef_sc_hd__decap_12
XANTENNA_12 net7 VGND VGND VPWR VPWR sky130_fd_sc_hd__diode_2
X_4865_ _1916_ VGND VGND VPWR VPWR _0326_ sky130_fd_sc_hd__clkbuf_1
X_7653_ u_register_bank.status_flags\[3\] _3775_ _3778_ u_register_bank.sensor_enable\[3\]
+ VGND VGND VPWR VPWR _3790_ sky130_fd_sc_hd__a22o_1
XFILLER_0_6_110 VGND VGND VPWR VPWR sky130_fd_sc_hd__decap_3
XANTENNA_23 net52 VGND VGND VPWR VPWR sky130_fd_sc_hd__diode_2
XFILLER_0_47_558 VGND VGND VPWR VPWR sky130_fd_sc_hd__fill_2
XANTENNA_34 net82 VGND VGND VPWR VPWR sky130_fd_sc_hd__diode_2
XANTENNA_56 _2096_ VGND VGND VPWR VPWR sky130_fd_sc_hd__diode_2
X_4796_ net661 _1712_ _1874_ VGND VGND VPWR VPWR _1879_ sky130_fd_sc_hd__mux2_1
X_7584_ net43 u_analytics_engine.threshold\[9\] _3737_ VGND VGND VPWR VPWR _3747_
+ sky130_fd_sc_hd__mux2_1
X_6604_ net1312 VGND VGND VPWR VPWR _2870_ sky130_fd_sc_hd__inv_2
XANTENNA_45 _2908_ VGND VGND VPWR VPWR sky130_fd_sc_hd__diode_2
XFILLER_0_103_81 VPWR VGND VPWR VGND sky130_ef_sc_hd__decap_12
X_6535_ _1614_ net832 _2825_ VGND VGND VPWR VPWR _2832_ sky130_fd_sc_hd__mux2_1
XFILLER_0_113_641 VPWR VGND VPWR VGND sky130_ef_sc_hd__decap_12
X_6466_ _2795_ VGND VGND VPWR VPWR _1048_ sky130_fd_sc_hd__clkbuf_1
X_8205_ clknet_leaf_41_clk _0294_ VGND VGND VPWR VPWR u_input_buffer.fifo_mem\[50\]\[3\]
+ sky130_fd_sc_hd__dfxtp_1
XFILLER_0_70_583 VGND VGND VPWR VPWR sky130_fd_sc_hd__decap_4
Xoutput141 net141 VGND VGND VPWR VPWR cfg_rdata[5] sky130_fd_sc_hd__clkbuf_4
Xoutput152 net152 VGND VGND VPWR VPWR processed_data_out[13] sky130_fd_sc_hd__clkbuf_4
X_9185_ clknet_leaf_13_clk _1273_ net186 VGND VGND VPWR VPWR net157 sky130_fd_sc_hd__dfrtp_2
Xoutput130 net130 VGND VGND VPWR VPWR cfg_rdata[24] sky130_fd_sc_hd__clkbuf_4
X_5417_ _1457_ net1181 _2204_ VGND VGND VPWR VPWR _2219_ sky130_fd_sc_hd__mux2_1
X_6397_ _1612_ net1282 _2753_ VGND VGND VPWR VPWR _2759_ sky130_fd_sc_hd__mux2_1
X_8136_ clknet_leaf_89_clk _0225_ VGND VGND VPWR VPWR u_input_buffer.fifo_mem\[55\]\[14\]
+ sky130_fd_sc_hd__dfxtp_1
Xoutput163 net163 VGND VGND VPWR VPWR processed_data_out[9] sky130_fd_sc_hd__clkbuf_4
X_5348_ _2182_ VGND VGND VPWR VPWR _0543_ sky130_fd_sc_hd__clkbuf_1
X_8067_ clknet_leaf_69_clk _0156_ VGND VGND VPWR VPWR u_input_buffer.fifo_mem\[59\]\[9\]
+ sky130_fd_sc_hd__dfxtp_1
X_7018_ u_input_buffer.fifo_mem\[7\]\[5\] _3025_ _3027_ u_input_buffer.fifo_mem\[22\]\[5\]
+ _3264_ VGND VGND VPWR VPWR _3265_ sky130_fd_sc_hd__a221o_1
X_5279_ _1451_ net1256 _2132_ VGND VGND VPWR VPWR _2146_ sky130_fd_sc_hd__mux2_1
X_8969_ clknet_leaf_88_clk _1058_ VGND VGND VPWR VPWR u_input_buffer.fifo_mem\[3\]\[15\]
+ sky130_fd_sc_hd__dfxtp_1
XFILLER_0_92_141 VGND VGND VPWR VPWR sky130_fd_sc_hd__fill_1
XFILLER_0_53_517 VGND VGND VPWR VPWR sky130_fd_sc_hd__fill_1
XFILLER_0_61_561 VGND VGND VPWR VPWR sky130_fd_sc_hd__decap_4
XFILLER_0_103_151 VGND VGND VPWR VPWR sky130_fd_sc_hd__fill_1
XTAP_609 VGND VPWR sky130_fd_sc_hd__tapvpwrvgnd_1
XFILLER_0_108_15 VPWR VGND VPWR VGND sky130_ef_sc_hd__decap_12
XFILLER_0_69_661 VGND VGND VPWR VPWR sky130_fd_sc_hd__decap_3
XTAP_1392 VGND VPWR sky130_fd_sc_hd__tapvpwrvgnd_1
XTAP_1381 VGND VPWR sky130_fd_sc_hd__tapvpwrvgnd_1
XTAP_1370 VGND VPWR sky130_fd_sc_hd__tapvpwrvgnd_1
XFILLER_0_68_193 VGND VGND VPWR VPWR sky130_fd_sc_hd__decap_3
X_4650_ net1077 _1706_ _1798_ VGND VGND VPWR VPWR _1800_ sky130_fd_sc_hd__mux2_1
XFILLER_0_71_314 VGND VGND VPWR VPWR sky130_fd_sc_hd__decap_3
XFILLER_0_44_539 VGND VGND VPWR VPWR sky130_fd_sc_hd__fill_1
Xinput21 cfg_wdata[18] VGND VGND VPWR VPWR net21 sky130_fd_sc_hd__clkbuf_4
XFILLER_0_4_625 VPWR VGND VPWR VGND sky130_ef_sc_hd__decap_12
Xinput10 cfg_read VGND VGND VPWR VPWR net10 sky130_fd_sc_hd__clkbuf_2
Xinput54 sensor_data_in[17] VGND VGND VPWR VPWR net54 sky130_fd_sc_hd__buf_1
Xinput43 cfg_wdata[9] VGND VGND VPWR VPWR net43 sky130_fd_sc_hd__clkbuf_2
X_6320_ _2718_ VGND VGND VPWR VPWR _0979_ sky130_fd_sc_hd__clkbuf_1
X_4581_ net815 _1710_ _1757_ VGND VGND VPWR VPWR _1761_ sky130_fd_sc_hd__mux2_1
Xinput32 cfg_wdata[28] VGND VGND VPWR VPWR net32 sky130_fd_sc_hd__buf_1
XFILLER_0_3_113 VGND VGND VPWR VPWR sky130_fd_sc_hd__decap_4
Xhold816 u_input_buffer.fifo_mem\[58\]\[4\] VGND VGND VPWR VPWR net1028 sky130_fd_sc_hd__dlygate4sd3_1
Xinput76 sensor_data_in[37] VGND VGND VPWR VPWR net76 sky130_fd_sc_hd__clkbuf_1
Xinput87 sensor_data_in[47] VGND VGND VPWR VPWR net87 sky130_fd_sc_hd__clkbuf_1
XFILLER_0_4_669 VPWR VGND VPWR VGND sky130_ef_sc_hd__decap_12
Xinput98 sensor_data_in[57] VGND VGND VPWR VPWR net98 sky130_fd_sc_hd__clkbuf_2
Xinput65 sensor_data_in[27] VGND VGND VPWR VPWR net65 sky130_fd_sc_hd__buf_1
Xhold827 u_input_buffer.fifo_mem\[8\]\[15\] VGND VGND VPWR VPWR net1039 sky130_fd_sc_hd__dlygate4sd3_1
Xhold805 u_input_buffer.fifo_mem\[52\]\[12\] VGND VGND VPWR VPWR net1017 sky130_fd_sc_hd__dlygate4sd3_1
X_6251_ _2681_ VGND VGND VPWR VPWR _0947_ sky130_fd_sc_hd__clkbuf_1
Xhold849 u_input_buffer.fifo_mem\[59\]\[3\] VGND VGND VPWR VPWR net1061 sky130_fd_sc_hd__dlygate4sd3_1
Xhold838 u_input_buffer.fifo_mem\[61\]\[14\] VGND VGND VPWR VPWR net1050 sky130_fd_sc_hd__dlygate4sd3_1
X_5202_ _2105_ VGND VGND VPWR VPWR _0474_ sky130_fd_sc_hd__clkbuf_1
X_6182_ net342 _2496_ _2644_ VGND VGND VPWR VPWR _2645_ sky130_fd_sc_hd__mux2_1
X_5133_ _2068_ VGND VGND VPWR VPWR _0442_ sky130_fd_sc_hd__clkbuf_1
X_5064_ net456 _2004_ _2024_ VGND VGND VPWR VPWR _2032_ sky130_fd_sc_hd__mux2_1
X_4015_ net358 net46 _1356_ VGND VGND VPWR VPWR _1359_ sky130_fd_sc_hd__mux2_1
XFILLER_0_79_436 VGND VGND VPWR VPWR sky130_fd_sc_hd__fill_1
X_8823_ clknet_leaf_11_clk _0912_ VGND VGND VPWR VPWR u_input_buffer.fifo_mem\[12\]\[13\]
+ sky130_fd_sc_hd__dfxtp_1
X_8754_ clknet_leaf_18_clk _0843_ VGND VGND VPWR VPWR u_input_buffer.fifo_mem\[16\]\[8\]
+ sky130_fd_sc_hd__dfxtp_1
XFILLER_0_47_300 VGND VGND VPWR VPWR sky130_fd_sc_hd__fill_1
X_5966_ net272 _2526_ _2497_ VGND VGND VPWR VPWR _2527_ sky130_fd_sc_hd__mux2_1
X_8685_ clknet_leaf_46_clk _0774_ VGND VGND VPWR VPWR u_input_buffer.fifo_mem\[20\]\[3\]
+ sky130_fd_sc_hd__dfxtp_1
XFILLER_0_75_653 VPWR VGND VPWR VGND sky130_ef_sc_hd__decap_12
X_5897_ net823 _2252_ _2479_ VGND VGND VPWR VPWR _2484_ sky130_fd_sc_hd__mux2_1
X_7705_ _3830_ VGND VGND VPWR VPWR _1252_ sky130_fd_sc_hd__clkbuf_1
X_4917_ _1945_ VGND VGND VPWR VPWR _0349_ sky130_fd_sc_hd__clkbuf_1
XFILLER_0_90_634 VGND VGND VPWR VPWR sky130_fd_sc_hd__fill_1
XFILLER_0_90_612 VGND VGND VPWR VPWR sky130_fd_sc_hd__fill_1
XFILLER_0_62_303 VGND VGND VPWR VPWR sky130_fd_sc_hd__fill_2
X_4848_ _1906_ VGND VGND VPWR VPWR _0319_ sky130_fd_sc_hd__clkbuf_1
X_7636_ net3 net4 _3696_ VGND VGND VPWR VPWR _3776_ sky130_fd_sc_hd__and3b_1
XFILLER_0_90_645 VGND VGND VPWR VPWR sky130_fd_sc_hd__decap_4
X_7567_ _3738_ VGND VGND VPWR VPWR _1206_ sky130_fd_sc_hd__clkbuf_1
XFILLER_0_7_496 VGND VGND VPWR VPWR sky130_fd_sc_hd__decap_8
X_4779_ net635 _1730_ _1854_ VGND VGND VPWR VPWR _1869_ sky130_fd_sc_hd__mux2_1
X_7498_ _3701_ VGND VGND VPWR VPWR _1174_ sky130_fd_sc_hd__clkbuf_1
X_6518_ _2822_ VGND VGND VPWR VPWR _1073_ sky130_fd_sc_hd__clkbuf_1
X_6449_ net539 _1462_ _2770_ VGND VGND VPWR VPWR _2786_ sky130_fd_sc_hd__mux2_1
XFILLER_0_100_121 VGND VGND VPWR VPWR sky130_fd_sc_hd__decap_6
X_9168_ net169 _1256_ VGND VGND VPWR VPWR net123 sky130_fd_sc_hd__dfxtp_2
X_8119_ clknet_leaf_73_clk _0208_ VGND VGND VPWR VPWR u_input_buffer.fifo_mem\[56\]\[13\]
+ sky130_fd_sc_hd__dfxtp_1
X_9099_ net171 _1187_ net202 VGND VGND VPWR VPWR u_register_bank.window_cfg\[13\]
+ sky130_fd_sc_hd__dfrtp_1
XFILLER_0_97_233 VGND VGND VPWR VPWR sky130_fd_sc_hd__fill_2
XFILLER_0_85_417 VGND VGND VPWR VPWR sky130_fd_sc_hd__fill_1
XFILLER_0_38_355 VGND VGND VPWR VPWR sky130_fd_sc_hd__fill_2
XFILLER_0_81_623 VGND VGND VPWR VPWR sky130_fd_sc_hd__fill_1
XFILLER_0_110_27 VGND VGND VPWR VPWR sky130_fd_sc_hd__fill_1
XFILLER_0_1_617 VPWR VGND VPWR VGND sky130_ef_sc_hd__decap_12
XFILLER_0_21_211 VGND VGND VPWR VPWR sky130_fd_sc_hd__fill_1
XFILLER_0_21_222 VGND VGND VPWR VPWR sky130_fd_sc_hd__fill_2
XFILLER_0_0_105 VGND VGND VPWR VPWR sky130_fd_sc_hd__fill_1
XTAP_406 VGND VPWR sky130_fd_sc_hd__tapvpwrvgnd_1
XTAP_417 VGND VPWR sky130_fd_sc_hd__tapvpwrvgnd_1
XTAP_428 VGND VPWR sky130_fd_sc_hd__tapvpwrvgnd_1
XTAP_439 VGND VPWR sky130_fd_sc_hd__tapvpwrvgnd_1
XFILLER_0_28_12 VGND VGND VPWR VPWR sky130_fd_sc_hd__fill_1
XFILLER_0_28_45 VGND VGND VPWR VPWR sky130_fd_sc_hd__fill_2
XFILLER_0_44_11 VGND VGND VPWR VPWR sky130_fd_sc_hd__fill_1
XFILLER_0_44_33 VGND VGND VPWR VPWR sky130_fd_sc_hd__fill_1
XFILLER_0_49_609 VGND VGND VPWR VPWR sky130_fd_sc_hd__decap_6
XFILLER_0_57_631 VGND VGND VPWR VPWR sky130_fd_sc_hd__fill_2
XFILLER_0_29_300 VGND VGND VPWR VPWR sky130_fd_sc_hd__fill_2
X_5820_ _2442_ VGND VGND VPWR VPWR _2443_ sky130_fd_sc_hd__clkbuf_4
XFILLER_0_48_119 VGND VGND VPWR VPWR sky130_fd_sc_hd__fill_2
X_5751_ _2405_ VGND VGND VPWR VPWR _2406_ sky130_fd_sc_hd__clkbuf_4
XFILLER_0_56_174 VGND VGND VPWR VPWR sky130_fd_sc_hd__fill_1
X_8470_ clknet_leaf_99_clk _0559_ VGND VGND VPWR VPWR u_input_buffer.fifo_mem\[34\]\[12\]
+ sky130_fd_sc_hd__dfxtp_1
X_4702_ _1827_ VGND VGND VPWR VPWR _0252_ sky130_fd_sc_hd__clkbuf_1
XFILLER_0_71_122 VGND VGND VPWR VPWR sky130_fd_sc_hd__fill_1
XFILLER_0_71_111 VGND VGND VPWR VPWR sky130_fd_sc_hd__fill_1
X_7421_ _3639_ _3648_ _3657_ VGND VGND VPWR VPWR _3658_ sky130_fd_sc_hd__or3_1
X_5682_ _1736_ _2295_ VGND VGND VPWR VPWR _2369_ sky130_fd_sc_hd__nand2_4
X_4633_ _1789_ VGND VGND VPWR VPWR _0221_ sky130_fd_sc_hd__clkbuf_1
XFILLER_0_25_561 VGND VGND VPWR VPWR sky130_fd_sc_hd__fill_1
XFILLER_0_12_211 VGND VGND VPWR VPWR sky130_fd_sc_hd__decap_6
X_4564_ _1451_ net1174 _1737_ VGND VGND VPWR VPWR _1751_ sky130_fd_sc_hd__mux2_1
X_7352_ u_input_buffer.fifo_mem\[29\]\[14\] _2938_ _2940_ u_input_buffer.fifo_mem\[13\]\[14\]
+ _3589_ VGND VGND VPWR VPWR _3590_ sky130_fd_sc_hd__a221o_1
Xhold602 u_input_buffer.fifo_mem\[37\]\[14\] VGND VGND VPWR VPWR net814 sky130_fd_sc_hd__dlygate4sd3_1
Xhold624 u_input_buffer.fifo_mem\[26\]\[7\] VGND VGND VPWR VPWR net836 sky130_fd_sc_hd__dlygate4sd3_1
Xhold613 u_input_buffer.fifo_mem\[60\]\[6\] VGND VGND VPWR VPWR net825 sky130_fd_sc_hd__dlygate4sd3_1
X_6303_ _2708_ VGND VGND VPWR VPWR _0972_ sky130_fd_sc_hd__clkbuf_1
X_7283_ u_input_buffer.fifo_mem\[51\]\[12\] _2989_ _2992_ u_input_buffer.fifo_mem\[11\]\[12\]
+ _3522_ VGND VGND VPWR VPWR _3523_ sky130_fd_sc_hd__a221o_1
Xhold635 u_input_buffer.fifo_mem\[33\]\[0\] VGND VGND VPWR VPWR net847 sky130_fd_sc_hd__dlygate4sd3_1
X_4495_ _1390_ VGND VGND VPWR VPWR _1708_ sky130_fd_sc_hd__buf_4
X_6234_ net674 _2516_ _2662_ VGND VGND VPWR VPWR _2672_ sky130_fd_sc_hd__mux2_1
Xhold657 u_input_buffer.fifo_mem\[36\]\[10\] VGND VGND VPWR VPWR net869 sky130_fd_sc_hd__dlygate4sd3_1
X_9022_ clknet_leaf_87_clk _1111_ net189 VGND VGND VPWR VPWR u_input_buffer.count\[4\]
+ sky130_fd_sc_hd__dfrtp_1
Xhold646 u_input_buffer.fifo_mem\[30\]\[13\] VGND VGND VPWR VPWR net858 sky130_fd_sc_hd__dlygate4sd3_1
Xhold668 u_input_buffer.fifo_mem\[29\]\[8\] VGND VGND VPWR VPWR net880 sky130_fd_sc_hd__dlygate4sd3_1
Xhold679 u_input_buffer.fifo_mem\[6\]\[14\] VGND VGND VPWR VPWR net891 sky130_fd_sc_hd__dlygate4sd3_1
XFILLER_0_110_496 VGND VGND VPWR VPWR sky130_fd_sc_hd__fill_1
X_6165_ net398 _2516_ _2625_ VGND VGND VPWR VPWR _2635_ sky130_fd_sc_hd__mux2_1
XTAP_962 VGND VPWR sky130_fd_sc_hd__tapvpwrvgnd_1
XTAP_951 VGND VPWR sky130_fd_sc_hd__tapvpwrvgnd_1
XTAP_940 VGND VPWR sky130_fd_sc_hd__tapvpwrvgnd_1
XFILLER_0_40_3 VGND VGND VPWR VPWR sky130_fd_sc_hd__decap_8
X_6096_ _2597_ VGND VGND VPWR VPWR _0876_ sky130_fd_sc_hd__clkbuf_1
XFILLER_0_85_73 VGND VGND VPWR VPWR sky130_fd_sc_hd__fill_1
XTAP_995 VGND VPWR sky130_fd_sc_hd__tapvpwrvgnd_1
XTAP_984 VGND VPWR sky130_fd_sc_hd__tapvpwrvgnd_1
XTAP_973 VGND VPWR sky130_fd_sc_hd__tapvpwrvgnd_1
X_5116_ _1736_ _1969_ VGND VGND VPWR VPWR _2059_ sky130_fd_sc_hd__nand2_4
X_5047_ _1680_ _1969_ VGND VGND VPWR VPWR _2022_ sky130_fd_sc_hd__and2_1
X_6998_ u_input_buffer.fifo_mem\[41\]\[5\] _2919_ _2921_ u_input_buffer.fifo_mem\[45\]\[5\]
+ _3244_ VGND VGND VPWR VPWR _3245_ sky130_fd_sc_hd__a221o_1
X_8806_ clknet_leaf_109_clk _0895_ VGND VGND VPWR VPWR u_input_buffer.fifo_mem\[13\]\[12\]
+ sky130_fd_sc_hd__dfxtp_1
XFILLER_0_48_620 VGND VGND VPWR VPWR sky130_fd_sc_hd__decap_4
X_5949_ _2515_ VGND VGND VPWR VPWR _0811_ sky130_fd_sc_hd__clkbuf_1
X_8737_ clknet_leaf_0_clk _0826_ VGND VGND VPWR VPWR u_input_buffer.fifo_mem\[17\]\[7\]
+ sky130_fd_sc_hd__dfxtp_1
XFILLER_0_63_601 VGND VGND VPWR VPWR sky130_fd_sc_hd__decap_8
XFILLER_0_75_494 VGND VGND VPWR VPWR sky130_fd_sc_hd__decap_8
X_8668_ clknet_leaf_5_clk _0757_ VGND VGND VPWR VPWR u_input_buffer.fifo_mem\[21\]\[2\]
+ sky130_fd_sc_hd__dfxtp_1
X_7619_ _3765_ VGND VGND VPWR VPWR _1231_ sky130_fd_sc_hd__clkbuf_1
X_8599_ clknet_leaf_87_clk _0688_ VGND VGND VPWR VPWR u_input_buffer.fifo_mem\[26\]\[13\]
+ sky130_fd_sc_hd__dfxtp_1
XFILLER_0_7_293 VGND VGND VPWR VPWR sky130_fd_sc_hd__fill_2
XFILLER_0_90_497 VGND VGND VPWR VPWR sky130_fd_sc_hd__decap_4
XFILLER_0_16_583 VGND VGND VPWR VPWR sky130_fd_sc_hd__fill_1
XFILLER_0_43_391 VGND VGND VPWR VPWR sky130_fd_sc_hd__fill_1
XFILLER_0_105_27 VPWR VGND VPWR VGND sky130_ef_sc_hd__decap_12
XFILLER_0_98_597 VGND VGND VPWR VPWR sky130_fd_sc_hd__fill_2
XFILLER_0_54_645 VPWR VGND VPWR VGND sky130_ef_sc_hd__decap_12
XFILLER_0_30_24 VGND VGND VPWR VPWR sky130_fd_sc_hd__fill_1
XFILLER_0_100_6 VPWR VGND VPWR VGND sky130_ef_sc_hd__decap_12
XFILLER_0_1_414 VGND VGND VPWR VPWR sky130_fd_sc_hd__decap_8
XFILLER_0_1_447 VGND VGND VPWR VPWR sky130_fd_sc_hd__fill_1
X_4280_ u_analytics_engine.data_in\[6\] VGND VGND VPWR VPWR _1560_ sky130_fd_sc_hd__inv_2
XFILLER_0_39_55 VGND VGND VPWR VPWR sky130_fd_sc_hd__fill_1
XTAP_236 VGND VPWR sky130_fd_sc_hd__tapvpwrvgnd_1
XTAP_247 VGND VPWR sky130_fd_sc_hd__tapvpwrvgnd_1
XTAP_258 VGND VPWR sky130_fd_sc_hd__tapvpwrvgnd_1
XTAP_269 VGND VPWR sky130_fd_sc_hd__tapvpwrvgnd_1
X_7970_ clknet_leaf_104_clk _0060_ net184 VGND VGND VPWR VPWR u_input_buffer.data_in\[10\]
+ sky130_fd_sc_hd__dfrtp_1
XFILLER_0_55_65 VGND VGND VPWR VPWR sky130_fd_sc_hd__fill_2
XFILLER_0_55_76 VGND VGND VPWR VPWR sky130_fd_sc_hd__decap_4
X_6921_ u_input_buffer.fifo_mem\[53\]\[3\] _2934_ _2936_ u_input_buffer.fifo_mem\[57\]\[3\]
+ VGND VGND VPWR VPWR _3170_ sky130_fd_sc_hd__a22o_1
X_6852_ u_input_buffer.fifo_mem\[12\]\[1\] _2980_ _2982_ u_input_buffer.fifo_mem\[18\]\[1\]
+ _3102_ VGND VGND VPWR VPWR _3103_ sky130_fd_sc_hd__a221o_1
XFILLER_0_49_428 VGND VGND VPWR VPWR sky130_fd_sc_hd__decap_4
X_5803_ net396 _2260_ _2425_ VGND VGND VPWR VPWR _2434_ sky130_fd_sc_hd__mux2_1
XFILLER_0_9_503 VGND VGND VPWR VPWR sky130_fd_sc_hd__fill_1
X_8522_ clknet_leaf_55_clk _0611_ VGND VGND VPWR VPWR u_input_buffer.fifo_mem\[30\]\[0\]
+ sky130_fd_sc_hd__dfxtp_1
XFILLER_0_57_461 VGND VGND VPWR VPWR sky130_fd_sc_hd__decap_3
X_3995_ _1348_ VGND VGND VPWR VPWR _0024_ sky130_fd_sc_hd__clkbuf_1
XFILLER_0_17_303 VGND VGND VPWR VPWR sky130_fd_sc_hd__fill_2
X_6783_ _3034_ VGND VGND VPWR VPWR _3035_ sky130_fd_sc_hd__clkbuf_4
XFILLER_0_84_280 VGND VGND VPWR VPWR sky130_fd_sc_hd__decap_8
X_5734_ net516 _2260_ _2388_ VGND VGND VPWR VPWR _2397_ sky130_fd_sc_hd__mux2_1
XFILLER_0_115_533 VGND VGND VPWR VPWR sky130_fd_sc_hd__decap_8
X_5665_ _2360_ VGND VGND VPWR VPWR _0682_ sky130_fd_sc_hd__clkbuf_1
XFILLER_0_45_667 VGND VGND VPWR VPWR sky130_fd_sc_hd__decap_4
X_8453_ clknet_leaf_10_clk _0542_ VGND VGND VPWR VPWR u_input_buffer.fifo_mem\[35\]\[11\]
+ sky130_fd_sc_hd__dfxtp_1
XFILLER_0_115_566 VGND VGND VPWR VPWR sky130_fd_sc_hd__decap_8
X_8384_ clknet_leaf_51_clk _0473_ VGND VGND VPWR VPWR u_input_buffer.fifo_mem\[39\]\[6\]
+ sky130_fd_sc_hd__dfxtp_1
X_4616_ net991 _1708_ _1778_ VGND VGND VPWR VPWR _1781_ sky130_fd_sc_hd__mux2_1
XFILLER_0_88_3 VPWR VGND VPWR VGND sky130_ef_sc_hd__decap_12
X_7404_ u_input_buffer.fifo_mem\[8\]\[15\] _3003_ _3005_ u_input_buffer.fifo_mem\[19\]\[15\]
+ _3640_ VGND VGND VPWR VPWR _3641_ sky130_fd_sc_hd__a221o_1
XFILLER_0_111_81 VPWR VGND VPWR VGND sky130_ef_sc_hd__decap_12
Xhold410 u_input_buffer.fifo_mem\[20\]\[7\] VGND VGND VPWR VPWR net622 sky130_fd_sc_hd__dlygate4sd3_1
X_5596_ _2323_ VGND VGND VPWR VPWR _0650_ sky130_fd_sc_hd__clkbuf_1
XFILLER_0_13_553 VGND VGND VPWR VPWR sky130_fd_sc_hd__decap_6
X_7335_ u_input_buffer.fifo_mem\[23\]\[13\] _3045_ _3047_ u_input_buffer.fifo_mem\[20\]\[13\]
+ _3573_ VGND VGND VPWR VPWR _3574_ sky130_fd_sc_hd__a221o_1
XFILLER_0_25_391 VGND VGND VPWR VPWR sky130_fd_sc_hd__fill_1
Xhold421 u_input_buffer.fifo_mem\[23\]\[2\] VGND VGND VPWR VPWR net633 sky130_fd_sc_hd__dlygate4sd3_1
Xhold432 u_input_buffer.fifo_mem\[11\]\[2\] VGND VGND VPWR VPWR net644 sky130_fd_sc_hd__dlygate4sd3_1
X_4547_ _1742_ VGND VGND VPWR VPWR _0182_ sky130_fd_sc_hd__clkbuf_1
Xhold443 u_input_buffer.fifo_mem\[14\]\[14\] VGND VGND VPWR VPWR net655 sky130_fd_sc_hd__dlygate4sd3_1
Xhold454 u_input_buffer.fifo_mem\[36\]\[14\] VGND VGND VPWR VPWR net666 sky130_fd_sc_hd__dlygate4sd3_1
Xhold487 u_input_buffer.fifo_mem\[47\]\[0\] VGND VGND VPWR VPWR net699 sky130_fd_sc_hd__dlygate4sd3_1
Xhold476 u_input_buffer.fifo_mem\[26\]\[0\] VGND VGND VPWR VPWR net688 sky130_fd_sc_hd__dlygate4sd3_1
Xhold465 u_input_buffer.fifo_mem\[18\]\[9\] VGND VGND VPWR VPWR net677 sky130_fd_sc_hd__dlygate4sd3_1
X_4478_ _1696_ VGND VGND VPWR VPWR _0159_ sky130_fd_sc_hd__clkbuf_1
X_7266_ net532 _3085_ _3087_ VGND VGND VPWR VPWR _3507_ sky130_fd_sc_hd__o21a_1
X_6217_ _2663_ VGND VGND VPWR VPWR _0931_ sky130_fd_sc_hd__clkbuf_1
Xhold498 u_input_buffer.fifo_mem\[6\]\[6\] VGND VGND VPWR VPWR net710 sky130_fd_sc_hd__dlygate4sd3_1
XFILLER_0_96_83 VGND VGND VPWR VPWR sky130_fd_sc_hd__fill_1
X_9005_ clknet_leaf_43_clk _1094_ VGND VGND VPWR VPWR u_input_buffer.fifo_mem\[0\]\[3\]
+ sky130_fd_sc_hd__dfxtp_1
X_7197_ u_input_buffer.fifo_mem\[1\]\[10\] _2931_ _3436_ _3438_ VGND VGND VPWR VPWR
+ _3439_ sky130_fd_sc_hd__a211o_1
X_6148_ _2626_ VGND VGND VPWR VPWR _0899_ sky130_fd_sc_hd__clkbuf_1
XTAP_770 VGND VPWR sky130_fd_sc_hd__tapvpwrvgnd_1
Xhold1110 u_input_buffer.count\[0\] VGND VGND VPWR VPWR net1322 sky130_fd_sc_hd__dlygate4sd3_1
XTAP_781 VGND VPWR sky130_fd_sc_hd__tapvpwrvgnd_1
XTAP_792 VGND VPWR sky130_fd_sc_hd__tapvpwrvgnd_1
X_6079_ net474 _2500_ _2587_ VGND VGND VPWR VPWR _2589_ sky130_fd_sc_hd__mux2_1
XFILLER_0_55_409 VGND VGND VPWR VPWR sky130_fd_sc_hd__fill_1
XFILLER_0_36_645 VGND VGND VPWR VPWR sky130_fd_sc_hd__decap_4
XFILLER_0_51_615 VGND VGND VPWR VPWR sky130_fd_sc_hd__fill_1
XFILLER_0_63_475 VGND VGND VPWR VPWR sky130_fd_sc_hd__fill_2
XFILLER_0_25_46 VGND VGND VPWR VPWR sky130_fd_sc_hd__fill_1
XFILLER_0_98_394 VGND VGND VPWR VPWR sky130_fd_sc_hd__fill_2
XFILLER_0_58_236 VGND VGND VPWR VPWR sky130_fd_sc_hd__decap_4
XFILLER_0_73_217 VGND VGND VPWR VPWR sky130_fd_sc_hd__decap_4
XFILLER_0_54_453 VGND VGND VPWR VPWR sky130_fd_sc_hd__decap_4
XFILLER_0_26_177 VGND VGND VPWR VPWR sky130_fd_sc_hd__fill_2
X_5450_ _2236_ VGND VGND VPWR VPWR _0591_ sky130_fd_sc_hd__clkbuf_1
XFILLER_0_54_486 VGND VGND VPWR VPWR sky130_fd_sc_hd__fill_1
X_4401_ _1445_ net837 _1640_ VGND VGND VPWR VPWR _1653_ sky130_fd_sc_hd__mux2_1
XFILLER_0_41_125 VGND VGND VPWR VPWR sky130_fd_sc_hd__fill_1
XFILLER_0_1_222 VGND VGND VPWR VPWR sky130_fd_sc_hd__fill_2
X_5381_ net324 _2014_ _2186_ VGND VGND VPWR VPWR _2200_ sky130_fd_sc_hd__mux2_1
X_7120_ u_input_buffer.fifo_mem\[14\]\[8\] _2958_ _2961_ u_input_buffer.fifo_mem\[42\]\[8\]
+ VGND VGND VPWR VPWR _3364_ sky130_fd_sc_hd__a22o_1
X_4332_ u_input_buffer.data_in\[3\] VGND VGND VPWR VPWR _1608_ sky130_fd_sc_hd__buf_4
XFILLER_0_10_545 VPWR VGND VPWR VGND sky130_ef_sc_hd__decap_12
X_7051_ _3281_ _3283_ _3287_ _3296_ VGND VGND VPWR VPWR _3297_ sky130_fd_sc_hd__or4_2
Xfanout208 net212 VGND VGND VPWR VPWR net208 sky130_fd_sc_hd__clkbuf_4
X_4263_ u_analytics_engine.threshold\[10\] VGND VGND VPWR VPWR _1543_ sky130_fd_sc_hd__inv_2
XFILLER_0_10_589 VPWR VGND VPWR VGND sky130_ef_sc_hd__decap_12
X_6002_ _2546_ VGND VGND VPWR VPWR _0833_ sky130_fd_sc_hd__clkbuf_1
X_4194_ u_sample_counter.sample_count\[9\] u_sample_counter.sample_count\[10\] _1487_
+ u_sample_counter.sample_count\[11\] VGND VGND VPWR VPWR _1495_ sky130_fd_sc_hd__a31o_1
X_7953_ clknet_leaf_32_clk _0043_ VGND VGND VPWR VPWR u_sensor_interface.sensor_array\[0\]\[9\]
+ sky130_fd_sc_hd__dfxtp_1
X_6904_ _3147_ _3149_ _3151_ _3153_ VGND VGND VPWR VPWR _3154_ sky130_fd_sc_hd__or4_1
XFILLER_0_82_63 VGND VGND VPWR VPWR sky130_fd_sc_hd__decap_4
X_7884_ clknet_leaf_57_clk net239 net198 VGND VGND VPWR VPWR u_register_bank.status_flags\[4\]
+ sky130_fd_sc_hd__dfrtp_1
X_6835_ net192 _2860_ VGND VGND VPWR VPWR _3087_ sky130_fd_sc_hd__and2_2
X_3978_ _1339_ VGND VGND VPWR VPWR _0016_ sky130_fd_sc_hd__clkbuf_1
X_6766_ _2872_ _2877_ _2876_ _2873_ VGND VGND VPWR VPWR _3018_ sky130_fd_sc_hd__and4bb_1
XFILLER_0_72_250 VGND VGND VPWR VPWR sky130_fd_sc_hd__fill_2
X_8505_ clknet_leaf_10_clk _0594_ VGND VGND VPWR VPWR u_input_buffer.fifo_mem\[32\]\[15\]
+ sky130_fd_sc_hd__dfxtp_1
X_5717_ _2387_ VGND VGND VPWR VPWR _2388_ sky130_fd_sc_hd__buf_4
XFILLER_0_33_615 VGND VGND VPWR VPWR sky130_fd_sc_hd__fill_1
X_6697_ u_input_buffer.rd_ptr\[0\] u_input_buffer.rd_ptr\[1\] u_input_buffer.rd_ptr\[3\]
+ u_input_buffer.rd_ptr\[2\] VGND VGND VPWR VPWR _2949_ sky130_fd_sc_hd__or4b_4
XFILLER_0_115_385 VGND VGND VPWR VPWR sky130_fd_sc_hd__decap_3
XFILLER_0_115_363 VGND VGND VPWR VPWR sky130_fd_sc_hd__fill_1
X_8436_ clknet_leaf_13_clk _0525_ VGND VGND VPWR VPWR u_input_buffer.fifo_mem\[36\]\[10\]
+ sky130_fd_sc_hd__dfxtp_1
XFILLER_0_5_561 VPWR VGND VPWR VGND sky130_ef_sc_hd__decap_12
X_5648_ _1702_ _2242_ VGND VGND VPWR VPWR _2351_ sky130_fd_sc_hd__nor2_4
X_8367_ clknet_leaf_51_clk _0456_ VGND VGND VPWR VPWR u_input_buffer.fifo_mem\[40\]\[5\]
+ sky130_fd_sc_hd__dfxtp_1
XFILLER_0_20_309 VGND VGND VPWR VPWR sky130_fd_sc_hd__decap_3
XFILLER_0_41_670 VGND VGND VPWR VPWR sky130_fd_sc_hd__fill_2
X_5579_ _1659_ _2242_ VGND VGND VPWR VPWR _2314_ sky130_fd_sc_hd__nor2_4
X_8298_ clknet_leaf_34_clk _0387_ VGND VGND VPWR VPWR u_input_buffer.fifo_mem\[44\]\[0\]
+ sky130_fd_sc_hd__dfxtp_1
Xhold262 u_input_buffer.fifo_mem\[14\]\[1\] VGND VGND VPWR VPWR net474 sky130_fd_sc_hd__dlygate4sd3_1
Xhold251 u_input_buffer.fifo_mem\[63\]\[3\] VGND VGND VPWR VPWR net463 sky130_fd_sc_hd__dlygate4sd3_1
Xhold240 u_input_buffer.fifo_mem\[0\]\[3\] VGND VGND VPWR VPWR net452 sky130_fd_sc_hd__dlygate4sd3_1
X_7318_ u_input_buffer.fifo_mem\[34\]\[13\] _2965_ _2968_ u_input_buffer.fifo_mem\[48\]\[13\]
+ _3556_ VGND VGND VPWR VPWR _3557_ sky130_fd_sc_hd__a221o_1
Xhold295 u_input_buffer.fifo_mem\[40\]\[9\] VGND VGND VPWR VPWR net507 sky130_fd_sc_hd__dlygate4sd3_1
Xhold273 u_input_buffer.fifo_mem\[26\]\[2\] VGND VGND VPWR VPWR net485 sky130_fd_sc_hd__dlygate4sd3_1
Xhold284 u_input_buffer.fifo_mem\[54\]\[8\] VGND VGND VPWR VPWR net496 sky130_fd_sc_hd__dlygate4sd3_1
X_7249_ u_input_buffer.fifo_mem\[31\]\[11\] _3016_ _3019_ u_input_buffer.fifo_mem\[38\]\[11\]
+ VGND VGND VPWR VPWR _3490_ sky130_fd_sc_hd__a22o_1
XFILLER_0_99_169 VGND VGND VPWR VPWR sky130_fd_sc_hd__fill_2
XFILLER_0_68_589 VGND VGND VPWR VPWR sky130_fd_sc_hd__decap_8
XFILLER_0_23_169 VGND VGND VPWR VPWR sky130_fd_sc_hd__decap_4
Xinput8 cfg_addr[7] VGND VGND VPWR VPWR net8 sky130_fd_sc_hd__buf_1
X_4950_ net743 _1724_ _1951_ VGND VGND VPWR VPWR _1963_ sky130_fd_sc_hd__mux2_1
XFILLER_0_59_567 VGND VGND VPWR VPWR sky130_fd_sc_hd__decap_3
X_4881_ _1924_ VGND VGND VPWR VPWR _0334_ sky130_fd_sc_hd__clkbuf_1
X_6620_ _2876_ _2874_ VGND VGND VPWR VPWR _2881_ sky130_fd_sc_hd__and2_1
X_6551_ _1630_ net899 _2824_ VGND VGND VPWR VPWR _2840_ sky130_fd_sc_hd__mux2_1
XFILLER_0_27_431 VGND VGND VPWR VPWR sky130_fd_sc_hd__fill_1
XFILLER_0_6_347 VGND VGND VPWR VPWR sky130_fd_sc_hd__fill_1
X_5502_ _2271_ VGND VGND VPWR VPWR _0608_ sky130_fd_sc_hd__clkbuf_1
X_6482_ _2803_ VGND VGND VPWR VPWR _1056_ sky130_fd_sc_hd__clkbuf_1
XFILLER_0_42_456 VGND VGND VPWR VPWR sky130_fd_sc_hd__fill_2
X_5433_ net872 _1998_ _2223_ VGND VGND VPWR VPWR _2228_ sky130_fd_sc_hd__mux2_1
X_8221_ clknet_leaf_24_clk _0310_ VGND VGND VPWR VPWR u_input_buffer.fifo_mem\[49\]\[3\]
+ sky130_fd_sc_hd__dfxtp_1
X_5364_ _2191_ VGND VGND VPWR VPWR _0550_ sky130_fd_sc_hd__clkbuf_1
X_8152_ clknet_leaf_101_clk _0241_ VGND VGND VPWR VPWR u_input_buffer.fifo_mem\[54\]\[14\]
+ sky130_fd_sc_hd__dfxtp_1
X_7103_ u_input_buffer.fifo_mem\[10\]\[7\] _3056_ _3058_ u_input_buffer.fifo_mem\[44\]\[7\]
+ _3347_ VGND VGND VPWR VPWR _3348_ sky130_fd_sc_hd__a221o_1
XFILLER_0_10_331 VGND VGND VPWR VPWR sky130_fd_sc_hd__fill_2
X_4315_ u_input_buffer.count\[5\] u_input_buffer.count\[4\] _1593_ u_input_buffer.count\[6\]
+ VGND VGND VPWR VPWR _1594_ sky130_fd_sc_hd__or4b_4
X_5295_ net841 _1996_ _2151_ VGND VGND VPWR VPWR _2155_ sky130_fd_sc_hd__mux2_1
X_8083_ clknet_leaf_65_clk _0172_ VGND VGND VPWR VPWR u_input_buffer.fifo_mem\[58\]\[9\]
+ sky130_fd_sc_hd__dfxtp_1
X_4246_ u_sample_counter.sample_count\[28\] u_sample_counter.sample_count\[29\] VGND
+ VGND VPWR VPWR _1529_ sky130_fd_sc_hd__and2_1
X_7034_ u_input_buffer.fifo_mem\[21\]\[6\] _2909_ _2913_ u_input_buffer.fifo_mem\[25\]\[6\]
+ VGND VGND VPWR VPWR _3280_ sky130_fd_sc_hd__a22o_1
X_4177_ _1482_ _1483_ VGND VGND VPWR VPWR _0071_ sky130_fd_sc_hd__nor2_1
XFILLER_0_93_51 VGND VGND VPWR VPWR sky130_fd_sc_hd__decap_4
X_8985_ clknet_leaf_10_clk _1074_ VGND VGND VPWR VPWR u_input_buffer.fifo_mem\[2\]\[15\]
+ sky130_fd_sc_hd__dfxtp_1
X_7936_ clknet_leaf_31_clk _0026_ VGND VGND VPWR VPWR u_sensor_interface.sensor_array\[1\]\[8\]
+ sky130_fd_sc_hd__dfxtp_1
XTAP_1029 VGND VPWR sky130_fd_sc_hd__tapvpwrvgnd_1
XTAP_1018 VGND VPWR sky130_fd_sc_hd__tapvpwrvgnd_1
XTAP_1007 VGND VPWR sky130_fd_sc_hd__tapvpwrvgnd_1
X_7867_ _3933_ VGND VGND VPWR VPWR _1311_ sky130_fd_sc_hd__clkbuf_1
XFILLER_0_92_323 VGND VGND VPWR VPWR sky130_fd_sc_hd__fill_1
X_6818_ _3069_ VGND VGND VPWR VPWR _3070_ sky130_fd_sc_hd__clkbuf_4
XFILLER_0_65_559 VGND VGND VPWR VPWR sky130_fd_sc_hd__fill_1
X_7798_ net1286 u_analytics_engine.data_in\[9\] _3893_ VGND VGND VPWR VPWR _3897_
+ sky130_fd_sc_hd__mux2_1
X_6749_ _2915_ _2928_ _2948_ _3000_ VGND VGND VPWR VPWR _3001_ sky130_fd_sc_hd__or4_2
XFILLER_0_18_475 VGND VGND VPWR VPWR sky130_fd_sc_hd__fill_1
X_8419_ clknet_leaf_20_clk _0508_ VGND VGND VPWR VPWR u_input_buffer.fifo_mem\[37\]\[9\]
+ sky130_fd_sc_hd__dfxtp_1
XFILLER_0_60_253 VGND VGND VPWR VPWR sky130_fd_sc_hd__decap_4
XFILLER_0_88_618 VGND VGND VPWR VPWR sky130_fd_sc_hd__decap_8
XTAP_1541 VGND VPWR sky130_fd_sc_hd__tapvpwrvgnd_1
XTAP_1530 VGND VPWR sky130_fd_sc_hd__tapvpwrvgnd_1
XFILLER_0_113_27 VPWR VGND VPWR VGND sky130_ef_sc_hd__decap_12
XTAP_1585 VGND VPWR sky130_fd_sc_hd__tapvpwrvgnd_1
XTAP_1574 VGND VPWR sky130_fd_sc_hd__tapvpwrvgnd_1
XTAP_1563 VGND VPWR sky130_fd_sc_hd__tapvpwrvgnd_1
XTAP_1552 VGND VPWR sky130_fd_sc_hd__tapvpwrvgnd_1
XPHY_70 VGND VGND VPWR VPWR sky130_fd_sc_hd__decap_3
XPHY_81 VGND VGND VPWR VPWR sky130_fd_sc_hd__decap_3
XPHY_92 VGND VGND VPWR VPWR sky130_fd_sc_hd__decap_3
XTAP_1596 VGND VPWR sky130_fd_sc_hd__tapvpwrvgnd_1
XFILLER_0_36_250 VGND VGND VPWR VPWR sky130_fd_sc_hd__fill_2
XFILLER_0_43_209 VGND VGND VPWR VPWR sky130_fd_sc_hd__decap_4
XFILLER_0_98_29 VPWR VGND VPWR VGND sky130_ef_sc_hd__decap_12
XFILLER_0_106_160 VGND VGND VPWR VPWR sky130_fd_sc_hd__decap_6
XFILLER_0_12_618 VPWR VGND VPWR VGND sky130_ef_sc_hd__decap_12
XFILLER_0_11_139 VGND VGND VPWR VPWR sky130_fd_sc_hd__decap_4
X_4100_ _1420_ VGND VGND VPWR VPWR _1421_ sky130_fd_sc_hd__buf_2
X_5080_ net682 _2020_ _2023_ VGND VGND VPWR VPWR _2040_ sky130_fd_sc_hd__mux2_1
X_4031_ _1322_ VGND VGND VPWR VPWR _1367_ sky130_fd_sc_hd__clkbuf_8
X_8770_ clknet_leaf_41_clk _0859_ VGND VGND VPWR VPWR u_input_buffer.fifo_mem\[15\]\[8\]
+ sky130_fd_sc_hd__dfxtp_1
XFILLER_0_63_65 VGND VGND VPWR VPWR sky130_fd_sc_hd__decap_3
X_5982_ _2536_ VGND VGND VPWR VPWR _0823_ sky130_fd_sc_hd__clkbuf_1
X_4933_ _1954_ VGND VGND VPWR VPWR _0356_ sky130_fd_sc_hd__clkbuf_1
X_7721_ _3842_ VGND VGND VPWR VPWR _1256_ sky130_fd_sc_hd__clkbuf_1
XANTENNA_13 net7 VGND VGND VPWR VPWR sky130_fd_sc_hd__diode_2
XFILLER_0_86_194 VGND VGND VPWR VPWR sky130_fd_sc_hd__fill_2
X_4864_ net382 _1710_ _1912_ VGND VGND VPWR VPWR _1916_ sky130_fd_sc_hd__mux2_1
X_7652_ _3789_ VGND VGND VPWR VPWR _1240_ sky130_fd_sc_hd__clkbuf_1
XFILLER_0_7_612 VGND VGND VPWR VPWR sky130_fd_sc_hd__decap_4
X_7583_ _3746_ VGND VGND VPWR VPWR _1214_ sky130_fd_sc_hd__clkbuf_1
X_4795_ _1878_ VGND VGND VPWR VPWR _0294_ sky130_fd_sc_hd__clkbuf_1
X_6603_ _2868_ _2869_ _2861_ VGND VGND VPWR VPWR _1111_ sky130_fd_sc_hd__o21a_1
XFILLER_0_6_122 VGND VGND VPWR VPWR sky130_fd_sc_hd__decap_4
XANTENNA_24 net52 VGND VGND VPWR VPWR sky130_fd_sc_hd__diode_2
XANTENNA_35 net98 VGND VGND VPWR VPWR sky130_fd_sc_hd__diode_2
XANTENNA_46 _2938_ VGND VGND VPWR VPWR sky130_fd_sc_hd__diode_2
XANTENNA_57 u_analytics_engine.data_in\[12\] VGND VGND VPWR VPWR sky130_fd_sc_hd__diode_2
XFILLER_0_103_93 VPWR VGND VPWR VGND sky130_ef_sc_hd__decap_12
X_6534_ _2831_ VGND VGND VPWR VPWR _1080_ sky130_fd_sc_hd__clkbuf_1
X_6465_ net435 _1408_ _2789_ VGND VGND VPWR VPWR _2795_ sky130_fd_sc_hd__mux2_1
XFILLER_0_70_573 VGND VGND VPWR VPWR sky130_fd_sc_hd__fill_1
XFILLER_0_113_653 VPWR VGND VPWR VGND sky130_ef_sc_hd__decap_12
X_8204_ clknet_leaf_36_clk _0293_ VGND VGND VPWR VPWR u_input_buffer.fifo_mem\[50\]\[2\]
+ sky130_fd_sc_hd__dfxtp_1
XFILLER_0_88_73 VGND VGND VPWR VPWR sky130_fd_sc_hd__fill_2
X_5416_ _2218_ VGND VGND VPWR VPWR _0575_ sky130_fd_sc_hd__clkbuf_1
Xoutput131 net131 VGND VGND VPWR VPWR cfg_rdata[25] sky130_fd_sc_hd__clkbuf_4
Xoutput142 net142 VGND VGND VPWR VPWR cfg_rdata[6] sky130_fd_sc_hd__buf_2
X_9184_ clknet_leaf_64_clk _1272_ net196 VGND VGND VPWR VPWR net156 sky130_fd_sc_hd__dfrtp_1
Xoutput120 net120 VGND VGND VPWR VPWR cfg_rdata[15] sky130_fd_sc_hd__clkbuf_4
X_6396_ _2758_ VGND VGND VPWR VPWR _1015_ sky130_fd_sc_hd__clkbuf_1
XFILLER_0_30_448 VGND VGND VPWR VPWR sky130_fd_sc_hd__fill_1
X_8135_ clknet_leaf_101_clk _0224_ VGND VGND VPWR VPWR u_input_buffer.fifo_mem\[55\]\[13\]
+ sky130_fd_sc_hd__dfxtp_1
Xoutput153 net153 VGND VGND VPWR VPWR processed_data_out[14] sky130_fd_sc_hd__buf_2
X_5347_ net786 _2014_ _2168_ VGND VGND VPWR VPWR _2182_ sky130_fd_sc_hd__mux2_1
X_8066_ clknet_leaf_69_clk _0155_ VGND VGND VPWR VPWR u_input_buffer.fifo_mem\[59\]\[8\]
+ sky130_fd_sc_hd__dfxtp_1
X_5278_ _2145_ VGND VGND VPWR VPWR _0510_ sky130_fd_sc_hd__clkbuf_1
X_7017_ u_input_buffer.fifo_mem\[30\]\[5\] _3029_ _3031_ u_input_buffer.fifo_mem\[58\]\[5\]
+ VGND VGND VPWR VPWR _3264_ sky130_fd_sc_hd__a22o_1
X_4229_ u_sample_counter.sample_count\[22\] u_sample_counter.sample_count\[23\] VGND
+ VGND VPWR VPWR _1518_ sky130_fd_sc_hd__and2_1
X_8968_ clknet_leaf_88_clk _1057_ VGND VGND VPWR VPWR u_input_buffer.fifo_mem\[3\]\[14\]
+ sky130_fd_sc_hd__dfxtp_1
X_7919_ clknet_leaf_23_clk _0009_ VGND VGND VPWR VPWR u_sensor_interface.sensor_array\[2\]\[7\]
+ sky130_fd_sc_hd__dfxtp_1
XFILLER_0_93_610 VGND VGND VPWR VPWR sky130_fd_sc_hd__decap_6
X_8899_ clknet_leaf_68_clk _0988_ VGND VGND VPWR VPWR u_input_buffer.fifo_mem\[7\]\[9\]
+ sky130_fd_sc_hd__dfxtp_1
XFILLER_0_93_643 VGND VGND VPWR VPWR sky130_fd_sc_hd__decap_8
XFILLER_0_18_261 VGND VGND VPWR VPWR sky130_fd_sc_hd__decap_6
XFILLER_0_0_309 VGND VGND VPWR VPWR sky130_fd_sc_hd__fill_2
XFILLER_0_108_27 VGND VGND VPWR VPWR sky130_fd_sc_hd__fill_1
XFILLER_0_69_673 VGND VGND VPWR VPWR sky130_fd_sc_hd__fill_1
XFILLER_0_8_409 VGND VGND VPWR VPWR sky130_fd_sc_hd__fill_2
XTAP_1393 VGND VPWR sky130_fd_sc_hd__tapvpwrvgnd_1
XTAP_1382 VGND VPWR sky130_fd_sc_hd__tapvpwrvgnd_1
XTAP_1371 VGND VPWR sky130_fd_sc_hd__tapvpwrvgnd_1
XTAP_1360 VGND VPWR sky130_fd_sc_hd__tapvpwrvgnd_1
XFILLER_0_84_654 VGND VGND VPWR VPWR sky130_fd_sc_hd__decap_8
XFILLER_0_56_389 VGND VGND VPWR VPWR sky130_fd_sc_hd__fill_2
X_4580_ _1760_ VGND VGND VPWR VPWR _0197_ sky130_fd_sc_hd__clkbuf_1
Xinput22 cfg_wdata[19] VGND VGND VPWR VPWR net22 sky130_fd_sc_hd__clkbuf_2
XFILLER_0_71_337 VGND VGND VPWR VPWR sky130_fd_sc_hd__fill_2
Xinput11 cfg_rst_n VGND VGND VPWR VPWR net11 sky130_fd_sc_hd__clkbuf_2
Xinput33 cfg_wdata[29] VGND VGND VPWR VPWR net33 sky130_fd_sc_hd__dlymetal6s2s_1
XFILLER_0_109_3 VPWR VGND VPWR VGND sky130_ef_sc_hd__decap_12
XFILLER_0_4_637 VGND VGND VPWR VPWR sky130_fd_sc_hd__decap_6
XFILLER_0_3_103 VGND VGND VPWR VPWR sky130_fd_sc_hd__fill_2
Xinput55 sensor_data_in[18] VGND VGND VPWR VPWR net55 sky130_fd_sc_hd__clkbuf_1
Xinput44 cfg_write VGND VGND VPWR VPWR net44 sky130_fd_sc_hd__clkbuf_4
XFILLER_0_24_231 VGND VGND VPWR VPWR sky130_fd_sc_hd__decap_8
Xinput88 sensor_data_in[48] VGND VGND VPWR VPWR net88 sky130_fd_sc_hd__clkbuf_1
Xhold828 u_input_buffer.fifo_mem\[22\]\[1\] VGND VGND VPWR VPWR net1040 sky130_fd_sc_hd__dlygate4sd3_1
Xhold806 u_input_buffer.fifo_mem\[31\]\[9\] VGND VGND VPWR VPWR net1018 sky130_fd_sc_hd__dlygate4sd3_1
XFILLER_0_3_169 VGND VGND VPWR VPWR sky130_fd_sc_hd__fill_2
Xinput66 sensor_data_in[28] VGND VGND VPWR VPWR net66 sky130_fd_sc_hd__clkbuf_1
Xinput77 sensor_data_in[38] VGND VGND VPWR VPWR net77 sky130_fd_sc_hd__buf_1
Xhold817 u_input_buffer.fifo_mem\[12\]\[12\] VGND VGND VPWR VPWR net1029 sky130_fd_sc_hd__dlygate4sd3_1
XFILLER_0_110_601 VPWR VGND VPWR VGND sky130_ef_sc_hd__decap_12
X_6250_ _1588_ net799 _2680_ VGND VGND VPWR VPWR _2681_ sky130_fd_sc_hd__mux2_1
Xhold839 u_input_buffer.fifo_mem\[60\]\[12\] VGND VGND VPWR VPWR net1051 sky130_fd_sc_hd__dlygate4sd3_1
Xinput99 sensor_data_in[58] VGND VGND VPWR VPWR net99 sky130_fd_sc_hd__clkbuf_1
XFILLER_0_110_645 VPWR VGND VPWR VGND sky130_ef_sc_hd__decap_12
X_5201_ net753 _2004_ _2097_ VGND VGND VPWR VPWR _2105_ sky130_fd_sc_hd__mux2_1
X_6181_ _2643_ VGND VGND VPWR VPWR _2644_ sky130_fd_sc_hd__buf_4
XFILLER_0_58_32 VPWR VGND VPWR VGND sky130_ef_sc_hd__decap_12
X_5132_ _1421_ net1053 _2060_ VGND VGND VPWR VPWR _2068_ sky130_fd_sc_hd__mux2_1
X_5063_ _2031_ VGND VGND VPWR VPWR _0409_ sky130_fd_sc_hd__clkbuf_1
X_4014_ _1358_ VGND VGND VPWR VPWR _0033_ sky130_fd_sc_hd__clkbuf_1
X_8822_ clknet_leaf_10_clk _0911_ VGND VGND VPWR VPWR u_input_buffer.fifo_mem\[12\]\[12\]
+ sky130_fd_sc_hd__dfxtp_1
XFILLER_0_94_429 VGND VGND VPWR VPWR sky130_fd_sc_hd__fill_2
XFILLER_0_90_41 VPWR VGND VPWR VGND sky130_ef_sc_hd__decap_12
X_8753_ clknet_leaf_17_clk _0842_ VGND VGND VPWR VPWR u_input_buffer.fifo_mem\[16\]\[7\]
+ sky130_fd_sc_hd__dfxtp_1
X_5965_ _1462_ VGND VGND VPWR VPWR _2526_ sky130_fd_sc_hd__clkbuf_4
X_8684_ clknet_leaf_51_clk _0773_ VGND VGND VPWR VPWR u_input_buffer.fifo_mem\[20\]\[2\]
+ sky130_fd_sc_hd__dfxtp_1
XFILLER_0_90_85 VGND VGND VPWR VPWR sky130_fd_sc_hd__fill_1
XFILLER_0_75_665 VGND VGND VPWR VPWR sky130_fd_sc_hd__decap_6
XFILLER_0_74_120 VGND VGND VPWR VPWR sky130_fd_sc_hd__fill_1
X_5896_ _2483_ VGND VGND VPWR VPWR _0790_ sky130_fd_sc_hd__clkbuf_1
X_7704_ _3829_ net119 _3817_ VGND VGND VPWR VPWR _3830_ sky130_fd_sc_hd__mux2_1
X_4916_ net343 _1724_ _1933_ VGND VGND VPWR VPWR _1945_ sky130_fd_sc_hd__mux2_1
XFILLER_0_75_676 VGND VGND VPWR VPWR sky130_fd_sc_hd__decap_6
X_4847_ _1451_ net1289 _1892_ VGND VGND VPWR VPWR _1906_ sky130_fd_sc_hd__mux2_1
XFILLER_0_47_389 VGND VGND VPWR VPWR sky130_fd_sc_hd__decap_3
X_7635_ _3774_ VGND VGND VPWR VPWR _3775_ sky130_fd_sc_hd__clkbuf_4
XFILLER_0_90_657 VGND VGND VPWR VPWR sky130_fd_sc_hd__fill_2
XFILLER_0_90_668 VGND VGND VPWR VPWR sky130_fd_sc_hd__fill_2
X_7566_ net12 u_analytics_engine.threshold\[0\] _3737_ VGND VGND VPWR VPWR _3738_
+ sky130_fd_sc_hd__mux2_1
X_4778_ _1868_ VGND VGND VPWR VPWR _0287_ sky130_fd_sc_hd__clkbuf_1
X_7497_ net12 u_register_bank.window_cfg\[0\] _3700_ VGND VGND VPWR VPWR _3701_ sky130_fd_sc_hd__mux2_1
X_6517_ net521 _1462_ _2806_ VGND VGND VPWR VPWR _2822_ sky130_fd_sc_hd__mux2_1
XFILLER_0_101_612 VGND VGND VPWR VPWR sky130_fd_sc_hd__decap_4
X_6448_ _2785_ VGND VGND VPWR VPWR _1040_ sky130_fd_sc_hd__clkbuf_1
X_9167_ net168 _1255_ VGND VGND VPWR VPWR net122 sky130_fd_sc_hd__dfxtp_1
X_6379_ net285 _2524_ _2734_ VGND VGND VPWR VPWR _2749_ sky130_fd_sc_hd__mux2_1
X_8118_ clknet_leaf_74_clk _0207_ VGND VGND VPWR VPWR u_input_buffer.fifo_mem\[56\]\[12\]
+ sky130_fd_sc_hd__dfxtp_1
X_9098_ net170 _1186_ net203 VGND VGND VPWR VPWR u_register_bank.window_cfg\[12\]
+ sky130_fd_sc_hd__dfrtp_1
X_8049_ clknet_leaf_40_clk _0138_ VGND VGND VPWR VPWR u_input_buffer.fifo_mem\[60\]\[7\]
+ sky130_fd_sc_hd__dfxtp_1
XFILLER_0_38_389 VGND VGND VPWR VPWR sky130_fd_sc_hd__decap_4
XFILLER_0_80_112 VGND VGND VPWR VPWR sky130_fd_sc_hd__decap_3
XFILLER_0_19_592 VGND VGND VPWR VPWR sky130_fd_sc_hd__fill_2
XFILLER_0_53_337 VGND VGND VPWR VPWR sky130_fd_sc_hd__fill_2
XFILLER_0_53_348 VGND VGND VPWR VPWR sky130_fd_sc_hd__fill_1
XFILLER_0_21_201 VGND VGND VPWR VPWR sky130_fd_sc_hd__fill_2
XFILLER_0_1_629 VPWR VGND VPWR VGND sky130_ef_sc_hd__decap_12
Xclkbuf_leaf_100_clk clknet_3_0__leaf_clk VGND VGND VPWR VPWR clknet_leaf_100_clk
+ sky130_fd_sc_hd__clkbuf_16
XFILLER_0_21_289 VGND VGND VPWR VPWR sky130_fd_sc_hd__fill_1
XTAP_418 VGND VPWR sky130_fd_sc_hd__tapvpwrvgnd_1
XTAP_407 VGND VPWR sky130_fd_sc_hd__tapvpwrvgnd_1
XTAP_429 VGND VPWR sky130_fd_sc_hd__tapvpwrvgnd_1
XFILLER_0_48_109 VGND VGND VPWR VPWR sky130_fd_sc_hd__fill_1
XFILLER_0_57_654 VGND VGND VPWR VPWR sky130_fd_sc_hd__decap_6
XFILLER_0_29_345 VGND VGND VPWR VPWR sky130_fd_sc_hd__decap_3
X_5750_ _1775_ _2295_ VGND VGND VPWR VPWR _2405_ sky130_fd_sc_hd__and2_1
XTAP_1190 VGND VPWR sky130_fd_sc_hd__tapvpwrvgnd_1
X_5681_ _2368_ VGND VGND VPWR VPWR _0690_ sky130_fd_sc_hd__clkbuf_1
XFILLER_0_17_529 VGND VGND VPWR VPWR sky130_fd_sc_hd__fill_1
X_4701_ _1433_ net921 _1817_ VGND VGND VPWR VPWR _1827_ sky130_fd_sc_hd__mux2_1
XFILLER_0_56_197 VGND VGND VPWR VPWR sky130_fd_sc_hd__fill_2
X_4632_ net289 _1724_ _1777_ VGND VGND VPWR VPWR _1789_ sky130_fd_sc_hd__mux2_1
X_7420_ _3650_ _3652_ _3654_ _3656_ VGND VGND VPWR VPWR _3657_ sky130_fd_sc_hd__or4_1
Xhold603 u_input_buffer.fifo_mem\[56\]\[3\] VGND VGND VPWR VPWR net815 sky130_fd_sc_hd__dlygate4sd3_1
X_4563_ _1750_ VGND VGND VPWR VPWR _0190_ sky130_fd_sc_hd__clkbuf_1
X_7351_ u_input_buffer.fifo_mem\[17\]\[14\] _2942_ _2944_ u_input_buffer.fifo_mem\[5\]\[14\]
+ VGND VGND VPWR VPWR _3589_ sky130_fd_sc_hd__a22o_1
X_4494_ _1707_ VGND VGND VPWR VPWR _0164_ sky130_fd_sc_hd__clkbuf_1
Xhold636 u_input_buffer.fifo_mem\[4\]\[6\] VGND VGND VPWR VPWR net848 sky130_fd_sc_hd__dlygate4sd3_1
XFILLER_0_69_42 VGND VGND VPWR VPWR sky130_fd_sc_hd__decap_4
X_6302_ net581 _2516_ _2698_ VGND VGND VPWR VPWR _2708_ sky130_fd_sc_hd__mux2_1
Xhold625 u_input_buffer.fifo_mem\[61\]\[11\] VGND VGND VPWR VPWR net837 sky130_fd_sc_hd__dlygate4sd3_1
Xhold614 u_input_buffer.fifo_mem\[55\]\[13\] VGND VGND VPWR VPWR net826 sky130_fd_sc_hd__dlygate4sd3_1
X_7282_ u_input_buffer.fifo_mem\[50\]\[12\] _2994_ _2996_ u_input_buffer.fifo_mem\[4\]\[12\]
+ VGND VGND VPWR VPWR _3522_ sky130_fd_sc_hd__a22o_1
Xhold647 u_input_buffer.fifo_mem\[40\]\[3\] VGND VGND VPWR VPWR net859 sky130_fd_sc_hd__dlygate4sd3_1
XFILLER_0_100_83 VGND VGND VPWR VPWR sky130_fd_sc_hd__fill_1
Xhold669 u_input_buffer.fifo_mem\[46\]\[4\] VGND VGND VPWR VPWR net881 sky130_fd_sc_hd__dlygate4sd3_1
Xhold658 u_input_buffer.fifo_mem\[31\]\[7\] VGND VGND VPWR VPWR net870 sky130_fd_sc_hd__dlygate4sd3_1
X_6233_ _2671_ VGND VGND VPWR VPWR _0939_ sky130_fd_sc_hd__clkbuf_1
X_9021_ clknet_leaf_86_clk _1110_ net189 VGND VGND VPWR VPWR u_input_buffer.count\[3\]
+ sky130_fd_sc_hd__dfrtp_1
XFILLER_0_110_475 VGND VGND VPWR VPWR sky130_fd_sc_hd__fill_1
XFILLER_0_0_673 VGND VGND VPWR VPWR sky130_fd_sc_hd__fill_2
XFILLER_0_110_486 VGND VGND VPWR VPWR sky130_fd_sc_hd__fill_1
XFILLER_0_85_30 VPWR VGND VPWR VGND sky130_ef_sc_hd__decap_12
X_6164_ _2634_ VGND VGND VPWR VPWR _0907_ sky130_fd_sc_hd__clkbuf_1
XTAP_952 VGND VPWR sky130_fd_sc_hd__tapvpwrvgnd_1
XTAP_941 VGND VPWR sky130_fd_sc_hd__tapvpwrvgnd_1
XTAP_930 VGND VPWR sky130_fd_sc_hd__tapvpwrvgnd_1
X_6095_ net600 _2516_ _2587_ VGND VGND VPWR VPWR _2597_ sky130_fd_sc_hd__mux2_1
XTAP_996 VGND VPWR sky130_fd_sc_hd__tapvpwrvgnd_1
XTAP_985 VGND VPWR sky130_fd_sc_hd__tapvpwrvgnd_1
XTAP_963 VGND VPWR sky130_fd_sc_hd__tapvpwrvgnd_1
XTAP_974 VGND VPWR sky130_fd_sc_hd__tapvpwrvgnd_1
X_5115_ _2058_ VGND VGND VPWR VPWR _0434_ sky130_fd_sc_hd__clkbuf_1
XFILLER_0_109_81 VPWR VGND VPWR VGND sky130_ef_sc_hd__decap_12
XFILLER_0_33_3 VGND VGND VPWR VPWR sky130_fd_sc_hd__fill_1
X_5046_ _2021_ VGND VGND VPWR VPWR _0402_ sky130_fd_sc_hd__clkbuf_1
XFILLER_0_79_278 VGND VGND VPWR VPWR sky130_fd_sc_hd__fill_2
X_6997_ u_input_buffer.fifo_mem\[37\]\[5\] _2923_ _2926_ u_input_buffer.fifo_mem\[9\]\[5\]
+ VGND VGND VPWR VPWR _3244_ sky130_fd_sc_hd__a22o_1
X_8805_ clknet_leaf_108_clk _0894_ VGND VGND VPWR VPWR u_input_buffer.fifo_mem\[13\]\[11\]
+ sky130_fd_sc_hd__dfxtp_1
XFILLER_0_94_248 VGND VGND VPWR VPWR sky130_fd_sc_hd__fill_1
XFILLER_0_94_237 VGND VGND VPWR VPWR sky130_fd_sc_hd__fill_2
X_5948_ net1205 _2514_ _2498_ VGND VGND VPWR VPWR _2515_ sky130_fd_sc_hd__mux2_1
X_8736_ clknet_leaf_0_clk _0825_ VGND VGND VPWR VPWR u_input_buffer.fifo_mem\[17\]\[6\]
+ sky130_fd_sc_hd__dfxtp_1
X_5879_ net1219 _2268_ _2460_ VGND VGND VPWR VPWR _2474_ sky130_fd_sc_hd__mux2_1
XFILLER_0_35_337 VGND VGND VPWR VPWR sky130_fd_sc_hd__fill_2
XFILLER_0_35_348 VGND VGND VPWR VPWR sky130_fd_sc_hd__decap_3
X_8667_ clknet_leaf_5_clk _0756_ VGND VGND VPWR VPWR u_input_buffer.fifo_mem\[21\]\[1\]
+ sky130_fd_sc_hd__dfxtp_1
XFILLER_0_105_225 VGND VGND VPWR VPWR sky130_fd_sc_hd__fill_1
XFILLER_0_90_465 VGND VGND VPWR VPWR sky130_fd_sc_hd__decap_4
XFILLER_0_90_454 VGND VGND VPWR VPWR sky130_fd_sc_hd__decap_4
X_7618_ net29 u_register_bank.threshold_cfg\[25\] _3759_ VGND VGND VPWR VPWR _3765_
+ sky130_fd_sc_hd__mux2_1
X_8598_ clknet_leaf_87_clk _0687_ VGND VGND VPWR VPWR u_input_buffer.fifo_mem\[26\]\[12\]
+ sky130_fd_sc_hd__dfxtp_1
X_7549_ net29 u_register_bank.window_cfg\[25\] _3722_ VGND VGND VPWR VPWR _3728_ sky130_fd_sc_hd__mux2_1
XFILLER_0_101_431 VGND VGND VPWR VPWR sky130_fd_sc_hd__fill_1
X_9219_ net176 _1306_ net208 VGND VGND VPWR VPWR u_register_bank.sensor_enable\[20\]
+ sky130_fd_sc_hd__dfrtp_1
XFILLER_0_101_497 VGND VGND VPWR VPWR sky130_fd_sc_hd__decap_6
XFILLER_0_98_510 VGND VGND VPWR VPWR sky130_fd_sc_hd__decap_6
XFILLER_0_105_39 VPWR VGND VPWR VGND sky130_ef_sc_hd__decap_12
XFILLER_0_38_197 VGND VGND VPWR VPWR sky130_fd_sc_hd__fill_2
XFILLER_0_54_657 VGND VGND VPWR VPWR sky130_fd_sc_hd__fill_2
XFILLER_0_34_392 VGND VGND VPWR VPWR sky130_fd_sc_hd__fill_1
XTAP_237 VGND VPWR sky130_fd_sc_hd__tapvpwrvgnd_1
XTAP_248 VGND VPWR sky130_fd_sc_hd__tapvpwrvgnd_1
XTAP_259 VGND VPWR sky130_fd_sc_hd__tapvpwrvgnd_1
X_6920_ u_input_buffer.fifo_mem\[41\]\[3\] _2919_ _2921_ u_input_buffer.fifo_mem\[45\]\[3\]
+ _3168_ VGND VGND VPWR VPWR _3169_ sky130_fd_sc_hd__a221o_1
X_6851_ u_input_buffer.fifo_mem\[2\]\[1\] _2984_ _2986_ u_input_buffer.fifo_mem\[32\]\[1\]
+ VGND VGND VPWR VPWR _3102_ sky130_fd_sc_hd__a22o_1
X_5802_ _2433_ VGND VGND VPWR VPWR _0746_ sky130_fd_sc_hd__clkbuf_1
XFILLER_0_57_473 VGND VGND VPWR VPWR sky130_fd_sc_hd__decap_3
XFILLER_0_9_559 VGND VGND VPWR VPWR sky130_fd_sc_hd__fill_1
X_3994_ u_sensor_interface.sensor_array\[1\]\[6\] net60 _1345_ VGND VGND VPWR VPWR
+ _1348_ sky130_fd_sc_hd__mux2_1
X_8521_ clknet_leaf_92_clk _0610_ VGND VGND VPWR VPWR u_input_buffer.fifo_mem\[31\]\[15\]
+ sky130_fd_sc_hd__dfxtp_1
X_6782_ _2924_ _3018_ VGND VGND VPWR VPWR _3034_ sky130_fd_sc_hd__and2_2
X_5733_ _2396_ VGND VGND VPWR VPWR _0714_ sky130_fd_sc_hd__clkbuf_1
XFILLER_0_72_421 VGND VGND VPWR VPWR sky130_fd_sc_hd__decap_6
XFILLER_0_17_337 VGND VGND VPWR VPWR sky130_fd_sc_hd__decap_4
XFILLER_0_44_112 VGND VGND VPWR VPWR sky130_fd_sc_hd__fill_2
X_5664_ net836 _2258_ _2352_ VGND VGND VPWR VPWR _2360_ sky130_fd_sc_hd__mux2_1
X_8452_ clknet_leaf_13_clk _0541_ VGND VGND VPWR VPWR u_input_buffer.fifo_mem\[35\]\[10\]
+ sky130_fd_sc_hd__dfxtp_1
XFILLER_0_115_545 VPWR VGND VPWR VGND sky130_ef_sc_hd__decap_12
X_8383_ clknet_leaf_51_clk _0472_ VGND VGND VPWR VPWR u_input_buffer.fifo_mem\[39\]\[5\]
+ sky130_fd_sc_hd__dfxtp_1
X_5595_ net1024 _2258_ _2315_ VGND VGND VPWR VPWR _2323_ sky130_fd_sc_hd__mux2_1
X_4615_ _1780_ VGND VGND VPWR VPWR _0212_ sky130_fd_sc_hd__clkbuf_1
XFILLER_0_4_231 VGND VGND VPWR VPWR sky130_fd_sc_hd__fill_2
XFILLER_0_32_307 VGND VGND VPWR VPWR sky130_fd_sc_hd__fill_1
X_7403_ u_input_buffer.fifo_mem\[47\]\[15\] _2879_ _2917_ _3008_ u_input_buffer.fifo_mem\[24\]\[15\]
+ VGND VGND VPWR VPWR _3640_ sky130_fd_sc_hd__a32o_1
XFILLER_0_44_189 VGND VGND VPWR VPWR sky130_fd_sc_hd__fill_1
XFILLER_0_115_589 VGND VGND VPWR VPWR sky130_fd_sc_hd__decap_8
Xhold400 u_input_buffer.fifo_mem\[12\]\[7\] VGND VGND VPWR VPWR net612 sky130_fd_sc_hd__dlygate4sd3_1
XFILLER_0_4_275 VGND VGND VPWR VPWR sky130_fd_sc_hd__fill_2
X_7334_ u_input_buffer.fifo_mem\[39\]\[13\] _3049_ _3051_ u_input_buffer.fifo_mem\[40\]\[13\]
+ VGND VGND VPWR VPWR _3573_ sky130_fd_sc_hd__a22o_1
X_4546_ _1397_ net1271 _1738_ VGND VGND VPWR VPWR _1742_ sky130_fd_sc_hd__mux2_1
Xhold411 u_input_buffer.fifo_mem\[6\]\[11\] VGND VGND VPWR VPWR net623 sky130_fd_sc_hd__dlygate4sd3_1
XFILLER_0_111_93 VPWR VGND VPWR VGND sky130_ef_sc_hd__decap_12
XFILLER_0_102_228 VGND VGND VPWR VPWR sky130_fd_sc_hd__decap_6
Xhold433 u_input_buffer.fifo_mem\[62\]\[7\] VGND VGND VPWR VPWR net645 sky130_fd_sc_hd__dlygate4sd3_1
Xhold444 u_input_buffer.fifo_mem\[31\]\[8\] VGND VGND VPWR VPWR net656 sky130_fd_sc_hd__dlygate4sd3_1
Xhold422 u_input_buffer.fifo_mem\[7\]\[8\] VGND VGND VPWR VPWR net634 sky130_fd_sc_hd__dlygate4sd3_1
X_4477_ net1277 _1626_ _1682_ VGND VGND VPWR VPWR _1696_ sky130_fd_sc_hd__mux2_1
X_7265_ _3487_ _3496_ _3505_ VGND VGND VPWR VPWR _3506_ sky130_fd_sc_hd__or3_1
Xhold455 u_input_buffer.fifo_mem\[29\]\[1\] VGND VGND VPWR VPWR net667 sky130_fd_sc_hd__dlygate4sd3_1
XFILLER_0_40_373 VGND VGND VPWR VPWR sky130_fd_sc_hd__fill_2
Xhold477 u_input_buffer.fifo_mem\[56\]\[12\] VGND VGND VPWR VPWR net689 sky130_fd_sc_hd__dlygate4sd3_1
Xhold466 u_input_buffer.fifo_mem\[8\]\[13\] VGND VGND VPWR VPWR net678 sky130_fd_sc_hd__dlygate4sd3_1
X_6216_ net625 _2496_ _2662_ VGND VGND VPWR VPWR _2663_ sky130_fd_sc_hd__mux2_1
Xhold488 u_input_buffer.fifo_mem\[28\]\[5\] VGND VGND VPWR VPWR net700 sky130_fd_sc_hd__dlygate4sd3_1
X_9004_ clknet_leaf_47_clk _1093_ VGND VGND VPWR VPWR u_input_buffer.fifo_mem\[0\]\[2\]
+ sky130_fd_sc_hd__dfxtp_1
Xhold499 u_input_buffer.fifo_mem\[34\]\[3\] VGND VGND VPWR VPWR net711 sky130_fd_sc_hd__dlygate4sd3_1
X_7196_ u_input_buffer.fifo_mem\[29\]\[10\] _2938_ _2940_ u_input_buffer.fifo_mem\[13\]\[10\]
+ _3437_ VGND VGND VPWR VPWR _3438_ sky130_fd_sc_hd__a221o_1
X_6147_ net533 _2496_ _2625_ VGND VGND VPWR VPWR _2626_ sky130_fd_sc_hd__mux2_1
Xhold1100 u_input_buffer.count\[5\] VGND VGND VPWR VPWR net1312 sky130_fd_sc_hd__dlygate4sd3_1
XTAP_760 VGND VPWR sky130_fd_sc_hd__tapvpwrvgnd_1
Xhold1111 net154 VGND VGND VPWR VPWR net1323 sky130_fd_sc_hd__dlygate4sd3_1
XTAP_771 VGND VPWR sky130_fd_sc_hd__tapvpwrvgnd_1
XTAP_782 VGND VPWR sky130_fd_sc_hd__tapvpwrvgnd_1
XTAP_793 VGND VPWR sky130_fd_sc_hd__tapvpwrvgnd_1
X_6078_ _2588_ VGND VGND VPWR VPWR _0867_ sky130_fd_sc_hd__clkbuf_1
X_5029_ _1438_ VGND VGND VPWR VPWR _2010_ sky130_fd_sc_hd__buf_2
X_8719_ clknet_leaf_29_clk _0808_ VGND VGND VPWR VPWR u_input_buffer.fifo_mem\[18\]\[5\]
+ sky130_fd_sc_hd__dfxtp_1
XFILLER_0_8_570 VPWR VGND VPWR VGND sky130_ef_sc_hd__decap_12
XFILLER_0_106_545 VGND VGND VPWR VPWR sky130_fd_sc_hd__fill_1
XFILLER_0_35_178 VGND VGND VPWR VPWR sky130_fd_sc_hd__decap_4
XFILLER_0_106_589 VGND VGND VPWR VPWR sky130_fd_sc_hd__fill_2
XFILLER_0_31_351 VGND VGND VPWR VPWR sky130_fd_sc_hd__decap_4
XFILLER_0_41_13 VGND VGND VPWR VPWR sky130_fd_sc_hd__fill_1
XFILLER_0_26_101 VGND VGND VPWR VPWR sky130_fd_sc_hd__decap_4
X_4400_ _1652_ VGND VGND VPWR VPWR _0125_ sky130_fd_sc_hd__clkbuf_1
X_5380_ _2199_ VGND VGND VPWR VPWR _0558_ sky130_fd_sc_hd__clkbuf_1
X_4331_ _1607_ VGND VGND VPWR VPWR _0101_ sky130_fd_sc_hd__clkbuf_1
XFILLER_0_1_245 VGND VGND VPWR VPWR sky130_fd_sc_hd__decap_6
X_7050_ _3289_ _3291_ _3293_ _3295_ VGND VGND VPWR VPWR _3296_ sky130_fd_sc_hd__or4_1
Xfanout209 net212 VGND VGND VPWR VPWR net209 sky130_fd_sc_hd__clkbuf_4
XFILLER_0_10_557 VPWR VGND VPWR VGND sky130_ef_sc_hd__decap_12
X_4262_ u_analytics_engine.threshold\[11\] VGND VGND VPWR VPWR _1542_ sky130_fd_sc_hd__inv_2
XFILLER_0_5_57 VGND VGND VPWR VPWR sky130_fd_sc_hd__fill_1
X_6001_ _1630_ net781 _2530_ VGND VGND VPWR VPWR _2546_ sky130_fd_sc_hd__mux2_1
X_4193_ _1493_ VGND VGND VPWR VPWR _1494_ sky130_fd_sc_hd__buf_2
X_7952_ clknet_leaf_32_clk _0042_ VGND VGND VPWR VPWR u_sensor_interface.sensor_array\[0\]\[8\]
+ sky130_fd_sc_hd__dfxtp_1
X_6903_ u_input_buffer.fifo_mem\[6\]\[2\] _3035_ _3037_ u_input_buffer.fifo_mem\[28\]\[2\]
+ _3152_ VGND VGND VPWR VPWR _3153_ sky130_fd_sc_hd__a221o_1
XFILLER_0_77_502 VGND VGND VPWR VPWR sky130_fd_sc_hd__fill_2
X_7883_ clknet_leaf_57_clk net233 net198 VGND VGND VPWR VPWR u_register_bank.status_flags\[3\]
+ sky130_fd_sc_hd__dfrtp_1
XFILLER_0_49_237 VGND VGND VPWR VPWR sky130_fd_sc_hd__decap_3
X_6834_ _3085_ VGND VGND VPWR VPWR _3086_ sky130_fd_sc_hd__clkbuf_4
X_6765_ _3016_ VGND VGND VPWR VPWR _3017_ sky130_fd_sc_hd__clkbuf_4
X_3977_ net411 net86 _1334_ VGND VGND VPWR VPWR _1339_ sky130_fd_sc_hd__mux2_1
X_5716_ _1755_ _2242_ VGND VGND VPWR VPWR _2387_ sky130_fd_sc_hd__nor2_4
X_8504_ clknet_leaf_12_clk _0593_ VGND VGND VPWR VPWR u_input_buffer.fifo_mem\[32\]\[14\]
+ sky130_fd_sc_hd__dfxtp_1
XFILLER_0_115_342 VGND VGND VPWR VPWR sky130_fd_sc_hd__decap_6
X_8435_ clknet_leaf_28_clk _0524_ VGND VGND VPWR VPWR u_input_buffer.fifo_mem\[36\]\[9\]
+ sky130_fd_sc_hd__dfxtp_1
XFILLER_0_17_167 VGND VGND VPWR VPWR sky130_fd_sc_hd__fill_1
X_6696_ u_input_buffer.fifo_mem\[1\]\[0\] _2932_ _2937_ _2947_ VGND VGND VPWR VPWR
+ _2948_ sky130_fd_sc_hd__a211o_1
XFILLER_0_45_476 VGND VGND VPWR VPWR sky130_fd_sc_hd__fill_2
XFILLER_0_5_573 VPWR VGND VPWR VGND sky130_ef_sc_hd__decap_12
X_5647_ _2350_ VGND VGND VPWR VPWR _0674_ sky130_fd_sc_hd__clkbuf_1
X_8366_ clknet_leaf_49_clk _0455_ VGND VGND VPWR VPWR u_input_buffer.fifo_mem\[40\]\[4\]
+ sky130_fd_sc_hd__dfxtp_1
X_5578_ _2313_ VGND VGND VPWR VPWR _0642_ sky130_fd_sc_hd__clkbuf_1
Xhold252 u_input_buffer.fifo_mem\[34\]\[2\] VGND VGND VPWR VPWR net464 sky130_fd_sc_hd__dlygate4sd3_1
Xhold241 u_input_buffer.fifo_mem\[7\]\[4\] VGND VGND VPWR VPWR net453 sky130_fd_sc_hd__dlygate4sd3_1
Xhold230 u_input_buffer.fifo_mem\[38\]\[10\] VGND VGND VPWR VPWR net442 sky130_fd_sc_hd__dlygate4sd3_1
X_4529_ net1032 _1730_ _1703_ VGND VGND VPWR VPWR _1731_ sky130_fd_sc_hd__mux2_1
X_8297_ clknet_leaf_99_clk _0386_ VGND VGND VPWR VPWR u_input_buffer.fifo_mem\[45\]\[15\]
+ sky130_fd_sc_hd__dfxtp_1
X_7317_ u_input_buffer.fifo_mem\[16\]\[13\] _2970_ _2972_ u_input_buffer.fifo_mem\[49\]\[13\]
+ _2974_ VGND VGND VPWR VPWR _3556_ sky130_fd_sc_hd__a221o_1
Xhold285 u_input_buffer.fifo_mem\[7\]\[5\] VGND VGND VPWR VPWR net497 sky130_fd_sc_hd__dlygate4sd3_1
Xhold296 u_input_buffer.fifo_mem\[63\]\[0\] VGND VGND VPWR VPWR net508 sky130_fd_sc_hd__dlygate4sd3_1
Xhold274 u_input_buffer.fifo_mem\[2\]\[6\] VGND VGND VPWR VPWR net486 sky130_fd_sc_hd__dlygate4sd3_1
Xhold263 u_input_buffer.fifo_mem\[55\]\[3\] VGND VGND VPWR VPWR net475 sky130_fd_sc_hd__dlygate4sd3_1
X_7248_ u_input_buffer.fifo_mem\[8\]\[11\] _3003_ _3005_ u_input_buffer.fifo_mem\[19\]\[11\]
+ _3488_ VGND VGND VPWR VPWR _3489_ sky130_fd_sc_hd__a221o_1
X_7179_ u_input_buffer.fifo_mem\[23\]\[9\] _3046_ _3048_ u_input_buffer.fifo_mem\[20\]\[9\]
+ _3421_ VGND VGND VPWR VPWR _3422_ sky130_fd_sc_hd__a221o_1
XTAP_590 VGND VPWR sky130_fd_sc_hd__tapvpwrvgnd_1
Xclkbuf_leaf_80_clk clknet_3_3__leaf_clk VGND VGND VPWR VPWR clknet_leaf_80_clk sky130_fd_sc_hd__clkbuf_16
XFILLER_0_95_398 VGND VGND VPWR VPWR sky130_fd_sc_hd__decap_6
XFILLER_0_36_421 VGND VGND VPWR VPWR sky130_fd_sc_hd__fill_2
XFILLER_0_102_29 VPWR VGND VPWR VGND sky130_ef_sc_hd__decap_12
XFILLER_0_32_660 VGND VGND VPWR VPWR sky130_fd_sc_hd__decap_6
XFILLER_0_102_581 VGND VGND VPWR VPWR sky130_fd_sc_hd__fill_2
Xinput9 cfg_clk VGND VGND VPWR VPWR net9 sky130_fd_sc_hd__clkbuf_2
XFILLER_0_59_513 VGND VGND VPWR VPWR sky130_fd_sc_hd__decap_3
X_4880_ net449 _1726_ _1911_ VGND VGND VPWR VPWR _1924_ sky130_fd_sc_hd__mux2_1
Xclkbuf_leaf_71_clk clknet_3_3__leaf_clk VGND VGND VPWR VPWR clknet_leaf_71_clk sky130_fd_sc_hd__clkbuf_16
XFILLER_0_86_398 VGND VGND VPWR VPWR sky130_fd_sc_hd__fill_2
XFILLER_0_74_549 VGND VGND VPWR VPWR sky130_fd_sc_hd__fill_1
XFILLER_0_46_229 VGND VGND VPWR VPWR sky130_fd_sc_hd__decap_6
X_6550_ _2839_ VGND VGND VPWR VPWR _1088_ sky130_fd_sc_hd__clkbuf_1
XFILLER_0_6_304 VGND VGND VPWR VPWR sky130_fd_sc_hd__fill_1
X_5501_ net372 _2270_ _2243_ VGND VGND VPWR VPWR _2271_ sky130_fd_sc_hd__mux2_1
XFILLER_0_54_251 VGND VGND VPWR VPWR sky130_fd_sc_hd__fill_1
X_6481_ net556 _1456_ _2788_ VGND VGND VPWR VPWR _2803_ sky130_fd_sc_hd__mux2_1
X_8220_ clknet_leaf_23_clk _0309_ VGND VGND VPWR VPWR u_input_buffer.fifo_mem\[49\]\[2\]
+ sky130_fd_sc_hd__dfxtp_1
X_5432_ _2227_ VGND VGND VPWR VPWR _0582_ sky130_fd_sc_hd__clkbuf_1
X_5363_ net711 _1996_ _2187_ VGND VGND VPWR VPWR _2191_ sky130_fd_sc_hd__mux2_1
XFILLER_0_23_671 VGND VGND VPWR VPWR sky130_fd_sc_hd__fill_1
X_8151_ clknet_leaf_101_clk _0240_ VGND VGND VPWR VPWR u_input_buffer.fifo_mem\[54\]\[13\]
+ sky130_fd_sc_hd__dfxtp_1
X_7102_ u_input_buffer.fifo_mem\[15\]\[7\] _3060_ _3062_ u_input_buffer.fifo_mem\[43\]\[7\]
+ VGND VGND VPWR VPWR _3347_ sky130_fd_sc_hd__a22o_1
X_4314_ u_input_buffer.count\[0\] u_input_buffer.count\[1\] u_input_buffer.count\[3\]
+ u_input_buffer.count\[2\] VGND VGND VPWR VPWR _1593_ sky130_fd_sc_hd__or4_2
XFILLER_0_2_587 VGND VGND VPWR VPWR sky130_fd_sc_hd__fill_1
X_5294_ _2154_ VGND VGND VPWR VPWR _0517_ sky130_fd_sc_hd__clkbuf_1
X_8082_ clknet_leaf_65_clk _0171_ VGND VGND VPWR VPWR u_input_buffer.fifo_mem\[58\]\[8\]
+ sky130_fd_sc_hd__dfxtp_1
X_7033_ u_analytics_engine.data_in\[5\] _2893_ _3278_ _3279_ VGND VGND VPWR VPWR _1131_
+ sky130_fd_sc_hd__a22o_1
X_4245_ net237 net164 VGND VGND VPWR VPWR _0094_ sky130_fd_sc_hd__xor2_1
X_4176_ u_sample_counter.sample_count\[3\] u_sample_counter.sample_count\[4\] u_sample_counter.sample_count\[5\]
+ _1477_ VGND VGND VPWR VPWR _1483_ sky130_fd_sc_hd__and4_1
X_8984_ clknet_leaf_12_clk _1073_ VGND VGND VPWR VPWR u_input_buffer.fifo_mem\[2\]\[14\]
+ sky130_fd_sc_hd__dfxtp_1
XTAP_1019 VGND VPWR sky130_fd_sc_hd__tapvpwrvgnd_1
XTAP_1008 VGND VPWR sky130_fd_sc_hd__tapvpwrvgnd_1
X_7935_ clknet_leaf_88_clk _0025_ VGND VGND VPWR VPWR u_sensor_interface.sensor_array\[1\]\[7\]
+ sky130_fd_sc_hd__dfxtp_1
X_7866_ net29 u_register_bank.sensor_enable\[25\] _3927_ VGND VGND VPWR VPWR _3933_
+ sky130_fd_sc_hd__mux2_1
Xclkbuf_leaf_62_clk clknet_3_6__leaf_clk VGND VGND VPWR VPWR clknet_leaf_62_clk sky130_fd_sc_hd__clkbuf_16
XFILLER_0_65_527 VGND VGND VPWR VPWR sky130_fd_sc_hd__decap_4
X_6817_ _2930_ _2953_ VGND VGND VPWR VPWR _3069_ sky130_fd_sc_hd__nor2_4
X_7797_ _3896_ VGND VGND VPWR VPWR _1278_ sky130_fd_sc_hd__clkbuf_1
X_6748_ _2963_ _2977_ _2988_ _2999_ VGND VGND VPWR VPWR _3000_ sky130_fd_sc_hd__or4_1
XFILLER_0_73_582 VGND VGND VPWR VPWR sky130_fd_sc_hd__decap_4
X_6679_ _2894_ _2930_ VGND VGND VPWR VPWR _2931_ sky130_fd_sc_hd__nor2_4
X_8418_ clknet_leaf_18_clk _0507_ VGND VGND VPWR VPWR u_input_buffer.fifo_mem\[37\]\[8\]
+ sky130_fd_sc_hd__dfxtp_1
X_8349_ clknet_leaf_21_clk _0438_ VGND VGND VPWR VPWR u_input_buffer.fifo_mem\[41\]\[3\]
+ sky130_fd_sc_hd__dfxtp_1
XFILLER_0_60_287 VGND VGND VPWR VPWR sky130_fd_sc_hd__decap_3
XFILLER_0_14_682 VGND VGND VPWR VPWR sky130_fd_sc_hd__decap_4
XFILLER_0_103_389 VGND VGND VPWR VPWR sky130_fd_sc_hd__decap_3
XTAP_1542 VGND VPWR sky130_fd_sc_hd__tapvpwrvgnd_1
XTAP_1531 VGND VPWR sky130_fd_sc_hd__tapvpwrvgnd_1
XTAP_1520 VGND VPWR sky130_fd_sc_hd__tapvpwrvgnd_1
Xclkbuf_leaf_53_clk clknet_3_7__leaf_clk VGND VGND VPWR VPWR clknet_leaf_53_clk sky130_fd_sc_hd__clkbuf_16
XFILLER_0_95_151 VGND VGND VPWR VPWR sky130_fd_sc_hd__fill_1
XTAP_1575 VGND VPWR sky130_fd_sc_hd__tapvpwrvgnd_1
XTAP_1564 VGND VPWR sky130_fd_sc_hd__tapvpwrvgnd_1
XTAP_1553 VGND VPWR sky130_fd_sc_hd__tapvpwrvgnd_1
XPHY_60 VGND VGND VPWR VPWR sky130_fd_sc_hd__decap_3
XPHY_71 VGND VGND VPWR VPWR sky130_fd_sc_hd__decap_3
XPHY_82 VGND VGND VPWR VPWR sky130_fd_sc_hd__decap_3
XTAP_1597 VGND VPWR sky130_fd_sc_hd__tapvpwrvgnd_1
XFILLER_0_113_39 VPWR VGND VPWR VGND sky130_ef_sc_hd__decap_12
XTAP_1586 VGND VPWR sky130_fd_sc_hd__tapvpwrvgnd_1
XPHY_93 VGND VGND VPWR VPWR sky130_fd_sc_hd__decap_3
XFILLER_0_107_673 VPWR VGND VPWR VGND sky130_ef_sc_hd__decap_12
XFILLER_0_64_593 VGND VGND VPWR VPWR sky130_fd_sc_hd__fill_1
XFILLER_0_20_685 VGND VGND VPWR VPWR sky130_fd_sc_hd__fill_1
X_4030_ _1366_ VGND VGND VPWR VPWR _0041_ sky130_fd_sc_hd__clkbuf_1
X_5981_ _1610_ net1283 _2531_ VGND VGND VPWR VPWR _2536_ sky130_fd_sc_hd__mux2_1
X_4932_ net1131 _1706_ _1952_ VGND VGND VPWR VPWR _1954_ sky130_fd_sc_hd__mux2_1
Xclkbuf_leaf_44_clk clknet_3_6__leaf_clk VGND VGND VPWR VPWR clknet_leaf_44_clk sky130_fd_sc_hd__clkbuf_16
X_7720_ _3841_ net123 _3817_ VGND VGND VPWR VPWR _3842_ sky130_fd_sc_hd__mux2_1
XFILLER_0_47_505 VGND VGND VPWR VPWR sky130_fd_sc_hd__fill_2
XFILLER_0_87_685 VGND VGND VPWR VPWR sky130_fd_sc_hd__fill_1
X_7651_ _3788_ net136 _3782_ VGND VGND VPWR VPWR _3789_ sky130_fd_sc_hd__mux2_1
XANTENNA_14 net7 VGND VGND VPWR VPWR sky130_fd_sc_hd__diode_2
X_4863_ _1915_ VGND VGND VPWR VPWR _0325_ sky130_fd_sc_hd__clkbuf_1
X_6602_ u_input_buffer.count\[4\] _1593_ VGND VGND VPWR VPWR _2869_ sky130_fd_sc_hd__and2_1
XANTENNA_47 _3049_ VGND VGND VPWR VPWR sky130_fd_sc_hd__diode_2
XANTENNA_25 net71 VGND VGND VPWR VPWR sky130_fd_sc_hd__diode_2
X_7582_ net42 u_analytics_engine.threshold\[8\] _3737_ VGND VGND VPWR VPWR _3746_
+ sky130_fd_sc_hd__mux2_1
X_4794_ net410 _1710_ _1874_ VGND VGND VPWR VPWR _1878_ sky130_fd_sc_hd__mux2_1
XANTENNA_36 net98 VGND VGND VPWR VPWR sky130_fd_sc_hd__diode_2
XFILLER_0_70_530 VGND VGND VPWR VPWR sky130_fd_sc_hd__fill_2
XFILLER_0_12_81 VGND VGND VPWR VPWR sky130_fd_sc_hd__decap_3
X_6533_ _1612_ net1169 _2825_ VGND VGND VPWR VPWR _2831_ sky130_fd_sc_hd__mux2_1
XANTENNA_58 u_analytics_engine.data_in\[12\] VGND VGND VPWR VPWR sky130_fd_sc_hd__diode_2
X_6464_ _2794_ VGND VGND VPWR VPWR _1047_ sky130_fd_sc_hd__clkbuf_1
XFILLER_0_113_665 VGND VGND VPWR VPWR sky130_fd_sc_hd__decap_6
XFILLER_0_88_41 VPWR VGND VPWR VGND sky130_ef_sc_hd__decap_12
X_8203_ clknet_leaf_39_clk _0292_ VGND VGND VPWR VPWR u_input_buffer.fifo_mem\[50\]\[1\]
+ sky130_fd_sc_hd__dfxtp_1
X_5415_ _1451_ net908 _2204_ VGND VGND VPWR VPWR _2218_ sky130_fd_sc_hd__mux2_1
Xoutput143 net143 VGND VGND VPWR VPWR cfg_rdata[7] sky130_fd_sc_hd__clkbuf_4
X_9183_ clknet_leaf_40_clk _1271_ net194 VGND VGND VPWR VPWR net155 sky130_fd_sc_hd__dfrtp_4
XFILLER_0_63_3 VGND VGND VPWR VPWR sky130_fd_sc_hd__fill_2
Xoutput132 net132 VGND VGND VPWR VPWR cfg_rdata[26] sky130_fd_sc_hd__buf_2
XFILLER_0_11_641 VPWR VGND VPWR VGND sky130_ef_sc_hd__decap_12
Xoutput121 net121 VGND VGND VPWR VPWR cfg_rdata[16] sky130_fd_sc_hd__clkbuf_4
X_6395_ _1610_ net1121 _2753_ VGND VGND VPWR VPWR _2758_ sky130_fd_sc_hd__mux2_1
XFILLER_0_10_162 VGND VGND VPWR VPWR sky130_fd_sc_hd__fill_2
Xoutput154 net154 VGND VGND VPWR VPWR processed_data_out[15] sky130_fd_sc_hd__clkbuf_4
X_8134_ clknet_leaf_89_clk _0223_ VGND VGND VPWR VPWR u_input_buffer.fifo_mem\[55\]\[12\]
+ sky130_fd_sc_hd__dfxtp_1
X_5346_ _2181_ VGND VGND VPWR VPWR _0542_ sky130_fd_sc_hd__clkbuf_1
X_8065_ clknet_leaf_45_clk _0154_ VGND VGND VPWR VPWR u_input_buffer.fifo_mem\[59\]\[7\]
+ sky130_fd_sc_hd__dfxtp_1
X_5277_ _1445_ net1261 _2132_ VGND VGND VPWR VPWR _2145_ sky130_fd_sc_hd__mux2_1
X_7016_ u_input_buffer.fifo_mem\[27\]\[5\] _3013_ _3015_ u_input_buffer.fifo_mem\[59\]\[5\]
+ _3262_ VGND VGND VPWR VPWR _3263_ sky130_fd_sc_hd__a221o_1
X_4228_ _1516_ _1517_ VGND VGND VPWR VPWR _0088_ sky130_fd_sc_hd__nor2_1
X_4159_ _1471_ u_sensor_interface.sensor_array\[3\]\[15\] net113 VGND VGND VPWR VPWR
+ _1472_ sky130_fd_sc_hd__mux2_1
XFILLER_0_97_449 VGND VGND VPWR VPWR sky130_fd_sc_hd__fill_2
X_8967_ clknet_leaf_88_clk _1056_ VGND VGND VPWR VPWR u_input_buffer.fifo_mem\[3\]\[13\]
+ sky130_fd_sc_hd__dfxtp_1
X_7918_ clknet_leaf_63_clk _0008_ VGND VGND VPWR VPWR u_sensor_interface.sensor_array\[2\]\[6\]
+ sky130_fd_sc_hd__dfxtp_1
Xclkbuf_leaf_35_clk clknet_3_5__leaf_clk VGND VGND VPWR VPWR clknet_leaf_35_clk sky130_fd_sc_hd__clkbuf_16
XFILLER_0_65_324 VGND VGND VPWR VPWR sky130_fd_sc_hd__decap_4
X_8898_ clknet_leaf_65_clk _0987_ VGND VGND VPWR VPWR u_input_buffer.fifo_mem\[7\]\[8\]
+ sky130_fd_sc_hd__dfxtp_1
X_7849_ net20 u_register_bank.sensor_enable\[17\] _3916_ VGND VGND VPWR VPWR _3924_
+ sky130_fd_sc_hd__mux2_1
XFILLER_0_108_448 VGND VGND VPWR VPWR sky130_fd_sc_hd__decap_4
XFILLER_0_18_251 VGND VGND VPWR VPWR sky130_fd_sc_hd__fill_1
XFILLER_0_104_665 VPWR VGND VPWR VGND sky130_ef_sc_hd__decap_12
XFILLER_0_104_643 VGND VGND VPWR VPWR sky130_fd_sc_hd__fill_1
XFILLER_0_88_416 VGND VGND VPWR VPWR sky130_fd_sc_hd__decap_4
XFILLER_0_88_405 VGND VGND VPWR VPWR sky130_fd_sc_hd__fill_2
XFILLER_0_88_427 VGND VGND VPWR VPWR sky130_fd_sc_hd__fill_1
Xclkbuf_leaf_26_clk clknet_3_5__leaf_clk VGND VGND VPWR VPWR clknet_leaf_26_clk sky130_fd_sc_hd__clkbuf_16
XTAP_1350 VGND VPWR sky130_fd_sc_hd__tapvpwrvgnd_1
XFILLER_0_84_622 VGND VGND VPWR VPWR sky130_fd_sc_hd__fill_2
XFILLER_0_84_600 VGND VGND VPWR VPWR sky130_fd_sc_hd__fill_2
XTAP_1383 VGND VPWR sky130_fd_sc_hd__tapvpwrvgnd_1
XTAP_1372 VGND VPWR sky130_fd_sc_hd__tapvpwrvgnd_1
XTAP_1361 VGND VPWR sky130_fd_sc_hd__tapvpwrvgnd_1
XTAP_1394 VGND VPWR sky130_fd_sc_hd__tapvpwrvgnd_1
Xinput12 cfg_wdata[0] VGND VGND VPWR VPWR net12 sky130_fd_sc_hd__dlymetal6s2s_1
Xinput45 rst_n VGND VGND VPWR VPWR net45 sky130_fd_sc_hd__clkbuf_1
Xinput34 cfg_wdata[2] VGND VGND VPWR VPWR net34 sky130_fd_sc_hd__clkbuf_4
Xinput23 cfg_wdata[1] VGND VGND VPWR VPWR net23 sky130_fd_sc_hd__clkbuf_2
XFILLER_0_52_541 VGND VGND VPWR VPWR sky130_fd_sc_hd__fill_2
Xinput89 sensor_data_in[49] VGND VGND VPWR VPWR net89 sky130_fd_sc_hd__clkbuf_1
Xinput56 sensor_data_in[19] VGND VGND VPWR VPWR net56 sky130_fd_sc_hd__clkbuf_1
Xinput78 sensor_data_in[39] VGND VGND VPWR VPWR net78 sky130_fd_sc_hd__clkbuf_1
Xinput67 sensor_data_in[29] VGND VGND VPWR VPWR net67 sky130_fd_sc_hd__buf_1
Xhold807 u_input_buffer.fifo_mem\[27\]\[15\] VGND VGND VPWR VPWR net1019 sky130_fd_sc_hd__dlygate4sd3_1
Xhold818 u_input_buffer.fifo_mem\[53\]\[8\] VGND VGND VPWR VPWR net1030 sky130_fd_sc_hd__dlygate4sd3_1
XFILLER_0_110_613 VPWR VGND VPWR VGND sky130_ef_sc_hd__decap_12
Xhold829 u_input_buffer.fifo_mem\[43\]\[1\] VGND VGND VPWR VPWR net1041 sky130_fd_sc_hd__dlygate4sd3_1
XFILLER_0_110_657 VPWR VGND VPWR VGND sky130_ef_sc_hd__decap_12
X_5200_ _2104_ VGND VGND VPWR VPWR _0473_ sky130_fd_sc_hd__clkbuf_1
XFILLER_0_58_44 VGND VGND VPWR VPWR sky130_fd_sc_hd__fill_1
X_6180_ _2642_ VGND VGND VPWR VPWR _2643_ sky130_fd_sc_hd__clkbuf_4
X_5131_ _2067_ VGND VGND VPWR VPWR _0441_ sky130_fd_sc_hd__clkbuf_1
XFILLER_0_58_88 VGND VGND VPWR VPWR sky130_fd_sc_hd__decap_4
X_5062_ net305 _2002_ _2024_ VGND VGND VPWR VPWR _2031_ sky130_fd_sc_hd__mux2_1
X_4013_ net359 net70 _1356_ VGND VGND VPWR VPWR _1358_ sky130_fd_sc_hd__mux2_1
X_8821_ clknet_leaf_10_clk _0910_ VGND VGND VPWR VPWR u_input_buffer.fifo_mem\[12\]\[11\]
+ sky130_fd_sc_hd__dfxtp_1
X_8752_ clknet_leaf_17_clk _0841_ VGND VGND VPWR VPWR u_input_buffer.fifo_mem\[16\]\[6\]
+ sky130_fd_sc_hd__dfxtp_1
XFILLER_0_90_53 VGND VGND VPWR VPWR sky130_fd_sc_hd__decap_8
Xclkbuf_leaf_17_clk clknet_3_4__leaf_clk VGND VGND VPWR VPWR clknet_leaf_17_clk sky130_fd_sc_hd__clkbuf_16
X_7703_ u_register_bank.window_cfg\[14\] _3812_ _3813_ u_analytics_engine.threshold\[14\]
+ _3828_ VGND VGND VPWR VPWR _3829_ sky130_fd_sc_hd__a221o_1
X_5964_ _2525_ VGND VGND VPWR VPWR _0816_ sky130_fd_sc_hd__clkbuf_1
X_8683_ clknet_leaf_49_clk _0772_ VGND VGND VPWR VPWR u_input_buffer.fifo_mem\[20\]\[1\]
+ sky130_fd_sc_hd__dfxtp_1
X_5895_ net864 _2250_ _2479_ VGND VGND VPWR VPWR _2483_ sky130_fd_sc_hd__mux2_1
X_4915_ _1944_ VGND VGND VPWR VPWR _0348_ sky130_fd_sc_hd__clkbuf_1
X_4846_ _1905_ VGND VGND VPWR VPWR _0318_ sky130_fd_sc_hd__clkbuf_1
X_7634_ net3 net4 _3696_ VGND VGND VPWR VPWR _3774_ sky130_fd_sc_hd__and3_2
X_7565_ _3736_ VGND VGND VPWR VPWR _3737_ sky130_fd_sc_hd__buf_4
XFILLER_0_99_51 VGND VGND VPWR VPWR sky130_fd_sc_hd__decap_4
X_4777_ net746 _1728_ _1854_ VGND VGND VPWR VPWR _1868_ sky130_fd_sc_hd__mux2_1
X_6516_ _2821_ VGND VGND VPWR VPWR _1072_ sky130_fd_sc_hd__clkbuf_1
XFILLER_0_70_382 VGND VGND VPWR VPWR sky130_fd_sc_hd__fill_1
X_7496_ _3699_ VGND VGND VPWR VPWR _3700_ sky130_fd_sc_hd__buf_4
XFILLER_0_15_276 VGND VGND VPWR VPWR sky130_fd_sc_hd__decap_4
XFILLER_0_3_671 VGND VGND VPWR VPWR sky130_fd_sc_hd__fill_1
X_6447_ net913 _1456_ _2770_ VGND VGND VPWR VPWR _2785_ sky130_fd_sc_hd__mux2_1
XFILLER_0_101_635 VGND VGND VPWR VPWR sky130_fd_sc_hd__fill_1
X_9166_ net169 _1254_ VGND VGND VPWR VPWR net121 sky130_fd_sc_hd__dfxtp_2
X_6378_ _2748_ VGND VGND VPWR VPWR _1007_ sky130_fd_sc_hd__clkbuf_1
X_5329_ net935 _1996_ _2169_ VGND VGND VPWR VPWR _2173_ sky130_fd_sc_hd__mux2_1
X_8117_ clknet_leaf_74_clk _0206_ VGND VGND VPWR VPWR u_input_buffer.fifo_mem\[56\]\[11\]
+ sky130_fd_sc_hd__dfxtp_1
XFILLER_0_100_189 VGND VGND VPWR VPWR sky130_fd_sc_hd__fill_1
X_9097_ net170 _1185_ net202 VGND VGND VPWR VPWR u_register_bank.window_cfg\[11\]
+ sky130_fd_sc_hd__dfrtp_1
X_8048_ clknet_leaf_43_clk _0137_ VGND VGND VPWR VPWR u_input_buffer.fifo_mem\[60\]\[6\]
+ sky130_fd_sc_hd__dfxtp_1
XFILLER_0_97_279 VGND VGND VPWR VPWR sky130_fd_sc_hd__fill_1
XFILLER_0_65_110 VGND VGND VPWR VPWR sky130_fd_sc_hd__fill_2
XFILLER_0_38_379 VGND VGND VPWR VPWR sky130_fd_sc_hd__fill_1
XFILLER_0_80_102 VGND VGND VPWR VPWR sky130_fd_sc_hd__decap_6
XFILLER_0_110_29 VPWR VGND VPWR VGND sky130_ef_sc_hd__decap_12
XFILLER_0_21_235 VGND VGND VPWR VPWR sky130_fd_sc_hd__decap_3
XFILLER_0_21_279 VGND VGND VPWR VPWR sky130_fd_sc_hd__fill_1
XTAP_419 VGND VPWR sky130_fd_sc_hd__tapvpwrvgnd_1
XTAP_408 VGND VPWR sky130_fd_sc_hd__tapvpwrvgnd_1
XFILLER_0_44_24 VGND VGND VPWR VPWR sky130_fd_sc_hd__decap_4
XFILLER_0_76_419 VGND VGND VPWR VPWR sky130_fd_sc_hd__fill_1
XFILLER_0_96_290 VGND VGND VPWR VPWR sky130_fd_sc_hd__decap_4
XTAP_1191 VGND VPWR sky130_fd_sc_hd__tapvpwrvgnd_1
XTAP_1180 VGND VPWR sky130_fd_sc_hd__tapvpwrvgnd_1
X_5680_ net917 _2274_ _2351_ VGND VGND VPWR VPWR _2368_ sky130_fd_sc_hd__mux2_1
X_4700_ _1826_ VGND VGND VPWR VPWR _0251_ sky130_fd_sc_hd__clkbuf_1
XFILLER_0_84_485 VGND VGND VPWR VPWR sky130_fd_sc_hd__decap_8
XFILLER_0_71_113 VGND VGND VPWR VPWR sky130_fd_sc_hd__fill_2
X_4631_ _1788_ VGND VGND VPWR VPWR _0220_ sky130_fd_sc_hd__clkbuf_1
XFILLER_0_97_9 VPWR VGND VPWR VGND sky130_ef_sc_hd__decap_12
XFILLER_0_37_390 VGND VGND VPWR VPWR sky130_fd_sc_hd__fill_2
X_4562_ _1445_ net948 _1737_ VGND VGND VPWR VPWR _1750_ sky130_fd_sc_hd__mux2_1
X_7350_ u_input_buffer.fifo_mem\[53\]\[14\] _2933_ _2935_ u_input_buffer.fifo_mem\[57\]\[14\]
+ VGND VGND VPWR VPWR _3588_ sky130_fd_sc_hd__a22o_1
Xhold626 u_input_buffer.fifo_mem\[39\]\[6\] VGND VGND VPWR VPWR net838 sky130_fd_sc_hd__dlygate4sd3_1
X_4493_ net719 _1706_ _1704_ VGND VGND VPWR VPWR _1707_ sky130_fd_sc_hd__mux2_1
XFILLER_0_69_54 VGND VGND VPWR VPWR sky130_fd_sc_hd__fill_2
Xhold615 u_input_buffer.fifo_mem\[39\]\[14\] VGND VGND VPWR VPWR net827 sky130_fd_sc_hd__dlygate4sd3_1
Xhold604 u_input_buffer.fifo_mem\[53\]\[0\] VGND VGND VPWR VPWR net816 sky130_fd_sc_hd__dlygate4sd3_1
X_7281_ u_input_buffer.fifo_mem\[12\]\[12\] _2979_ _2981_ u_input_buffer.fifo_mem\[18\]\[12\]
+ _3520_ VGND VGND VPWR VPWR _3521_ sky130_fd_sc_hd__a221o_1
X_6301_ _2707_ VGND VGND VPWR VPWR _0971_ sky130_fd_sc_hd__clkbuf_1
Xhold648 u_input_buffer.fifo_mem\[19\]\[6\] VGND VGND VPWR VPWR net860 sky130_fd_sc_hd__dlygate4sd3_1
X_6232_ net299 _2514_ _2662_ VGND VGND VPWR VPWR _2671_ sky130_fd_sc_hd__mux2_1
X_9020_ clknet_leaf_86_clk _1109_ net189 VGND VGND VPWR VPWR u_input_buffer.count\[2\]
+ sky130_fd_sc_hd__dfrtp_1
Xhold659 u_input_buffer.fifo_mem\[30\]\[14\] VGND VGND VPWR VPWR net871 sky130_fd_sc_hd__dlygate4sd3_1
Xhold637 u_input_buffer.fifo_mem\[39\]\[13\] VGND VGND VPWR VPWR net849 sky130_fd_sc_hd__dlygate4sd3_1
Xclkbuf_leaf_6_clk clknet_3_1__leaf_clk VGND VGND VPWR VPWR clknet_leaf_6_clk sky130_fd_sc_hd__clkbuf_16
XFILLER_0_85_42 VGND VGND VPWR VPWR sky130_fd_sc_hd__decap_8
X_6163_ net747 _2514_ _2625_ VGND VGND VPWR VPWR _2634_ sky130_fd_sc_hd__mux2_1
XTAP_953 VGND VPWR sky130_fd_sc_hd__tapvpwrvgnd_1
XTAP_942 VGND VPWR sky130_fd_sc_hd__tapvpwrvgnd_1
XTAP_931 VGND VPWR sky130_fd_sc_hd__tapvpwrvgnd_1
XTAP_920 VGND VPWR sky130_fd_sc_hd__tapvpwrvgnd_1
XFILLER_0_20_290 VGND VGND VPWR VPWR sky130_fd_sc_hd__fill_2
X_6094_ _2596_ VGND VGND VPWR VPWR _0875_ sky130_fd_sc_hd__clkbuf_1
XTAP_986 VGND VPWR sky130_fd_sc_hd__tapvpwrvgnd_1
XTAP_975 VGND VPWR sky130_fd_sc_hd__tapvpwrvgnd_1
XTAP_964 VGND VPWR sky130_fd_sc_hd__tapvpwrvgnd_1
X_5114_ net756 _2020_ _2041_ VGND VGND VPWR VPWR _2058_ sky130_fd_sc_hd__mux2_1
XFILLER_0_109_93 VGND VGND VPWR VPWR sky130_fd_sc_hd__decap_8
XTAP_997 VGND VPWR sky130_fd_sc_hd__tapvpwrvgnd_1
X_5045_ net795 _2020_ _1989_ VGND VGND VPWR VPWR _2021_ sky130_fd_sc_hd__mux2_1
X_8804_ clknet_leaf_104_clk _0893_ VGND VGND VPWR VPWR u_input_buffer.fifo_mem\[13\]\[10\]
+ sky130_fd_sc_hd__dfxtp_1
X_6996_ u_input_buffer.fifo_mem\[33\]\[5\] _2898_ _2904_ u_input_buffer.fifo_mem\[61\]\[5\]
+ _3242_ VGND VGND VPWR VPWR _3243_ sky130_fd_sc_hd__a221o_1
X_5947_ _1426_ VGND VGND VPWR VPWR _2514_ sky130_fd_sc_hd__buf_4
X_8735_ clknet_leaf_111_clk _0824_ VGND VGND VPWR VPWR u_input_buffer.fifo_mem\[17\]\[5\]
+ sky130_fd_sc_hd__dfxtp_1
XFILLER_0_75_474 VGND VGND VPWR VPWR sky130_fd_sc_hd__decap_3
XFILLER_0_63_614 VGND VGND VPWR VPWR sky130_fd_sc_hd__fill_2
X_8666_ clknet_leaf_4_clk _0755_ VGND VGND VPWR VPWR u_input_buffer.fifo_mem\[21\]\[0\]
+ sky130_fd_sc_hd__dfxtp_1
XFILLER_0_63_625 VGND VGND VPWR VPWR sky130_fd_sc_hd__fill_2
X_5878_ _2473_ VGND VGND VPWR VPWR _0782_ sky130_fd_sc_hd__clkbuf_1
X_7617_ _3764_ VGND VGND VPWR VPWR _1230_ sky130_fd_sc_hd__clkbuf_1
X_4829_ _1397_ net1309 _1893_ VGND VGND VPWR VPWR _1897_ sky130_fd_sc_hd__mux2_1
X_8597_ clknet_leaf_89_clk _0686_ VGND VGND VPWR VPWR u_input_buffer.fifo_mem\[26\]\[11\]
+ sky130_fd_sc_hd__dfxtp_1
XFILLER_0_16_541 VGND VGND VPWR VPWR sky130_fd_sc_hd__fill_2
XFILLER_0_16_552 VGND VGND VPWR VPWR sky130_fd_sc_hd__fill_1
X_7548_ _3727_ VGND VGND VPWR VPWR _1198_ sky130_fd_sc_hd__clkbuf_1
X_7479_ net1124 _1438_ _3677_ VGND VGND VPWR VPWR _3689_ sky130_fd_sc_hd__mux2_1
XFILLER_0_43_393 VGND VGND VPWR VPWR sky130_fd_sc_hd__decap_6
XFILLER_0_113_281 VGND VGND VPWR VPWR sky130_fd_sc_hd__decap_4
X_9218_ net173 _1305_ net203 VGND VGND VPWR VPWR u_register_bank.sensor_enable\[19\]
+ sky130_fd_sc_hd__dfrtp_1
X_9149_ net172 _1237_ net203 VGND VGND VPWR VPWR u_register_bank.threshold_cfg\[31\]
+ sky130_fd_sc_hd__dfrtp_1
XFILLER_0_14_27 VGND VGND VPWR VPWR sky130_fd_sc_hd__fill_1
XFILLER_0_39_600 VGND VGND VPWR VPWR sky130_fd_sc_hd__fill_2
XFILLER_0_39_611 VGND VGND VPWR VPWR sky130_fd_sc_hd__fill_1
XFILLER_0_85_249 VGND VGND VPWR VPWR sky130_fd_sc_hd__decap_3
XPHY_230 VGND VGND VPWR VPWR sky130_fd_sc_hd__decap_3
XFILLER_0_81_422 VGND VGND VPWR VPWR sky130_fd_sc_hd__fill_1
XFILLER_0_53_102 VGND VGND VPWR VPWR sky130_fd_sc_hd__fill_1
XFILLER_0_53_113 VGND VGND VPWR VPWR sky130_fd_sc_hd__fill_1
XFILLER_0_22_533 VGND VGND VPWR VPWR sky130_fd_sc_hd__decap_3
XFILLER_0_22_544 VGND VGND VPWR VPWR sky130_fd_sc_hd__fill_1
XFILLER_0_1_449 VPWR VGND VPWR VGND sky130_ef_sc_hd__decap_12
XFILLER_0_39_57 VGND VGND VPWR VPWR sky130_fd_sc_hd__decap_4
XTAP_238 VGND VPWR sky130_fd_sc_hd__tapvpwrvgnd_1
XTAP_249 VGND VPWR sky130_fd_sc_hd__tapvpwrvgnd_1
Xhold1 u_sample_counter.sample_count\[25\] VGND VGND VPWR VPWR net213 sky130_fd_sc_hd__dlygate4sd3_1
X_6850_ u_input_buffer.fifo_mem\[34\]\[1\] _2966_ _2969_ u_input_buffer.fifo_mem\[48\]\[1\]
+ _3100_ VGND VGND VPWR VPWR _3101_ sky130_fd_sc_hd__a221o_1
X_6781_ u_input_buffer.fifo_mem\[7\]\[0\] _3025_ _3027_ u_input_buffer.fifo_mem\[22\]\[0\]
+ _3032_ VGND VGND VPWR VPWR _3033_ sky130_fd_sc_hd__a221o_1
X_5801_ net774 _2258_ _2425_ VGND VGND VPWR VPWR _2433_ sky130_fd_sc_hd__mux2_1
XFILLER_0_71_55 VGND VGND VPWR VPWR sky130_fd_sc_hd__fill_1
XFILLER_0_9_505 VPWR VGND VPWR VGND sky130_ef_sc_hd__decap_12
X_5732_ net492 _2258_ _2388_ VGND VGND VPWR VPWR _2396_ sky130_fd_sc_hd__mux2_1
X_8520_ clknet_leaf_92_clk _0609_ VGND VGND VPWR VPWR u_input_buffer.fifo_mem\[31\]\[14\]
+ sky130_fd_sc_hd__dfxtp_1
X_3993_ _1347_ VGND VGND VPWR VPWR _0023_ sky130_fd_sc_hd__clkbuf_1
X_8451_ clknet_leaf_28_clk _0540_ VGND VGND VPWR VPWR u_input_buffer.fifo_mem\[35\]\[9\]
+ sky130_fd_sc_hd__dfxtp_1
X_5663_ _2359_ VGND VGND VPWR VPWR _0681_ sky130_fd_sc_hd__clkbuf_1
XFILLER_0_115_557 VGND VGND VPWR VPWR sky130_fd_sc_hd__decap_3
X_8382_ clknet_leaf_50_clk _0471_ VGND VGND VPWR VPWR u_input_buffer.fifo_mem\[39\]\[4\]
+ sky130_fd_sc_hd__dfxtp_1
X_5594_ _2322_ VGND VGND VPWR VPWR _0649_ sky130_fd_sc_hd__clkbuf_1
X_4614_ net905 _1706_ _1778_ VGND VGND VPWR VPWR _1780_ sky130_fd_sc_hd__mux2_1
XFILLER_0_72_477 VGND VGND VPWR VPWR sky130_fd_sc_hd__decap_6
X_7402_ _3623_ _3625_ _3629_ _3638_ VGND VGND VPWR VPWR _3639_ sky130_fd_sc_hd__or4_1
Xhold401 u_input_buffer.fifo_mem\[10\]\[13\] VGND VGND VPWR VPWR net613 sky130_fd_sc_hd__dlygate4sd3_1
XFILLER_0_13_522 VGND VGND VPWR VPWR sky130_fd_sc_hd__fill_2
XFILLER_0_20_70 VGND VGND VPWR VPWR sky130_fd_sc_hd__fill_1
XFILLER_0_25_371 VGND VGND VPWR VPWR sky130_fd_sc_hd__fill_2
X_7333_ _3565_ _3567_ _3569_ _3571_ VGND VGND VPWR VPWR _3572_ sky130_fd_sc_hd__or4_1
X_4545_ _1741_ VGND VGND VPWR VPWR _0181_ sky130_fd_sc_hd__clkbuf_1
Xhold412 u_input_buffer.fifo_mem\[4\]\[5\] VGND VGND VPWR VPWR net624 sky130_fd_sc_hd__dlygate4sd3_1
Xhold434 u_input_buffer.fifo_mem\[51\]\[6\] VGND VGND VPWR VPWR net646 sky130_fd_sc_hd__dlygate4sd3_1
Xhold445 u_input_buffer.fifo_mem\[46\]\[14\] VGND VGND VPWR VPWR net657 sky130_fd_sc_hd__dlygate4sd3_1
Xhold423 u_input_buffer.fifo_mem\[51\]\[13\] VGND VGND VPWR VPWR net635 sky130_fd_sc_hd__dlygate4sd3_1
XFILLER_0_96_41 VPWR VGND VPWR VGND sky130_ef_sc_hd__decap_12
X_9003_ clknet_leaf_44_clk _1092_ VGND VGND VPWR VPWR u_input_buffer.fifo_mem\[0\]\[1\]
+ sky130_fd_sc_hd__dfxtp_1
Xhold478 u_input_buffer.fifo_mem\[10\]\[3\] VGND VGND VPWR VPWR net690 sky130_fd_sc_hd__dlygate4sd3_1
Xhold456 u_input_buffer.fifo_mem\[7\]\[3\] VGND VGND VPWR VPWR net668 sky130_fd_sc_hd__dlygate4sd3_1
Xhold467 u_input_buffer.fifo_mem\[32\]\[10\] VGND VGND VPWR VPWR net679 sky130_fd_sc_hd__dlygate4sd3_1
X_4476_ _1695_ VGND VGND VPWR VPWR _0158_ sky130_fd_sc_hd__clkbuf_1
X_7264_ _3498_ _3500_ _3502_ _3504_ VGND VGND VPWR VPWR _3505_ sky130_fd_sc_hd__or4_1
XFILLER_0_96_85 VPWR VGND VPWR VGND sky130_ef_sc_hd__decap_12
X_6215_ _2661_ VGND VGND VPWR VPWR _2662_ sky130_fd_sc_hd__buf_4
Xhold489 u_input_buffer.fifo_mem\[55\]\[8\] VGND VGND VPWR VPWR net701 sky130_fd_sc_hd__dlygate4sd3_1
X_7195_ u_input_buffer.fifo_mem\[17\]\[10\] _2942_ _2944_ u_input_buffer.fifo_mem\[5\]\[10\]
+ VGND VGND VPWR VPWR _3437_ sky130_fd_sc_hd__a22o_1
X_6146_ _2624_ VGND VGND VPWR VPWR _2625_ sky130_fd_sc_hd__buf_4
XTAP_750 VGND VPWR sky130_fd_sc_hd__tapvpwrvgnd_1
XTAP_761 VGND VPWR sky130_fd_sc_hd__tapvpwrvgnd_1
Xhold1112 u_input_buffer.fifo_mem\[59\]\[5\] VGND VGND VPWR VPWR net1324 sky130_fd_sc_hd__dlygate4sd3_1
Xhold1101 u_input_buffer.fifo_mem\[45\]\[6\] VGND VGND VPWR VPWR net1313 sky130_fd_sc_hd__dlygate4sd3_1
XTAP_772 VGND VPWR sky130_fd_sc_hd__tapvpwrvgnd_1
XTAP_783 VGND VPWR sky130_fd_sc_hd__tapvpwrvgnd_1
XTAP_794 VGND VPWR sky130_fd_sc_hd__tapvpwrvgnd_1
X_6077_ net470 _2496_ _2587_ VGND VGND VPWR VPWR _2588_ sky130_fd_sc_hd__mux2_1
X_5028_ _2009_ VGND VGND VPWR VPWR _0396_ sky130_fd_sc_hd__clkbuf_1
XFILLER_0_95_514 VGND VGND VPWR VPWR sky130_fd_sc_hd__decap_4
X_6979_ u_input_buffer.fifo_mem\[7\]\[4\] _3025_ _3027_ u_input_buffer.fifo_mem\[22\]\[4\]
+ _3226_ VGND VGND VPWR VPWR _3227_ sky130_fd_sc_hd__a221o_1
X_8718_ clknet_leaf_24_clk _0807_ VGND VGND VPWR VPWR u_input_buffer.fifo_mem\[18\]\[4\]
+ sky130_fd_sc_hd__dfxtp_1
XFILLER_0_63_400 VGND VGND VPWR VPWR sky130_fd_sc_hd__fill_2
XFILLER_0_0_80 VGND VGND VPWR VPWR sky130_fd_sc_hd__fill_1
XFILLER_0_63_455 VGND VGND VPWR VPWR sky130_fd_sc_hd__fill_1
XFILLER_0_8_582 VGND VGND VPWR VPWR sky130_fd_sc_hd__decap_6
X_8649_ clknet_leaf_90_clk _0738_ VGND VGND VPWR VPWR u_input_buffer.fifo_mem\[23\]\[15\]
+ sky130_fd_sc_hd__dfxtp_1
XFILLER_0_51_617 VGND VGND VPWR VPWR sky130_fd_sc_hd__decap_6
Xhold990 u_input_buffer.fifo_mem\[14\]\[10\] VGND VGND VPWR VPWR net1202 sky130_fd_sc_hd__dlygate4sd3_1
XFILLER_0_86_503 VGND VGND VPWR VPWR sky130_fd_sc_hd__fill_1
XFILLER_0_81_241 VGND VGND VPWR VPWR sky130_fd_sc_hd__decap_3
XFILLER_0_81_263 VGND VGND VPWR VPWR sky130_fd_sc_hd__fill_1
X_4330_ net350 _1606_ _1602_ VGND VGND VPWR VPWR _1607_ sky130_fd_sc_hd__mux2_1
XFILLER_0_10_569 VPWR VGND VPWR VGND sky130_ef_sc_hd__decap_12
X_4261_ _1540_ u_analytics_engine.data_in\[12\] VGND VGND VPWR VPWR _1541_ sky130_fd_sc_hd__or2_1
X_6000_ _2545_ VGND VGND VPWR VPWR _0832_ sky130_fd_sc_hd__clkbuf_1
X_4192_ u_sample_counter.sample_count\[9\] u_sample_counter.sample_count\[10\] u_sample_counter.sample_count\[11\]
+ _1487_ VGND VGND VPWR VPWR _1493_ sky130_fd_sc_hd__and4_1
X_7951_ clknet_leaf_52_clk _0041_ VGND VGND VPWR VPWR u_sensor_interface.sensor_array\[0\]\[7\]
+ sky130_fd_sc_hd__dfxtp_1
X_6902_ u_input_buffer.fifo_mem\[52\]\[2\] _3039_ _3041_ u_input_buffer.fifo_mem\[56\]\[2\]
+ VGND VGND VPWR VPWR _3152_ sky130_fd_sc_hd__a22o_1
XFILLER_0_89_363 VGND VGND VPWR VPWR sky130_fd_sc_hd__decap_3
X_7882_ clknet_leaf_61_clk net220 net197 VGND VGND VPWR VPWR u_register_bank.status_flags\[2\]
+ sky130_fd_sc_hd__dfrtp_1
X_6833_ _2930_ _2967_ VGND VGND VPWR VPWR _3085_ sky130_fd_sc_hd__or2_2
XFILLER_0_77_569 VGND VGND VPWR VPWR sky130_fd_sc_hd__fill_2
XFILLER_0_15_81 VPWR VGND VPWR VGND sky130_ef_sc_hd__decap_12
X_3976_ _1338_ VGND VGND VPWR VPWR _0015_ sky130_fd_sc_hd__clkbuf_1
XFILLER_0_17_113 VGND VGND VPWR VPWR sky130_fd_sc_hd__decap_6
XFILLER_0_18_636 VGND VGND VPWR VPWR sky130_fd_sc_hd__decap_8
X_6764_ _2878_ _2910_ VGND VGND VPWR VPWR _3016_ sky130_fd_sc_hd__and2_2
X_5715_ _2386_ VGND VGND VPWR VPWR _0706_ sky130_fd_sc_hd__clkbuf_1
XFILLER_0_18_669 VGND VGND VPWR VPWR sky130_fd_sc_hd__fill_1
X_6695_ u_input_buffer.fifo_mem\[29\]\[0\] _2939_ _2941_ u_input_buffer.fifo_mem\[13\]\[0\]
+ _2946_ VGND VGND VPWR VPWR _2947_ sky130_fd_sc_hd__a221o_1
X_8503_ clknet_leaf_7_clk _0592_ VGND VGND VPWR VPWR u_input_buffer.fifo_mem\[32\]\[13\]
+ sky130_fd_sc_hd__dfxtp_1
XFILLER_0_115_321 VPWR VGND VPWR VGND sky130_ef_sc_hd__decap_12
X_8434_ clknet_leaf_31_clk _0523_ VGND VGND VPWR VPWR u_input_buffer.fifo_mem\[36\]\[8\]
+ sky130_fd_sc_hd__dfxtp_1
XFILLER_0_93_3 VPWR VGND VPWR VGND sky130_ef_sc_hd__decap_12
XFILLER_0_5_541 VPWR VGND VPWR VGND sky130_ef_sc_hd__decap_12
X_5646_ net1019 _2274_ _2333_ VGND VGND VPWR VPWR _2350_ sky130_fd_sc_hd__mux2_1
Xhold220 u_input_buffer.fifo_mem\[44\]\[7\] VGND VGND VPWR VPWR net432 sky130_fd_sc_hd__dlygate4sd3_1
X_8365_ clknet_leaf_51_clk _0454_ VGND VGND VPWR VPWR u_input_buffer.fifo_mem\[40\]\[3\]
+ sky130_fd_sc_hd__dfxtp_1
X_5577_ _1469_ net923 _2296_ VGND VGND VPWR VPWR _2313_ sky130_fd_sc_hd__mux2_1
XFILLER_0_5_585 VPWR VGND VPWR VGND sky130_ef_sc_hd__decap_12
XFILLER_0_32_149 VGND VGND VPWR VPWR sky130_fd_sc_hd__fill_2
Xhold242 u_input_buffer.fifo_mem\[32\]\[1\] VGND VGND VPWR VPWR net454 sky130_fd_sc_hd__dlygate4sd3_1
Xhold253 u_input_buffer.fifo_mem\[22\]\[3\] VGND VGND VPWR VPWR net465 sky130_fd_sc_hd__dlygate4sd3_1
X_4528_ _1456_ VGND VGND VPWR VPWR _1730_ sky130_fd_sc_hd__buf_4
X_8296_ clknet_leaf_100_clk _0385_ VGND VGND VPWR VPWR u_input_buffer.fifo_mem\[45\]\[14\]
+ sky130_fd_sc_hd__dfxtp_1
Xhold231 u_input_buffer.fifo_mem\[52\]\[11\] VGND VGND VPWR VPWR net443 sky130_fd_sc_hd__dlygate4sd3_1
X_7316_ u_input_buffer.fifo_mem\[36\]\[13\] _2950_ _2954_ u_input_buffer.fifo_mem\[35\]\[13\]
+ _3554_ VGND VGND VPWR VPWR _3555_ sky130_fd_sc_hd__a221o_1
Xhold264 u_input_buffer.fifo_mem\[54\]\[2\] VGND VGND VPWR VPWR net476 sky130_fd_sc_hd__dlygate4sd3_1
X_4459_ net1061 _1608_ _1683_ VGND VGND VPWR VPWR _1687_ sky130_fd_sc_hd__mux2_1
Xhold286 u_input_buffer.fifo_mem\[55\]\[12\] VGND VGND VPWR VPWR net498 sky130_fd_sc_hd__dlygate4sd3_1
Xhold275 u_input_buffer.fifo_mem\[63\]\[12\] VGND VGND VPWR VPWR net487 sky130_fd_sc_hd__dlygate4sd3_1
X_7247_ u_input_buffer.fifo_mem\[47\]\[11\] _2879_ _2917_ _3008_ u_input_buffer.fifo_mem\[24\]\[11\]
+ VGND VGND VPWR VPWR _3488_ sky130_fd_sc_hd__a32o_1
Xhold297 u_input_buffer.fifo_mem\[36\]\[13\] VGND VGND VPWR VPWR net509 sky130_fd_sc_hd__dlygate4sd3_1
X_7178_ u_input_buffer.fifo_mem\[39\]\[9\] _3050_ _3052_ u_input_buffer.fifo_mem\[40\]\[9\]
+ VGND VGND VPWR VPWR _3421_ sky130_fd_sc_hd__a22o_1
X_6129_ _1618_ net1067 _2607_ VGND VGND VPWR VPWR _2616_ sky130_fd_sc_hd__mux2_1
XTAP_580 VGND VPWR sky130_fd_sc_hd__tapvpwrvgnd_1
XTAP_591 VGND VPWR sky130_fd_sc_hd__tapvpwrvgnd_1
XFILLER_0_99_149 VGND VGND VPWR VPWR sky130_fd_sc_hd__decap_3
XFILLER_0_95_366 VGND VGND VPWR VPWR sky130_fd_sc_hd__fill_2
XFILLER_0_83_528 VGND VGND VPWR VPWR sky130_fd_sc_hd__fill_2
XFILLER_0_91_561 VGND VGND VPWR VPWR sky130_fd_sc_hd__decap_4
XFILLER_0_106_365 VGND VGND VPWR VPWR sky130_fd_sc_hd__decap_3
XFILLER_0_91_594 VGND VGND VPWR VPWR sky130_fd_sc_hd__fill_2
XFILLER_0_36_25 VGND VGND VPWR VPWR sky130_fd_sc_hd__decap_3
XFILLER_0_36_69 VGND VGND VPWR VPWR sky130_fd_sc_hd__decap_3
XFILLER_0_59_503 VGND VGND VPWR VPWR sky130_fd_sc_hd__fill_1
XFILLER_0_74_539 VGND VGND VPWR VPWR sky130_fd_sc_hd__fill_1
XFILLER_0_74_517 VGND VGND VPWR VPWR sky130_fd_sc_hd__decap_3
XFILLER_0_82_550 VGND VGND VPWR VPWR sky130_fd_sc_hd__fill_2
X_5500_ _1456_ VGND VGND VPWR VPWR _2270_ sky130_fd_sc_hd__clkbuf_4
XFILLER_0_15_606 VGND VGND VPWR VPWR sky130_fd_sc_hd__decap_8
XFILLER_0_15_617 VGND VGND VPWR VPWR sky130_fd_sc_hd__decap_6
X_6480_ _2802_ VGND VGND VPWR VPWR _1055_ sky130_fd_sc_hd__clkbuf_1
XFILLER_0_54_296 VGND VGND VPWR VPWR sky130_fd_sc_hd__decap_3
X_5431_ net472 _1996_ _2223_ VGND VGND VPWR VPWR _2227_ sky130_fd_sc_hd__mux2_1
XFILLER_0_2_533 VPWR VGND VPWR VGND sky130_ef_sc_hd__decap_12
XFILLER_0_30_609 VPWR VGND VPWR VGND sky130_ef_sc_hd__decap_12
X_5362_ _2190_ VGND VGND VPWR VPWR _0549_ sky130_fd_sc_hd__clkbuf_1
X_8150_ clknet_leaf_102_clk _0239_ VGND VGND VPWR VPWR u_input_buffer.fifo_mem\[54\]\[12\]
+ sky130_fd_sc_hd__dfxtp_1
X_7101_ u_input_buffer.fifo_mem\[23\]\[7\] _3046_ _3048_ u_input_buffer.fifo_mem\[20\]\[7\]
+ _3345_ VGND VGND VPWR VPWR _3346_ sky130_fd_sc_hd__a221o_1
X_8081_ clknet_leaf_54_clk _0170_ VGND VGND VPWR VPWR u_input_buffer.fifo_mem\[58\]\[7\]
+ sky130_fd_sc_hd__dfxtp_1
X_4313_ _1591_ VGND VGND VPWR VPWR _1592_ sky130_fd_sc_hd__buf_8
X_5293_ net314 _1994_ _2151_ VGND VGND VPWR VPWR _2154_ sky130_fd_sc_hd__mux2_1
X_7032_ net279 _3086_ _3088_ VGND VGND VPWR VPWR _3279_ sky130_fd_sc_hd__o21a_1
X_4244_ net225 _1526_ net165 VGND VGND VPWR VPWR _0093_ sky130_fd_sc_hd__o21ba_1
X_4175_ net233 net260 _1477_ net214 VGND VGND VPWR VPWR _1482_ sky130_fd_sc_hd__a31oi_1
X_8983_ clknet_leaf_7_clk _1072_ VGND VGND VPWR VPWR u_input_buffer.fifo_mem\[2\]\[13\]
+ sky130_fd_sc_hd__dfxtp_1
XTAP_1009 VGND VPWR sky130_fd_sc_hd__tapvpwrvgnd_1
X_7934_ clknet_leaf_86_clk _0024_ VGND VGND VPWR VPWR u_sensor_interface.sensor_array\[1\]\[6\]
+ sky130_fd_sc_hd__dfxtp_1
X_7865_ _3932_ VGND VGND VPWR VPWR _1310_ sky130_fd_sc_hd__clkbuf_1
XFILLER_0_65_517 VGND VGND VPWR VPWR sky130_fd_sc_hd__fill_1
X_6816_ _3067_ VGND VGND VPWR VPWR _3068_ sky130_fd_sc_hd__clkbuf_4
X_7796_ net162 u_analytics_engine.data_in\[8\] _3893_ VGND VGND VPWR VPWR _3896_ sky130_fd_sc_hd__mux2_1
X_6747_ u_input_buffer.fifo_mem\[51\]\[0\] _2990_ _2993_ u_input_buffer.fifo_mem\[11\]\[0\]
+ _2998_ VGND VGND VPWR VPWR _2999_ sky130_fd_sc_hd__a221o_1
XFILLER_0_73_561 VGND VGND VPWR VPWR sky130_fd_sc_hd__fill_1
X_3959_ _1329_ VGND VGND VPWR VPWR _0007_ sky130_fd_sc_hd__clkbuf_1
XFILLER_0_18_466 VGND VGND VPWR VPWR sky130_fd_sc_hd__fill_2
XFILLER_0_45_241 VGND VGND VPWR VPWR sky130_fd_sc_hd__fill_1
X_6678_ _2929_ VGND VGND VPWR VPWR _2930_ sky130_fd_sc_hd__buf_8
X_5629_ _2341_ VGND VGND VPWR VPWR _0665_ sky130_fd_sc_hd__clkbuf_1
X_8417_ clknet_leaf_19_clk _0506_ VGND VGND VPWR VPWR u_input_buffer.fifo_mem\[37\]\[7\]
+ sky130_fd_sc_hd__dfxtp_1
XFILLER_0_115_195 VGND VGND VPWR VPWR sky130_fd_sc_hd__fill_1
X_8348_ clknet_leaf_21_clk _0437_ VGND VGND VPWR VPWR u_input_buffer.fifo_mem\[41\]\[2\]
+ sky130_fd_sc_hd__dfxtp_1
XFILLER_0_60_299 VGND VGND VPWR VPWR sky130_fd_sc_hd__fill_1
XFILLER_0_41_480 VGND VGND VPWR VPWR sky130_fd_sc_hd__fill_1
X_8279_ clknet_leaf_101_clk _0368_ VGND VGND VPWR VPWR u_input_buffer.fifo_mem\[46\]\[13\]
+ sky130_fd_sc_hd__dfxtp_1
XTAP_1532 VGND VPWR sky130_fd_sc_hd__tapvpwrvgnd_1
XTAP_1510 VGND VPWR sky130_fd_sc_hd__tapvpwrvgnd_1
XTAP_1521 VGND VPWR sky130_fd_sc_hd__tapvpwrvgnd_1
XFILLER_0_68_355 VGND VGND VPWR VPWR sky130_fd_sc_hd__decap_6
XFILLER_0_56_506 VGND VGND VPWR VPWR sky130_fd_sc_hd__fill_2
XTAP_1576 VGND VPWR sky130_fd_sc_hd__tapvpwrvgnd_1
XTAP_1565 VGND VPWR sky130_fd_sc_hd__tapvpwrvgnd_1
XTAP_1554 VGND VPWR sky130_fd_sc_hd__tapvpwrvgnd_1
XTAP_1543 VGND VPWR sky130_fd_sc_hd__tapvpwrvgnd_1
XFILLER_0_68_377 VGND VGND VPWR VPWR sky130_fd_sc_hd__fill_1
XPHY_50 VGND VGND VPWR VPWR sky130_fd_sc_hd__decap_3
XPHY_61 VGND VGND VPWR VPWR sky130_fd_sc_hd__decap_3
XPHY_72 VGND VGND VPWR VPWR sky130_fd_sc_hd__decap_3
XPHY_83 VGND VGND VPWR VPWR sky130_fd_sc_hd__decap_3
XTAP_1598 VGND VPWR sky130_fd_sc_hd__tapvpwrvgnd_1
XTAP_1587 VGND VPWR sky130_fd_sc_hd__tapvpwrvgnd_1
XFILLER_0_22_27 VGND VGND VPWR VPWR sky130_fd_sc_hd__fill_1
XFILLER_0_22_38 VGND VGND VPWR VPWR sky130_fd_sc_hd__fill_2
XPHY_94 VGND VGND VPWR VPWR sky130_fd_sc_hd__decap_3
XFILLER_0_107_663 VGND VGND VPWR VPWR sky130_fd_sc_hd__decap_8
XFILLER_0_91_391 VGND VGND VPWR VPWR sky130_fd_sc_hd__fill_1
XFILLER_0_3_308 VGND VGND VPWR VPWR sky130_fd_sc_hd__decap_8
XFILLER_0_107_685 VGND VGND VPWR VPWR sky130_fd_sc_hd__fill_1
XFILLER_0_51_299 VGND VGND VPWR VPWR sky130_fd_sc_hd__decap_3
XFILLER_0_47_68 VGND VGND VPWR VPWR sky130_fd_sc_hd__fill_1
XFILLER_0_2_15 VPWR VGND VPWR VGND sky130_ef_sc_hd__decap_12
XFILLER_0_59_311 VGND VGND VPWR VPWR sky130_fd_sc_hd__fill_1
X_5980_ _2535_ VGND VGND VPWR VPWR _0822_ sky130_fd_sc_hd__clkbuf_1
X_4931_ _1953_ VGND VGND VPWR VPWR _0355_ sky130_fd_sc_hd__clkbuf_1
XFILLER_0_59_333 VGND VGND VPWR VPWR sky130_fd_sc_hd__decap_3
X_4862_ net944 _1708_ _1912_ VGND VGND VPWR VPWR _1915_ sky130_fd_sc_hd__mux2_1
X_7650_ u_register_bank.window_cfg\[2\] _3772_ _3773_ u_analytics_engine.threshold\[2\]
+ _3787_ VGND VGND VPWR VPWR _3788_ sky130_fd_sc_hd__a221o_1
XFILLER_0_74_347 VPWR VGND VPWR VGND sky130_ef_sc_hd__decap_12
X_6601_ u_input_buffer.count\[4\] _1593_ VGND VGND VPWR VPWR _2868_ sky130_fd_sc_hd__nor2_1
XANTENNA_15 net7 VGND VGND VPWR VPWR sky130_fd_sc_hd__diode_2
XFILLER_0_103_51 VGND VGND VPWR VPWR sky130_fd_sc_hd__decap_4
XANTENNA_26 net71 VGND VGND VPWR VPWR sky130_fd_sc_hd__diode_2
X_7581_ _3745_ VGND VGND VPWR VPWR _1213_ sky130_fd_sc_hd__clkbuf_1
XANTENNA_37 net119 VGND VGND VPWR VPWR sky130_fd_sc_hd__diode_2
X_4793_ _1877_ VGND VGND VPWR VPWR _0293_ sky130_fd_sc_hd__clkbuf_1
XFILLER_0_6_135 VGND VGND VPWR VPWR sky130_fd_sc_hd__decap_4
XANTENNA_48 u_analytics_engine.data_in\[12\] VGND VGND VPWR VPWR sky130_fd_sc_hd__diode_2
XANTENNA_59 u_sensor_interface.sensor_array\[2\]\[8\] VGND VGND VPWR VPWR sky130_fd_sc_hd__diode_2
X_6532_ _2830_ VGND VGND VPWR VPWR _1079_ sky130_fd_sc_hd__clkbuf_1
X_6463_ net549 _1402_ _2789_ VGND VGND VPWR VPWR _2794_ sky130_fd_sc_hd__mux2_1
X_9182_ clknet_leaf_33_clk _1270_ net194 VGND VGND VPWR VPWR net148 sky130_fd_sc_hd__dfrtp_2
XFILLER_0_112_121 VGND VGND VPWR VPWR sky130_fd_sc_hd__decap_3
X_8202_ clknet_leaf_36_clk _0291_ VGND VGND VPWR VPWR u_input_buffer.fifo_mem\[50\]\[0\]
+ sky130_fd_sc_hd__dfxtp_1
XFILLER_0_88_53 VPWR VGND VPWR VGND sky130_ef_sc_hd__decap_12
XFILLER_0_2_341 VPWR VGND VPWR VGND sky130_ef_sc_hd__decap_12
X_5414_ _2217_ VGND VGND VPWR VPWR _0574_ sky130_fd_sc_hd__clkbuf_1
XFILLER_0_113_677 VGND VGND VPWR VPWR sky130_fd_sc_hd__fill_1
Xoutput122 net122 VGND VGND VPWR VPWR cfg_rdata[17] sky130_fd_sc_hd__buf_2
Xoutput133 net133 VGND VGND VPWR VPWR cfg_rdata[27] sky130_fd_sc_hd__clkbuf_4
X_6394_ _2757_ VGND VGND VPWR VPWR _1014_ sky130_fd_sc_hd__clkbuf_1
X_8133_ clknet_leaf_90_clk _0222_ VGND VGND VPWR VPWR u_input_buffer.fifo_mem\[55\]\[11\]
+ sky130_fd_sc_hd__dfxtp_1
XFILLER_0_112_187 VGND VGND VPWR VPWR sky130_fd_sc_hd__fill_2
Xoutput144 net144 VGND VGND VPWR VPWR cfg_rdata[8] sky130_fd_sc_hd__clkbuf_4
XFILLER_0_56_3 VGND VGND VPWR VPWR sky130_fd_sc_hd__decap_3
XFILLER_0_11_664 VGND VGND VPWR VPWR sky130_fd_sc_hd__decap_8
XFILLER_0_11_653 VGND VGND VPWR VPWR sky130_fd_sc_hd__decap_8
XFILLER_0_10_130 VGND VGND VPWR VPWR sky130_fd_sc_hd__fill_2
Xoutput155 net155 VGND VGND VPWR VPWR processed_data_out[1] sky130_fd_sc_hd__clkbuf_4
X_5345_ net889 _2012_ _2168_ VGND VGND VPWR VPWR _2181_ sky130_fd_sc_hd__mux2_1
X_8064_ clknet_leaf_45_clk _0153_ VGND VGND VPWR VPWR u_input_buffer.fifo_mem\[59\]\[6\]
+ sky130_fd_sc_hd__dfxtp_1
X_5276_ _2144_ VGND VGND VPWR VPWR _0509_ sky130_fd_sc_hd__clkbuf_1
X_7015_ u_input_buffer.fifo_mem\[31\]\[5\] _3017_ _3020_ u_input_buffer.fifo_mem\[38\]\[5\]
+ VGND VGND VPWR VPWR _3262_ sky130_fd_sc_hd__a22o_1
X_4227_ net245 _1513_ VGND VGND VPWR VPWR _1517_ sky130_fd_sc_hd__and2_1
XFILLER_0_97_417 VGND VGND VPWR VPWR sky130_fd_sc_hd__decap_3
X_4158_ _1470_ u_sensor_interface.sensor_array\[2\]\[15\] net112 VGND VGND VPWR VPWR
+ _1471_ sky130_fd_sc_hd__mux2_1
X_4089_ _1411_ u_sensor_interface.sensor_array\[3\]\[5\] _1381_ VGND VGND VPWR VPWR
+ _1412_ sky130_fd_sc_hd__mux2_1
X_8966_ clknet_leaf_87_clk _1055_ VGND VGND VPWR VPWR u_input_buffer.fifo_mem\[3\]\[12\]
+ sky130_fd_sc_hd__dfxtp_1
X_7917_ clknet_leaf_21_clk _0007_ VGND VGND VPWR VPWR u_sensor_interface.sensor_array\[2\]\[5\]
+ sky130_fd_sc_hd__dfxtp_1
X_8897_ clknet_leaf_54_clk _0986_ VGND VGND VPWR VPWR u_input_buffer.fifo_mem\[7\]\[7\]
+ sky130_fd_sc_hd__dfxtp_1
XFILLER_0_92_100 VGND VGND VPWR VPWR sky130_fd_sc_hd__decap_3
XFILLER_0_38_517 VGND VGND VPWR VPWR sky130_fd_sc_hd__fill_1
X_7848_ _3923_ VGND VGND VPWR VPWR _1302_ sky130_fd_sc_hd__clkbuf_1
X_7779_ net148 u_analytics_engine.data_in\[0\] _1474_ VGND VGND VPWR VPWR _3887_ sky130_fd_sc_hd__mux2_1
XFILLER_0_46_572 VGND VGND VPWR VPWR sky130_fd_sc_hd__fill_2
XFILLER_0_33_222 VGND VGND VPWR VPWR sky130_fd_sc_hd__fill_2
XFILLER_0_61_586 VGND VGND VPWR VPWR sky130_fd_sc_hd__decap_8
XFILLER_0_104_677 VGND VGND VPWR VPWR sky130_fd_sc_hd__decap_3
XFILLER_0_108_29 VPWR VGND VPWR VGND sky130_ef_sc_hd__decap_12
XTAP_1340 VGND VPWR sky130_fd_sc_hd__tapvpwrvgnd_1
XFILLER_0_68_141 VGND VGND VPWR VPWR sky130_fd_sc_hd__fill_2
XTAP_1384 VGND VPWR sky130_fd_sc_hd__tapvpwrvgnd_1
XTAP_1373 VGND VPWR sky130_fd_sc_hd__tapvpwrvgnd_1
XTAP_1351 VGND VPWR sky130_fd_sc_hd__tapvpwrvgnd_1
XTAP_1362 VGND VPWR sky130_fd_sc_hd__tapvpwrvgnd_1
XTAP_1395 VGND VPWR sky130_fd_sc_hd__tapvpwrvgnd_1
XFILLER_0_83_166 VGND VGND VPWR VPWR sky130_fd_sc_hd__fill_2
XFILLER_0_83_188 VGND VGND VPWR VPWR sky130_fd_sc_hd__decap_3
XFILLER_0_83_177 VGND VGND VPWR VPWR sky130_fd_sc_hd__fill_2
Xinput13 cfg_wdata[10] VGND VGND VPWR VPWR net13 sky130_fd_sc_hd__dlymetal6s2s_1
Xinput46 sensor_data_in[0] VGND VGND VPWR VPWR net46 sky130_fd_sc_hd__buf_1
Xinput24 cfg_wdata[20] VGND VGND VPWR VPWR net24 sky130_fd_sc_hd__clkbuf_2
Xinput35 cfg_wdata[30] VGND VGND VPWR VPWR net35 sky130_fd_sc_hd__dlymetal6s2s_1
XFILLER_0_52_531 VGND VGND VPWR VPWR sky130_fd_sc_hd__fill_1
Xinput68 sensor_data_in[2] VGND VGND VPWR VPWR net68 sky130_fd_sc_hd__clkbuf_1
Xinput79 sensor_data_in[3] VGND VGND VPWR VPWR net79 sky130_fd_sc_hd__clkbuf_1
Xinput57 sensor_data_in[1] VGND VGND VPWR VPWR net57 sky130_fd_sc_hd__buf_1
Xhold808 u_input_buffer.fifo_mem\[60\]\[10\] VGND VGND VPWR VPWR net1020 sky130_fd_sc_hd__dlygate4sd3_1
Xhold819 u_input_buffer.fifo_mem\[5\]\[0\] VGND VGND VPWR VPWR net1031 sky130_fd_sc_hd__dlygate4sd3_1
XFILLER_0_110_625 VGND VGND VPWR VPWR sky130_fd_sc_hd__decap_3
XFILLER_0_110_669 VPWR VGND VPWR VGND sky130_ef_sc_hd__decap_12
X_5130_ _1415_ net1239 _2060_ VGND VGND VPWR VPWR _2067_ sky130_fd_sc_hd__mux2_1
X_5061_ _2030_ VGND VGND VPWR VPWR _0408_ sky130_fd_sc_hd__clkbuf_1
XFILLER_0_74_11 VGND VGND VPWR VPWR sky130_fd_sc_hd__fill_2
X_4012_ _1357_ VGND VGND VPWR VPWR _0032_ sky130_fd_sc_hd__clkbuf_1
X_8820_ clknet_leaf_13_clk _0909_ VGND VGND VPWR VPWR u_input_buffer.fifo_mem\[12\]\[10\]
+ sky130_fd_sc_hd__dfxtp_1
X_8751_ clknet_leaf_17_clk _0840_ VGND VGND VPWR VPWR u_input_buffer.fifo_mem\[16\]\[5\]
+ sky130_fd_sc_hd__dfxtp_1
X_5963_ net517 _2524_ _2497_ VGND VGND VPWR VPWR _2525_ sky130_fd_sc_hd__mux2_1
X_4914_ net431 _1722_ _1934_ VGND VGND VPWR VPWR _1944_ sky130_fd_sc_hd__mux2_1
XFILLER_0_59_152 VGND VGND VPWR VPWR sky130_fd_sc_hd__fill_1
X_7702_ u_register_bank.status_flags\[14\] _3814_ _3808_ u_register_bank.sensor_enable\[14\]
+ VGND VGND VPWR VPWR _3828_ sky130_fd_sc_hd__a22o_1
XFILLER_0_114_61 VGND VGND VPWR VPWR sky130_fd_sc_hd__decap_3
X_8682_ clknet_leaf_49_clk _0771_ VGND VGND VPWR VPWR u_input_buffer.fifo_mem\[20\]\[0\]
+ sky130_fd_sc_hd__dfxtp_1
XFILLER_0_90_76 VGND VGND VPWR VPWR sky130_fd_sc_hd__fill_1
X_5894_ _2482_ VGND VGND VPWR VPWR _0789_ sky130_fd_sc_hd__clkbuf_1
XFILLER_0_114_83 VGND VGND VPWR VPWR sky130_fd_sc_hd__fill_1
XFILLER_0_74_155 VGND VGND VPWR VPWR sky130_fd_sc_hd__fill_1
X_7633_ net167 VGND VGND VPWR VPWR _3773_ sky130_fd_sc_hd__clkbuf_4
X_4845_ _1445_ net1013 _1892_ VGND VGND VPWR VPWR _1905_ sky130_fd_sc_hd__mux2_1
XFILLER_0_105_408 VGND VGND VPWR VPWR sky130_fd_sc_hd__fill_2
XFILLER_0_7_455 VGND VGND VPWR VPWR sky130_fd_sc_hd__fill_1
X_4776_ _1867_ VGND VGND VPWR VPWR _0286_ sky130_fd_sc_hd__clkbuf_1
X_7564_ net44 net167 VGND VGND VPWR VPWR _3736_ sky130_fd_sc_hd__nand2_2
XFILLER_0_55_391 VGND VGND VPWR VPWR sky130_fd_sc_hd__fill_1
X_6515_ net717 _1456_ _2806_ VGND VGND VPWR VPWR _2821_ sky130_fd_sc_hd__mux2_1
XFILLER_0_113_430 VGND VGND VPWR VPWR sky130_fd_sc_hd__fill_1
X_7495_ net44 _3698_ VGND VGND VPWR VPWR _3699_ sky130_fd_sc_hd__nand2_2
XFILLER_0_15_299 VGND VGND VPWR VPWR sky130_fd_sc_hd__fill_1
XFILLER_0_30_225 VGND VGND VPWR VPWR sky130_fd_sc_hd__decap_4
X_6446_ _2784_ VGND VGND VPWR VPWR _1039_ sky130_fd_sc_hd__clkbuf_1
X_9165_ net168 _1253_ VGND VGND VPWR VPWR net120 sky130_fd_sc_hd__dfxtp_1
X_6377_ net712 _2522_ _2734_ VGND VGND VPWR VPWR _2748_ sky130_fd_sc_hd__mux2_1
X_5328_ _2172_ VGND VGND VPWR VPWR _0533_ sky130_fd_sc_hd__clkbuf_1
X_8116_ clknet_leaf_72_clk _0205_ VGND VGND VPWR VPWR u_input_buffer.fifo_mem\[56\]\[10\]
+ sky130_fd_sc_hd__dfxtp_1
XFILLER_0_11_461 VGND VGND VPWR VPWR sky130_fd_sc_hd__decap_6
X_9096_ net170 _1184_ net202 VGND VGND VPWR VPWR u_register_bank.window_cfg\[10\]
+ sky130_fd_sc_hd__dfrtp_1
X_8047_ clknet_leaf_43_clk _0136_ VGND VGND VPWR VPWR u_input_buffer.fifo_mem\[60\]\[5\]
+ sky130_fd_sc_hd__dfxtp_1
X_5259_ _1391_ net1103 _2133_ VGND VGND VPWR VPWR _2136_ sky130_fd_sc_hd__mux2_1
XFILLER_0_97_214 VGND VGND VPWR VPWR sky130_fd_sc_hd__fill_1
XFILLER_0_3_91 VPWR VGND VPWR VGND sky130_ef_sc_hd__decap_12
X_8949_ clknet_leaf_8_clk _1038_ VGND VGND VPWR VPWR u_input_buffer.fifo_mem\[4\]\[11\]
+ sky130_fd_sc_hd__dfxtp_1
XFILLER_0_66_656 VGND VGND VPWR VPWR sky130_fd_sc_hd__fill_1
XFILLER_0_19_561 VGND VGND VPWR VPWR sky130_fd_sc_hd__decap_4
XFILLER_0_53_306 VGND VGND VPWR VPWR sky130_fd_sc_hd__fill_1
XFILLER_0_108_246 VGND VGND VPWR VPWR sky130_fd_sc_hd__decap_6
XFILLER_0_108_235 VGND VGND VPWR VPWR sky130_fd_sc_hd__fill_2
XFILLER_0_65_177 VGND VGND VPWR VPWR sky130_fd_sc_hd__fill_1
XFILLER_0_19_572 VGND VGND VPWR VPWR sky130_fd_sc_hd__fill_2
XFILLER_0_104_474 VGND VGND VPWR VPWR sky130_fd_sc_hd__fill_2
XFILLER_0_1_609 VGND VGND VPWR VPWR sky130_fd_sc_hd__decap_6
XFILLER_0_21_225 VGND VGND VPWR VPWR sky130_fd_sc_hd__decap_3
XTAP_409 VGND VPWR sky130_fd_sc_hd__tapvpwrvgnd_1
Xfanout190 net192 VGND VGND VPWR VPWR net190 sky130_fd_sc_hd__clkbuf_4
XTAP_1192 VGND VPWR sky130_fd_sc_hd__tapvpwrvgnd_1
XTAP_1181 VGND VPWR sky130_fd_sc_hd__tapvpwrvgnd_1
XTAP_1170 VGND VPWR sky130_fd_sc_hd__tapvpwrvgnd_1
XFILLER_0_60_24 VGND VGND VPWR VPWR sky130_fd_sc_hd__decap_4
XFILLER_0_84_475 VGND VGND VPWR VPWR sky130_fd_sc_hd__fill_1
X_4630_ net788 _1722_ _1778_ VGND VGND VPWR VPWR _1788_ sky130_fd_sc_hd__mux2_1
XFILLER_0_4_403 VGND VGND VPWR VPWR sky130_fd_sc_hd__fill_1
X_4561_ _1749_ VGND VGND VPWR VPWR _0189_ sky130_fd_sc_hd__clkbuf_1
X_6300_ net538 _2514_ _2698_ VGND VGND VPWR VPWR _2707_ sky130_fd_sc_hd__mux2_1
Xhold605 u_input_buffer.fifo_mem\[39\]\[8\] VGND VGND VPWR VPWR net817 sky130_fd_sc_hd__dlygate4sd3_1
X_4492_ _1384_ VGND VGND VPWR VPWR _1706_ sky130_fd_sc_hd__buf_4
Xhold616 u_input_buffer.fifo_mem\[48\]\[14\] VGND VGND VPWR VPWR net828 sky130_fd_sc_hd__dlygate4sd3_1
X_7280_ u_input_buffer.fifo_mem\[2\]\[12\] _2983_ _2985_ u_input_buffer.fifo_mem\[32\]\[12\]
+ VGND VGND VPWR VPWR _3520_ sky130_fd_sc_hd__a22o_1
Xhold627 u_input_buffer.fifo_mem\[25\]\[6\] VGND VGND VPWR VPWR net839 sky130_fd_sc_hd__dlygate4sd3_1
Xhold649 u_input_buffer.fifo_mem\[43\]\[5\] VGND VGND VPWR VPWR net861 sky130_fd_sc_hd__dlygate4sd3_1
X_6231_ _2670_ VGND VGND VPWR VPWR _0938_ sky130_fd_sc_hd__clkbuf_1
XFILLER_0_100_41 VPWR VGND VPWR VGND sky130_ef_sc_hd__decap_12
Xhold638 u_input_buffer.fifo_mem\[3\]\[12\] VGND VGND VPWR VPWR net850 sky130_fd_sc_hd__dlygate4sd3_1
XFILLER_0_100_85 VPWR VGND VPWR VGND sky130_ef_sc_hd__decap_12
X_6162_ _2633_ VGND VGND VPWR VPWR _0906_ sky130_fd_sc_hd__clkbuf_1
XTAP_910 VGND VPWR sky130_fd_sc_hd__tapvpwrvgnd_1
XFILLER_0_40_589 VGND VGND VPWR VPWR sky130_fd_sc_hd__decap_4
XTAP_943 VGND VPWR sky130_fd_sc_hd__tapvpwrvgnd_1
XTAP_932 VGND VPWR sky130_fd_sc_hd__tapvpwrvgnd_1
X_5113_ _2057_ VGND VGND VPWR VPWR _0433_ sky130_fd_sc_hd__clkbuf_1
XTAP_921 VGND VPWR sky130_fd_sc_hd__tapvpwrvgnd_1
X_6093_ net404 _2514_ _2587_ VGND VGND VPWR VPWR _2596_ sky130_fd_sc_hd__mux2_1
XTAP_987 VGND VPWR sky130_fd_sc_hd__tapvpwrvgnd_1
XTAP_976 VGND VPWR sky130_fd_sc_hd__tapvpwrvgnd_1
XTAP_954 VGND VPWR sky130_fd_sc_hd__tapvpwrvgnd_1
XTAP_965 VGND VPWR sky130_fd_sc_hd__tapvpwrvgnd_1
XTAP_998 VGND VPWR sky130_fd_sc_hd__tapvpwrvgnd_1
X_5044_ _1468_ VGND VGND VPWR VPWR _2020_ sky130_fd_sc_hd__clkbuf_4
XFILLER_0_19_3 VPWR VGND VPWR VGND sky130_ef_sc_hd__decap_12
X_8803_ clknet_leaf_2_clk _0892_ VGND VGND VPWR VPWR u_input_buffer.fifo_mem\[13\]\[9\]
+ sky130_fd_sc_hd__dfxtp_1
X_6995_ u_input_buffer.fifo_mem\[21\]\[5\] _2909_ _2913_ u_input_buffer.fifo_mem\[25\]\[5\]
+ VGND VGND VPWR VPWR _3242_ sky130_fd_sc_hd__a22o_1
X_5946_ _2513_ VGND VGND VPWR VPWR _0810_ sky130_fd_sc_hd__clkbuf_1
X_8734_ clknet_leaf_111_clk _0823_ VGND VGND VPWR VPWR u_input_buffer.fifo_mem\[17\]\[4\]
+ sky130_fd_sc_hd__dfxtp_1
X_8665_ clknet_leaf_85_clk _0754_ VGND VGND VPWR VPWR u_input_buffer.fifo_mem\[22\]\[15\]
+ sky130_fd_sc_hd__dfxtp_1
X_5877_ net557 _2266_ _2460_ VGND VGND VPWR VPWR _2473_ sky130_fd_sc_hd__mux2_1
X_4828_ _1896_ VGND VGND VPWR VPWR _0309_ sky130_fd_sc_hd__clkbuf_1
X_7616_ net28 u_register_bank.threshold_cfg\[24\] _3759_ VGND VGND VPWR VPWR _3764_
+ sky130_fd_sc_hd__mux2_1
X_8596_ clknet_leaf_87_clk _0685_ VGND VGND VPWR VPWR u_input_buffer.fifo_mem\[26\]\[10\]
+ sky130_fd_sc_hd__dfxtp_1
XFILLER_0_105_238 VGND VGND VPWR VPWR sky130_fd_sc_hd__fill_1
X_4759_ net589 _1710_ _1855_ VGND VGND VPWR VPWR _1859_ sky130_fd_sc_hd__mux2_1
X_7547_ net28 u_register_bank.window_cfg\[24\] _3722_ VGND VGND VPWR VPWR _3727_ sky130_fd_sc_hd__mux2_1
XFILLER_0_50_309 VGND VGND VPWR VPWR sky130_fd_sc_hd__decap_3
XFILLER_0_70_180 VGND VGND VPWR VPWR sky130_fd_sc_hd__fill_1
X_7478_ _3688_ VGND VGND VPWR VPWR _1167_ sky130_fd_sc_hd__clkbuf_1
XFILLER_0_43_383 VGND VGND VPWR VPWR sky130_fd_sc_hd__decap_3
X_6429_ net1218 _1402_ _2771_ VGND VGND VPWR VPWR _2776_ sky130_fd_sc_hd__mux2_1
X_9217_ net169 _1304_ net201 VGND VGND VPWR VPWR u_register_bank.sensor_enable\[18\]
+ sky130_fd_sc_hd__dfrtp_1
XFILLER_0_3_491 VPWR VGND VPWR VGND sky130_ef_sc_hd__decap_12
X_9148_ net172 _1236_ net203 VGND VGND VPWR VPWR u_register_bank.threshold_cfg\[30\]
+ sky130_fd_sc_hd__dfrtp_1
X_9079_ clknet_leaf_42_clk _1167_ VGND VGND VPWR VPWR u_input_buffer.fifo_mem\[63\]\[9\]
+ sky130_fd_sc_hd__dfxtp_1
XFILLER_0_98_567 VGND VGND VPWR VPWR sky130_fd_sc_hd__fill_1
XFILLER_0_39_623 VGND VGND VPWR VPWR sky130_fd_sc_hd__fill_1
XPHY_231 VGND VGND VPWR VPWR sky130_fd_sc_hd__decap_3
XPHY_220 VGND VGND VPWR VPWR sky130_fd_sc_hd__decap_3
XFILLER_0_93_250 VGND VGND VPWR VPWR sky130_fd_sc_hd__fill_1
XFILLER_0_81_467 VGND VGND VPWR VPWR sky130_fd_sc_hd__fill_1
XFILLER_0_104_293 VGND VGND VPWR VPWR sky130_fd_sc_hd__decap_6
XTAP_239 VGND VPWR sky130_fd_sc_hd__tapvpwrvgnd_1
Xhold2 u_sample_counter.sample_count\[5\] VGND VGND VPWR VPWR net214 sky130_fd_sc_hd__dlygate4sd3_1
XFILLER_0_89_545 VGND VGND VPWR VPWR sky130_fd_sc_hd__decap_3
X_6780_ u_input_buffer.fifo_mem\[30\]\[0\] _3029_ _3031_ u_input_buffer.fifo_mem\[58\]\[0\]
+ VGND VGND VPWR VPWR _3032_ sky130_fd_sc_hd__a22o_1
X_5800_ _2432_ VGND VGND VPWR VPWR _0745_ sky130_fd_sc_hd__clkbuf_1
XFILLER_0_9_517 VPWR VGND VPWR VGND sky130_ef_sc_hd__decap_12
X_3992_ u_sensor_interface.sensor_array\[1\]\[5\] net59 _1345_ VGND VGND VPWR VPWR
+ _1347_ sky130_fd_sc_hd__mux2_1
X_5731_ _2395_ VGND VGND VPWR VPWR _0713_ sky130_fd_sc_hd__clkbuf_1
XFILLER_0_45_626 VGND VGND VPWR VPWR sky130_fd_sc_hd__decap_3
XFILLER_0_115_503 VGND VGND VPWR VPWR sky130_fd_sc_hd__fill_1
X_8450_ clknet_leaf_30_clk _0539_ VGND VGND VPWR VPWR u_input_buffer.fifo_mem\[35\]\[8\]
+ sky130_fd_sc_hd__dfxtp_1
X_5662_ net979 _2256_ _2352_ VGND VGND VPWR VPWR _2359_ sky130_fd_sc_hd__mux2_1
XFILLER_0_4_200 VGND VGND VPWR VPWR sky130_fd_sc_hd__fill_2
XFILLER_0_29_199 VGND VGND VPWR VPWR sky130_fd_sc_hd__decap_6
XFILLER_0_44_136 VGND VGND VPWR VPWR sky130_fd_sc_hd__fill_1
X_8381_ clknet_leaf_51_clk _0470_ VGND VGND VPWR VPWR u_input_buffer.fifo_mem\[39\]\[3\]
+ sky130_fd_sc_hd__dfxtp_1
X_5593_ net876 _2256_ _2315_ VGND VGND VPWR VPWR _2322_ sky130_fd_sc_hd__mux2_1
X_4613_ _1779_ VGND VGND VPWR VPWR _0211_ sky130_fd_sc_hd__clkbuf_1
X_7401_ _3631_ _3633_ _3635_ _3637_ VGND VGND VPWR VPWR _3638_ sky130_fd_sc_hd__or4_1
XFILLER_0_44_169 VGND VGND VPWR VPWR sky130_fd_sc_hd__decap_4
Xhold402 u_input_buffer.fifo_mem\[39\]\[2\] VGND VGND VPWR VPWR net614 sky130_fd_sc_hd__dlygate4sd3_1
XFILLER_0_111_51 VGND VGND VPWR VPWR sky130_fd_sc_hd__decap_4
X_4544_ _1391_ net1179 _1738_ VGND VGND VPWR VPWR _1741_ sky130_fd_sc_hd__mux2_1
X_7332_ u_input_buffer.fifo_mem\[6\]\[13\] _3034_ _3036_ u_input_buffer.fifo_mem\[28\]\[13\]
+ _3570_ VGND VGND VPWR VPWR _3571_ sky130_fd_sc_hd__a221o_1
Xhold413 u_input_buffer.fifo_mem\[10\]\[0\] VGND VGND VPWR VPWR net625 sky130_fd_sc_hd__dlygate4sd3_1
Xhold424 u_input_buffer.fifo_mem\[32\]\[0\] VGND VGND VPWR VPWR net636 sky130_fd_sc_hd__dlygate4sd3_1
Xhold435 u_input_buffer.fifo_mem\[11\]\[6\] VGND VGND VPWR VPWR net647 sky130_fd_sc_hd__dlygate4sd3_1
XFILLER_0_20_82 VGND VGND VPWR VPWR sky130_fd_sc_hd__fill_2
X_7263_ u_input_buffer.fifo_mem\[63\]\[11\] _2886_ _3075_ u_input_buffer.fifo_mem\[55\]\[11\]
+ _3503_ VGND VGND VPWR VPWR _3504_ sky130_fd_sc_hd__a221o_1
Xhold446 u_input_buffer.fifo_mem\[55\]\[5\] VGND VGND VPWR VPWR net658 sky130_fd_sc_hd__dlygate4sd3_1
XFILLER_0_96_53 VPWR VGND VPWR VGND sky130_ef_sc_hd__decap_12
X_9002_ clknet_leaf_48_clk _1091_ VGND VGND VPWR VPWR u_input_buffer.fifo_mem\[0\]\[0\]
+ sky130_fd_sc_hd__dfxtp_1
Xhold457 u_input_buffer.fifo_mem\[12\]\[2\] VGND VGND VPWR VPWR net669 sky130_fd_sc_hd__dlygate4sd3_1
X_4475_ net1287 _1624_ _1682_ VGND VGND VPWR VPWR _1695_ sky130_fd_sc_hd__mux2_1
X_6214_ _1702_ _2567_ VGND VGND VPWR VPWR _2661_ sky130_fd_sc_hd__nor2_4
Xhold468 u_input_buffer.fifo_mem\[28\]\[10\] VGND VGND VPWR VPWR net680 sky130_fd_sc_hd__dlygate4sd3_1
Xhold479 u_input_buffer.fifo_mem\[50\]\[9\] VGND VGND VPWR VPWR net691 sky130_fd_sc_hd__dlygate4sd3_1
X_7194_ u_input_buffer.fifo_mem\[53\]\[10\] _2933_ _2935_ u_input_buffer.fifo_mem\[57\]\[10\]
+ VGND VGND VPWR VPWR _3436_ sky130_fd_sc_hd__a22o_1
XFILLER_0_96_97 VGND VGND VPWR VPWR sky130_fd_sc_hd__decap_3
XTAP_740 VGND VPWR sky130_fd_sc_hd__tapvpwrvgnd_1
XTAP_751 VGND VPWR sky130_fd_sc_hd__tapvpwrvgnd_1
X_6145_ _1659_ _2567_ VGND VGND VPWR VPWR _2624_ sky130_fd_sc_hd__nor2_4
Xhold1102 u_sensor_interface.sensor_array\[0\]\[2\] VGND VGND VPWR VPWR net1314 sky130_fd_sc_hd__dlygate4sd3_1
X_6076_ _2586_ VGND VGND VPWR VPWR _2587_ sky130_fd_sc_hd__buf_4
Xhold1113 u_input_buffer.wr_ptr\[1\] VGND VGND VPWR VPWR net1325 sky130_fd_sc_hd__dlygate4sd3_1
XTAP_762 VGND VPWR sky130_fd_sc_hd__tapvpwrvgnd_1
XTAP_773 VGND VPWR sky130_fd_sc_hd__tapvpwrvgnd_1
XTAP_784 VGND VPWR sky130_fd_sc_hd__tapvpwrvgnd_1
XTAP_795 VGND VPWR sky130_fd_sc_hd__tapvpwrvgnd_1
X_5027_ net426 _2008_ _1990_ VGND VGND VPWR VPWR _2009_ sky130_fd_sc_hd__mux2_1
X_6978_ u_input_buffer.fifo_mem\[30\]\[4\] _3029_ _3031_ u_input_buffer.fifo_mem\[58\]\[4\]
+ VGND VGND VPWR VPWR _3226_ sky130_fd_sc_hd__a22o_1
X_8717_ clknet_leaf_18_clk _0806_ VGND VGND VPWR VPWR u_input_buffer.fifo_mem\[18\]\[3\]
+ sky130_fd_sc_hd__dfxtp_1
X_5929_ _1390_ VGND VGND VPWR VPWR _2502_ sky130_fd_sc_hd__buf_4
XFILLER_0_90_231 VGND VGND VPWR VPWR sky130_fd_sc_hd__fill_1
XFILLER_0_63_445 VGND VGND VPWR VPWR sky130_fd_sc_hd__decap_3
X_8648_ clknet_leaf_90_clk _0737_ VGND VGND VPWR VPWR u_input_buffer.fifo_mem\[23\]\[14\]
+ sky130_fd_sc_hd__dfxtp_1
X_8579_ clknet_leaf_69_clk _0668_ VGND VGND VPWR VPWR u_input_buffer.fifo_mem\[27\]\[9\]
+ sky130_fd_sc_hd__dfxtp_1
XFILLER_0_50_139 VGND VGND VPWR VPWR sky130_fd_sc_hd__fill_1
XFILLER_0_8_3 VPWR VGND VPWR VGND sky130_ef_sc_hd__decap_12
Xhold980 u_input_buffer.fifo_mem\[5\]\[14\] VGND VGND VPWR VPWR net1192 sky130_fd_sc_hd__dlygate4sd3_1
Xhold991 u_input_buffer.fifo_mem\[21\]\[0\] VGND VGND VPWR VPWR net1203 sky130_fd_sc_hd__dlygate4sd3_1
XFILLER_0_66_261 VGND VGND VPWR VPWR sky130_fd_sc_hd__fill_1
XFILLER_0_81_231 VGND VGND VPWR VPWR sky130_fd_sc_hd__fill_1
XFILLER_0_26_158 VGND VGND VPWR VPWR sky130_fd_sc_hd__decap_3
XFILLER_0_1_225 VGND VGND VPWR VPWR sky130_fd_sc_hd__fill_1
X_4260_ u_analytics_engine.threshold\[12\] VGND VGND VPWR VPWR _1540_ sky130_fd_sc_hd__inv_2
X_4191_ net236 _1490_ VGND VGND VPWR VPWR _0076_ sky130_fd_sc_hd__xnor2_1
X_7950_ clknet_leaf_52_clk _0040_ VGND VGND VPWR VPWR u_sensor_interface.sensor_array\[0\]\[6\]
+ sky130_fd_sc_hd__dfxtp_1
X_6901_ u_input_buffer.fifo_mem\[7\]\[2\] _3025_ _3027_ u_input_buffer.fifo_mem\[22\]\[2\]
+ _3150_ VGND VGND VPWR VPWR _3151_ sky130_fd_sc_hd__a221o_1
XFILLER_0_89_375 VGND VGND VPWR VPWR sky130_fd_sc_hd__fill_1
X_7881_ clknet_leaf_61_clk net227 net197 VGND VGND VPWR VPWR u_register_bank.status_flags\[1\]
+ sky130_fd_sc_hd__dfrtp_1
XFILLER_0_82_33 VGND VGND VPWR VPWR sky130_fd_sc_hd__fill_1
X_6832_ _3001_ _3044_ _3083_ VGND VGND VPWR VPWR _3084_ sky130_fd_sc_hd__or3_1
XFILLER_0_77_559 VGND VGND VPWR VPWR sky130_fd_sc_hd__fill_1
XFILLER_0_15_93 VGND VGND VPWR VPWR sky130_fd_sc_hd__fill_2
XFILLER_0_85_570 VGND VGND VPWR VPWR sky130_fd_sc_hd__fill_2
X_3975_ net1319 net85 _1334_ VGND VGND VPWR VPWR _1338_ sky130_fd_sc_hd__mux2_1
X_6763_ _3014_ VGND VGND VPWR VPWR _3015_ sky130_fd_sc_hd__clkbuf_4
X_5714_ _1632_ net1204 _2369_ VGND VGND VPWR VPWR _2386_ sky130_fd_sc_hd__mux2_1
X_6694_ u_input_buffer.fifo_mem\[17\]\[0\] _2943_ _2945_ u_input_buffer.fifo_mem\[5\]\[0\]
+ VGND VGND VPWR VPWR _2946_ sky130_fd_sc_hd__a22o_1
X_8502_ clknet_leaf_10_clk _0591_ VGND VGND VPWR VPWR u_input_buffer.fifo_mem\[32\]\[12\]
+ sky130_fd_sc_hd__dfxtp_1
XFILLER_0_45_445 VGND VGND VPWR VPWR sky130_fd_sc_hd__decap_3
XFILLER_0_115_333 VGND VGND VPWR VPWR sky130_fd_sc_hd__decap_3
X_8433_ clknet_leaf_32_clk _0522_ VGND VGND VPWR VPWR u_input_buffer.fifo_mem\[36\]\[7\]
+ sky130_fd_sc_hd__dfxtp_1
XFILLER_0_60_404 VGND VGND VPWR VPWR sky130_fd_sc_hd__decap_3
XFILLER_0_17_169 VGND VGND VPWR VPWR sky130_fd_sc_hd__fill_1
X_5645_ _2349_ VGND VGND VPWR VPWR _0673_ sky130_fd_sc_hd__clkbuf_1
XFILLER_0_33_629 VGND VGND VPWR VPWR sky130_fd_sc_hd__fill_1
XFILLER_0_86_3 VPWR VGND VPWR VGND sky130_ef_sc_hd__decap_12
XFILLER_0_60_448 VGND VGND VPWR VPWR sky130_fd_sc_hd__fill_1
XFILLER_0_5_553 VGND VGND VPWR VPWR sky130_fd_sc_hd__decap_6
XFILLER_0_32_139 VGND VGND VPWR VPWR sky130_fd_sc_hd__fill_1
XFILLER_0_115_377 VGND VGND VPWR VPWR sky130_fd_sc_hd__decap_8
X_8364_ clknet_leaf_51_clk _0453_ VGND VGND VPWR VPWR u_input_buffer.fifo_mem\[40\]\[2\]
+ sky130_fd_sc_hd__dfxtp_1
XFILLER_0_13_331 VGND VGND VPWR VPWR sky130_fd_sc_hd__fill_2
XFILLER_0_13_320 VGND VGND VPWR VPWR sky130_fd_sc_hd__fill_2
X_5576_ _2312_ VGND VGND VPWR VPWR _0641_ sky130_fd_sc_hd__clkbuf_1
XFILLER_0_5_597 VPWR VGND VPWR VGND sky130_ef_sc_hd__decap_12
Xhold210 u_input_buffer.fifo_mem\[50\]\[12\] VGND VGND VPWR VPWR net422 sky130_fd_sc_hd__dlygate4sd3_1
Xhold243 u_input_buffer.fifo_mem\[39\]\[3\] VGND VGND VPWR VPWR net455 sky130_fd_sc_hd__dlygate4sd3_1
Xhold221 u_input_buffer.fifo_mem\[23\]\[9\] VGND VGND VPWR VPWR net433 sky130_fd_sc_hd__dlygate4sd3_1
Xhold232 u_input_buffer.fifo_mem\[15\]\[13\] VGND VGND VPWR VPWR net444 sky130_fd_sc_hd__dlygate4sd3_1
X_7315_ u_input_buffer.fifo_mem\[14\]\[13\] _2957_ _2960_ u_input_buffer.fifo_mem\[42\]\[13\]
+ VGND VGND VPWR VPWR _3554_ sky130_fd_sc_hd__a22o_1
X_4527_ _1729_ VGND VGND VPWR VPWR _0175_ sky130_fd_sc_hd__clkbuf_1
X_8295_ clknet_leaf_0_clk _0384_ VGND VGND VPWR VPWR u_input_buffer.fifo_mem\[45\]\[13\]
+ sky130_fd_sc_hd__dfxtp_1
XFILLER_0_111_572 VPWR VGND VPWR VGND sky130_ef_sc_hd__decap_12
Xhold287 u_input_buffer.fifo_mem\[39\]\[1\] VGND VGND VPWR VPWR net499 sky130_fd_sc_hd__dlygate4sd3_1
Xhold265 u_input_buffer.fifo_mem\[8\]\[7\] VGND VGND VPWR VPWR net477 sky130_fd_sc_hd__dlygate4sd3_1
X_4458_ _1686_ VGND VGND VPWR VPWR _0149_ sky130_fd_sc_hd__clkbuf_1
Xhold276 u_input_buffer.fifo_mem\[62\]\[1\] VGND VGND VPWR VPWR net488 sky130_fd_sc_hd__dlygate4sd3_1
Xhold254 u_input_buffer.fifo_mem\[14\]\[13\] VGND VGND VPWR VPWR net466 sky130_fd_sc_hd__dlygate4sd3_1
X_7246_ _3471_ _3473_ _3477_ _3486_ VGND VGND VPWR VPWR _3487_ sky130_fd_sc_hd__or4_2
Xhold298 u_input_buffer.fifo_mem\[35\]\[2\] VGND VGND VPWR VPWR net510 sky130_fd_sc_hd__dlygate4sd3_1
X_7177_ _3413_ _3415_ _3417_ _3419_ VGND VGND VPWR VPWR _3420_ sky130_fd_sc_hd__or4_1
XTAP_570 VGND VPWR sky130_fd_sc_hd__tapvpwrvgnd_1
X_6128_ _2615_ VGND VGND VPWR VPWR _0890_ sky130_fd_sc_hd__clkbuf_1
X_4389_ _1409_ net1186 _1641_ VGND VGND VPWR VPWR _1647_ sky130_fd_sc_hd__mux2_1
XTAP_581 VGND VPWR sky130_fd_sc_hd__tapvpwrvgnd_1
XTAP_592 VGND VPWR sky130_fd_sc_hd__tapvpwrvgnd_1
X_6059_ net390 _2514_ _2569_ VGND VGND VPWR VPWR _2578_ sky130_fd_sc_hd__mux2_1
XFILLER_0_95_334 VGND VGND VPWR VPWR sky130_fd_sc_hd__fill_2
XFILLER_0_48_283 VGND VGND VPWR VPWR sky130_fd_sc_hd__fill_2
XFILLER_0_106_355 VGND VGND VPWR VPWR sky130_fd_sc_hd__fill_1
XFILLER_0_51_415 VGND VGND VPWR VPWR sky130_fd_sc_hd__fill_2
XFILLER_0_36_48 VGND VGND VPWR VPWR sky130_fd_sc_hd__fill_2
XFILLER_0_74_529 VGND VGND VPWR VPWR sky130_fd_sc_hd__decap_3
X_5430_ _2226_ VGND VGND VPWR VPWR _0581_ sky130_fd_sc_hd__clkbuf_1
XFILLER_0_2_501 VPWR VGND VPWR VGND sky130_ef_sc_hd__decap_12
X_5361_ net464 _1994_ _2187_ VGND VGND VPWR VPWR _2190_ sky130_fd_sc_hd__mux2_1
XFILLER_0_2_545 VPWR VGND VPWR VGND sky130_ef_sc_hd__decap_12
XFILLER_0_23_673 VGND VGND VPWR VPWR sky130_fd_sc_hd__decap_3
X_7100_ u_input_buffer.fifo_mem\[39\]\[7\] _3050_ _3052_ u_input_buffer.fifo_mem\[40\]\[7\]
+ VGND VGND VPWR VPWR _3345_ sky130_fd_sc_hd__a22o_1
X_5292_ _2153_ VGND VGND VPWR VPWR _0516_ sky130_fd_sc_hd__clkbuf_1
X_8080_ clknet_leaf_59_clk _0169_ VGND VGND VPWR VPWR u_input_buffer.fifo_mem\[58\]\[6\]
+ sky130_fd_sc_hd__dfxtp_1
XFILLER_0_77_44 VGND VGND VPWR VPWR sky130_fd_sc_hd__fill_1
XFILLER_0_10_312 VGND VGND VPWR VPWR sky130_fd_sc_hd__decap_3
XFILLER_0_2_589 VPWR VGND VPWR VGND sky130_ef_sc_hd__decap_12
XFILLER_0_22_172 VGND VGND VPWR VPWR sky130_fd_sc_hd__fill_2
X_4312_ _1589_ _1590_ VGND VGND VPWR VPWR _1591_ sky130_fd_sc_hd__or2_1
X_7031_ _3259_ _3268_ _3277_ VGND VGND VPWR VPWR _3278_ sky130_fd_sc_hd__or3_1
X_4243_ _1520_ _1521_ _1519_ _1527_ VGND VGND VPWR VPWR _1528_ sky130_fd_sc_hd__nor4_1
X_4174_ net239 _1479_ VGND VGND VPWR VPWR _0070_ sky130_fd_sc_hd__xnor2_1
X_8982_ clknet_leaf_10_clk _1071_ VGND VGND VPWR VPWR u_input_buffer.fifo_mem\[2\]\[12\]
+ sky130_fd_sc_hd__dfxtp_1
X_7933_ clknet_leaf_75_clk _0023_ VGND VGND VPWR VPWR u_sensor_interface.sensor_array\[1\]\[5\]
+ sky130_fd_sc_hd__dfxtp_2
XFILLER_0_77_334 VGND VGND VPWR VPWR sky130_fd_sc_hd__fill_2
X_7864_ net28 u_register_bank.sensor_enable\[24\] _3927_ VGND VGND VPWR VPWR _3932_
+ sky130_fd_sc_hd__mux2_1
XFILLER_0_9_100 VGND VGND VPWR VPWR sky130_fd_sc_hd__decap_4
X_7795_ _3895_ VGND VGND VPWR VPWR _1277_ sky130_fd_sc_hd__clkbuf_1
X_6815_ _2885_ _2882_ _2956_ VGND VGND VPWR VPWR _3067_ sky130_fd_sc_hd__and3_2
XFILLER_0_107_108 VGND VGND VPWR VPWR sky130_fd_sc_hd__decap_4
X_6746_ u_input_buffer.fifo_mem\[50\]\[0\] _2995_ _2997_ u_input_buffer.fifo_mem\[4\]\[0\]
+ VGND VGND VPWR VPWR _2998_ sky130_fd_sc_hd__a22o_1
XFILLER_0_73_540 VGND VGND VPWR VPWR sky130_fd_sc_hd__fill_2
X_3958_ net1284 net76 _1323_ VGND VGND VPWR VPWR _1329_ sky130_fd_sc_hd__mux2_1
XFILLER_0_115_141 VGND VGND VPWR VPWR sky130_fd_sc_hd__decap_8
X_6677_ u_input_buffer.rd_ptr\[5\] u_input_buffer.rd_ptr\[4\] VGND VGND VPWR VPWR
+ _2929_ sky130_fd_sc_hd__or2_2
X_5628_ net879 _2256_ _2334_ VGND VGND VPWR VPWR _2341_ sky130_fd_sc_hd__mux2_1
X_8416_ clknet_leaf_18_clk _0505_ VGND VGND VPWR VPWR u_input_buffer.fifo_mem\[37\]\[6\]
+ sky130_fd_sc_hd__dfxtp_1
X_8347_ clknet_leaf_20_clk _0436_ VGND VGND VPWR VPWR u_input_buffer.fifo_mem\[41\]\[1\]
+ sky130_fd_sc_hd__dfxtp_1
XFILLER_0_60_278 VGND VGND VPWR VPWR sky130_fd_sc_hd__fill_1
X_5559_ _1415_ net1224 _2297_ VGND VGND VPWR VPWR _2304_ sky130_fd_sc_hd__mux2_1
X_8278_ clknet_leaf_102_clk _0367_ VGND VGND VPWR VPWR u_input_buffer.fifo_mem\[46\]\[12\]
+ sky130_fd_sc_hd__dfxtp_1
X_7229_ u_input_buffer.fifo_mem\[21\]\[11\] _2908_ _2912_ u_input_buffer.fifo_mem\[25\]\[11\]
+ VGND VGND VPWR VPWR _3470_ sky130_fd_sc_hd__a22o_1
XFILLER_0_96_632 VPWR VGND VPWR VGND sky130_ef_sc_hd__decap_12
XTAP_1533 VGND VPWR sky130_fd_sc_hd__tapvpwrvgnd_1
XTAP_1511 VGND VPWR sky130_fd_sc_hd__tapvpwrvgnd_1
XTAP_1522 VGND VPWR sky130_fd_sc_hd__tapvpwrvgnd_1
XTAP_1500 VGND VPWR sky130_fd_sc_hd__tapvpwrvgnd_1
XFILLER_0_96_654 VPWR VGND VPWR VGND sky130_ef_sc_hd__decap_12
XFILLER_0_68_345 VGND VGND VPWR VPWR sky130_fd_sc_hd__fill_1
XPHY_40 VGND VGND VPWR VPWR sky130_fd_sc_hd__decap_3
XTAP_1566 VGND VPWR sky130_fd_sc_hd__tapvpwrvgnd_1
XTAP_1555 VGND VPWR sky130_fd_sc_hd__tapvpwrvgnd_1
XTAP_1544 VGND VPWR sky130_fd_sc_hd__tapvpwrvgnd_1
XFILLER_0_95_164 VGND VGND VPWR VPWR sky130_fd_sc_hd__decap_4
XPHY_51 VGND VGND VPWR VPWR sky130_fd_sc_hd__decap_3
XPHY_62 VGND VGND VPWR VPWR sky130_fd_sc_hd__decap_3
XPHY_73 VGND VGND VPWR VPWR sky130_fd_sc_hd__decap_3
XTAP_1599 VGND VPWR sky130_fd_sc_hd__tapvpwrvgnd_1
XTAP_1588 VGND VPWR sky130_fd_sc_hd__tapvpwrvgnd_1
XTAP_1577 VGND VPWR sky130_fd_sc_hd__tapvpwrvgnd_1
XFILLER_0_83_337 VGND VGND VPWR VPWR sky130_fd_sc_hd__decap_6
XPHY_84 VGND VGND VPWR VPWR sky130_fd_sc_hd__decap_3
XPHY_95 VGND VGND VPWR VPWR sky130_fd_sc_hd__decap_3
XFILLER_0_36_264 VGND VGND VPWR VPWR sky130_fd_sc_hd__fill_1
XFILLER_0_24_448 VGND VGND VPWR VPWR sky130_fd_sc_hd__fill_1
XFILLER_0_51_223 VGND VGND VPWR VPWR sky130_fd_sc_hd__fill_1
XFILLER_0_47_36 VGND VGND VPWR VPWR sky130_fd_sc_hd__fill_1
XFILLER_0_2_27 VGND VGND VPWR VPWR sky130_fd_sc_hd__fill_1
XFILLER_0_87_621 VGND VGND VPWR VPWR sky130_fd_sc_hd__fill_1
X_4930_ net482 _1700_ _1952_ VGND VGND VPWR VPWR _1953_ sky130_fd_sc_hd__mux2_1
X_4861_ _1914_ VGND VGND VPWR VPWR _0324_ sky130_fd_sc_hd__clkbuf_1
XFILLER_0_86_197 VGND VGND VPWR VPWR sky130_fd_sc_hd__fill_2
XFILLER_0_74_326 VGND VGND VPWR VPWR sky130_fd_sc_hd__fill_1
X_6600_ _2866_ _2861_ _2867_ VGND VGND VPWR VPWR _1110_ sky130_fd_sc_hd__a21o_1
X_7580_ net41 u_analytics_engine.threshold\[7\] _3737_ VGND VGND VPWR VPWR _3745_
+ sky130_fd_sc_hd__mux2_1
XANTENNA_27 net71 VGND VGND VPWR VPWR sky130_fd_sc_hd__diode_2
XANTENNA_38 net119 VGND VGND VPWR VPWR sky130_fd_sc_hd__diode_2
X_4792_ net1097 _1708_ _1874_ VGND VGND VPWR VPWR _1877_ sky130_fd_sc_hd__mux2_1
XFILLER_0_74_359 VGND VGND VPWR VPWR sky130_fd_sc_hd__decap_4
XANTENNA_16 net7 VGND VGND VPWR VPWR sky130_fd_sc_hd__diode_2
XANTENNA_49 u_analytics_engine.data_in\[13\] VGND VGND VPWR VPWR sky130_fd_sc_hd__diode_2
X_6531_ _1610_ net1272 _2825_ VGND VGND VPWR VPWR _2830_ sky130_fd_sc_hd__mux2_1
X_6462_ _2793_ VGND VGND VPWR VPWR _1046_ sky130_fd_sc_hd__clkbuf_1
XFILLER_0_70_587 VGND VGND VPWR VPWR sky130_fd_sc_hd__fill_1
X_5413_ _1445_ net980 _2204_ VGND VGND VPWR VPWR _2217_ sky130_fd_sc_hd__mux2_1
X_9181_ net169 _1269_ VGND VGND VPWR VPWR net138 sky130_fd_sc_hd__dfxtp_1
X_6393_ _1608_ net1194 _2753_ VGND VGND VPWR VPWR _2757_ sky130_fd_sc_hd__mux2_1
X_8201_ clknet_leaf_98_clk _0290_ VGND VGND VPWR VPWR u_input_buffer.fifo_mem\[51\]\[15\]
+ sky130_fd_sc_hd__dfxtp_1
XFILLER_0_100_306 VGND VGND VPWR VPWR sky130_fd_sc_hd__fill_2
XFILLER_0_88_65 VGND VGND VPWR VPWR sky130_fd_sc_hd__decap_8
Xoutput134 net134 VGND VGND VPWR VPWR cfg_rdata[28] sky130_fd_sc_hd__clkbuf_4
X_5344_ _2180_ VGND VGND VPWR VPWR _0541_ sky130_fd_sc_hd__clkbuf_1
XFILLER_0_2_353 VGND VGND VPWR VPWR sky130_fd_sc_hd__fill_2
X_8132_ clknet_leaf_89_clk _0221_ VGND VGND VPWR VPWR u_input_buffer.fifo_mem\[55\]\[10\]
+ sky130_fd_sc_hd__dfxtp_1
Xoutput123 net123 VGND VGND VPWR VPWR cfg_rdata[18] sky130_fd_sc_hd__clkbuf_4
Xoutput145 net145 VGND VGND VPWR VPWR cfg_rdata[9] sky130_fd_sc_hd__clkbuf_4
Xoutput156 net156 VGND VGND VPWR VPWR processed_data_out[2] sky130_fd_sc_hd__clkbuf_4
X_8063_ clknet_leaf_45_clk _0152_ VGND VGND VPWR VPWR u_input_buffer.fifo_mem\[59\]\[5\]
+ sky130_fd_sc_hd__dfxtp_1
X_5275_ _1439_ net1193 _2132_ VGND VGND VPWR VPWR _2144_ sky130_fd_sc_hd__mux2_1
X_7014_ u_input_buffer.fifo_mem\[8\]\[5\] _3004_ _3006_ u_input_buffer.fifo_mem\[19\]\[5\]
+ _3260_ VGND VGND VPWR VPWR _3261_ sky130_fd_sc_hd__a221o_1
X_4226_ net230 _1513_ VGND VGND VPWR VPWR _1516_ sky130_fd_sc_hd__nor2_1
XFILLER_0_49_3 VGND VGND VPWR VPWR sky130_fd_sc_hd__decap_8
X_4157_ u_sensor_interface.sensor_array\[0\]\[15\] u_sensor_interface.sensor_array\[1\]\[15\]
+ net111 VGND VGND VPWR VPWR _1470_ sky130_fd_sc_hd__mux2_1
XFILLER_0_97_429 VGND VGND VPWR VPWR sky130_fd_sc_hd__decap_3
X_4088_ _1410_ u_sensor_interface.sensor_array\[2\]\[5\] _1379_ VGND VGND VPWR VPWR
+ _1411_ sky130_fd_sc_hd__mux2_1
X_8965_ clknet_leaf_89_clk _1054_ VGND VGND VPWR VPWR u_input_buffer.fifo_mem\[3\]\[11\]
+ sky130_fd_sc_hd__dfxtp_1
X_8896_ clknet_leaf_54_clk _0985_ VGND VGND VPWR VPWR u_input_buffer.fifo_mem\[7\]\[6\]
+ sky130_fd_sc_hd__dfxtp_1
X_7916_ clknet_leaf_83_clk _0006_ VGND VGND VPWR VPWR u_sensor_interface.sensor_array\[2\]\[4\]
+ sky130_fd_sc_hd__dfxtp_2
X_7847_ net19 u_register_bank.sensor_enable\[16\] _3916_ VGND VGND VPWR VPWR _3923_
+ sky130_fd_sc_hd__mux2_1
XFILLER_0_65_337 VGND VGND VPWR VPWR sky130_fd_sc_hd__decap_3
X_7778_ _3886_ VGND VGND VPWR VPWR _1269_ sky130_fd_sc_hd__clkbuf_1
XFILLER_0_80_318 VGND VGND VPWR VPWR sky130_fd_sc_hd__fill_2
X_6729_ _2906_ _2964_ VGND VGND VPWR VPWR _2981_ sky130_fd_sc_hd__nor2_4
XFILLER_0_6_681 VGND VGND VPWR VPWR sky130_fd_sc_hd__fill_1
XFILLER_0_103_111 VGND VGND VPWR VPWR sky130_fd_sc_hd__fill_1
XFILLER_0_61_565 VGND VGND VPWR VPWR sky130_fd_sc_hd__fill_1
XFILLER_0_21_407 VGND VGND VPWR VPWR sky130_fd_sc_hd__decap_4
XTAP_1341 VGND VPWR sky130_fd_sc_hd__tapvpwrvgnd_1
XTAP_1330 VGND VPWR sky130_fd_sc_hd__tapvpwrvgnd_1
XTAP_1374 VGND VPWR sky130_fd_sc_hd__tapvpwrvgnd_1
XTAP_1352 VGND VPWR sky130_fd_sc_hd__tapvpwrvgnd_1
XTAP_1363 VGND VPWR sky130_fd_sc_hd__tapvpwrvgnd_1
XFILLER_0_83_123 VGND VGND VPWR VPWR sky130_fd_sc_hd__fill_2
XTAP_1396 VGND VPWR sky130_fd_sc_hd__tapvpwrvgnd_1
XTAP_1385 VGND VPWR sky130_fd_sc_hd__tapvpwrvgnd_1
XFILLER_0_71_329 VGND VGND VPWR VPWR sky130_fd_sc_hd__decap_6
Xinput36 cfg_wdata[31] VGND VGND VPWR VPWR net36 sky130_fd_sc_hd__clkbuf_2
Xinput25 cfg_wdata[21] VGND VGND VPWR VPWR net25 sky130_fd_sc_hd__clkbuf_4
Xclkbuf_leaf_103_clk clknet_3_0__leaf_clk VGND VGND VPWR VPWR clknet_leaf_103_clk
+ sky130_fd_sc_hd__clkbuf_16
XFILLER_0_3_117 VGND VGND VPWR VPWR sky130_fd_sc_hd__fill_1
Xinput14 cfg_wdata[11] VGND VGND VPWR VPWR net14 sky130_fd_sc_hd__buf_2
Xinput47 sensor_data_in[10] VGND VGND VPWR VPWR net47 sky130_fd_sc_hd__dlymetal6s2s_1
Xinput58 sensor_data_in[20] VGND VGND VPWR VPWR net58 sky130_fd_sc_hd__clkbuf_1
XFILLER_0_107_483 VGND VGND VPWR VPWR sky130_fd_sc_hd__fill_1
Xhold809 u_input_buffer.fifo_mem\[53\]\[13\] VGND VGND VPWR VPWR net1021 sky130_fd_sc_hd__dlygate4sd3_1
Xinput69 sensor_data_in[30] VGND VGND VPWR VPWR net69 sky130_fd_sc_hd__clkbuf_1
X_5060_ net861 _2000_ _2024_ VGND VGND VPWR VPWR _2030_ sky130_fd_sc_hd__mux2_1
X_4011_ u_sensor_interface.sensor_array\[1\]\[14\] net69 _1356_ VGND VGND VPWR VPWR
+ _1357_ sky130_fd_sc_hd__mux2_1
X_8750_ clknet_leaf_17_clk _0839_ VGND VGND VPWR VPWR u_input_buffer.fifo_mem\[16\]\[4\]
+ sky130_fd_sc_hd__dfxtp_1
X_5962_ _1456_ VGND VGND VPWR VPWR _2524_ sky130_fd_sc_hd__buf_4
XFILLER_0_75_602 VGND VGND VPWR VPWR sky130_fd_sc_hd__fill_2
X_4913_ _1943_ VGND VGND VPWR VPWR _0347_ sky130_fd_sc_hd__clkbuf_1
X_7701_ _3827_ VGND VGND VPWR VPWR _1251_ sky130_fd_sc_hd__clkbuf_1
X_5893_ net419 _2248_ _2479_ VGND VGND VPWR VPWR _2482_ sky130_fd_sc_hd__mux2_1
X_8681_ clknet_leaf_106_clk _0770_ VGND VGND VPWR VPWR u_input_buffer.fifo_mem\[21\]\[15\]
+ sky130_fd_sc_hd__dfxtp_1
X_7632_ _3698_ VGND VGND VPWR VPWR _3772_ sky130_fd_sc_hd__clkbuf_4
X_4844_ _1904_ VGND VGND VPWR VPWR _0317_ sky130_fd_sc_hd__clkbuf_1
XFILLER_0_90_638 VGND VGND VPWR VPWR sky130_fd_sc_hd__decap_6
XFILLER_0_55_370 VGND VGND VPWR VPWR sky130_fd_sc_hd__fill_2
X_4775_ net379 _1726_ _1854_ VGND VGND VPWR VPWR _1867_ sky130_fd_sc_hd__mux2_1
X_7563_ net3 net4 _3696_ VGND VGND VPWR VPWR _3735_ sky130_fd_sc_hd__nor3b_1
XFILLER_0_55_381 VGND VGND VPWR VPWR sky130_fd_sc_hd__fill_2
X_6514_ _2820_ VGND VGND VPWR VPWR _1071_ sky130_fd_sc_hd__clkbuf_1
XFILLER_0_70_362 VGND VGND VPWR VPWR sky130_fd_sc_hd__fill_2
X_7494_ _3697_ VGND VGND VPWR VPWR _3698_ sky130_fd_sc_hd__clkbuf_2
XFILLER_0_43_576 VGND VGND VPWR VPWR sky130_fd_sc_hd__fill_2
XFILLER_0_3_673 VPWR VGND VPWR VGND sky130_ef_sc_hd__decap_12
XFILLER_0_15_289 VGND VGND VPWR VPWR sky130_fd_sc_hd__fill_2
X_6445_ net1295 _1450_ _2770_ VGND VGND VPWR VPWR _2784_ sky130_fd_sc_hd__mux2_1
XFILLER_0_2_150 VGND VGND VPWR VPWR sky130_fd_sc_hd__decap_3
X_9164_ net170 _1252_ VGND VGND VPWR VPWR net119 sky130_fd_sc_hd__dfxtp_4
X_6376_ _2747_ VGND VGND VPWR VPWR _1006_ sky130_fd_sc_hd__clkbuf_1
X_5327_ net510 _1994_ _2169_ VGND VGND VPWR VPWR _2172_ sky130_fd_sc_hd__mux2_1
XFILLER_0_101_659 VPWR VGND VPWR VGND sky130_ef_sc_hd__decap_12
XFILLER_0_100_136 VGND VGND VPWR VPWR sky130_fd_sc_hd__fill_1
X_8115_ clknet_leaf_69_clk _0204_ VGND VGND VPWR VPWR u_input_buffer.fifo_mem\[56\]\[9\]
+ sky130_fd_sc_hd__dfxtp_1
X_9095_ net174 _1183_ net206 VGND VGND VPWR VPWR u_register_bank.window_cfg\[9\] sky130_fd_sc_hd__dfrtp_1
XFILLER_0_2_194 VGND VGND VPWR VPWR sky130_fd_sc_hd__fill_2
X_8046_ clknet_leaf_40_clk _0135_ VGND VGND VPWR VPWR u_input_buffer.fifo_mem\[60\]\[4\]
+ sky130_fd_sc_hd__dfxtp_1
X_5258_ _2135_ VGND VGND VPWR VPWR _0500_ sky130_fd_sc_hd__clkbuf_1
X_5189_ net499 _1992_ _2097_ VGND VGND VPWR VPWR _2099_ sky130_fd_sc_hd__mux2_1
X_4209_ u_sample_counter.sample_count\[16\] u_sample_counter.sample_count\[17\] VGND
+ VGND VPWR VPWR _1504_ sky130_fd_sc_hd__nand2_1
XFILLER_0_3_81 VGND VGND VPWR VPWR sky130_fd_sc_hd__fill_1
X_8948_ clknet_leaf_15_clk _1037_ VGND VGND VPWR VPWR u_input_buffer.fifo_mem\[4\]\[10\]
+ sky130_fd_sc_hd__dfxtp_1
X_8879_ clknet_leaf_46_clk _0968_ VGND VGND VPWR VPWR u_input_buffer.fifo_mem\[8\]\[5\]
+ sky130_fd_sc_hd__dfxtp_1
XFILLER_0_93_476 VGND VGND VPWR VPWR sky130_fd_sc_hd__fill_2
XFILLER_0_65_189 VGND VGND VPWR VPWR sky130_fd_sc_hd__decap_6
XFILLER_0_65_167 VGND VGND VPWR VPWR sky130_fd_sc_hd__fill_1
XFILLER_0_34_587 VGND VGND VPWR VPWR sky130_fd_sc_hd__fill_1
Xfanout180 net182 VGND VGND VPWR VPWR net180 sky130_fd_sc_hd__buf_1
Xfanout191 net192 VGND VGND VPWR VPWR net191 sky130_fd_sc_hd__clkbuf_4
XFILLER_0_88_248 VGND VGND VPWR VPWR sky130_fd_sc_hd__fill_1
XFILLER_0_84_421 VGND VGND VPWR VPWR sky130_fd_sc_hd__fill_1
XFILLER_0_84_454 VGND VGND VPWR VPWR sky130_fd_sc_hd__fill_2
XTAP_1182 VGND VPWR sky130_fd_sc_hd__tapvpwrvgnd_1
XTAP_1171 VGND VPWR sky130_fd_sc_hd__tapvpwrvgnd_1
XTAP_1160 VGND VPWR sky130_fd_sc_hd__tapvpwrvgnd_1
XFILLER_0_29_359 VGND VGND VPWR VPWR sky130_fd_sc_hd__fill_1
XTAP_1193 VGND VPWR sky130_fd_sc_hd__tapvpwrvgnd_1
X_4560_ _1439_ net1270 _1737_ VGND VGND VPWR VPWR _1749_ sky130_fd_sc_hd__mux2_1
XFILLER_0_25_521 VGND VGND VPWR VPWR sky130_fd_sc_hd__decap_3
XFILLER_0_25_543 VGND VGND VPWR VPWR sky130_fd_sc_hd__fill_1
XFILLER_0_107_3 VPWR VGND VPWR VGND sky130_ef_sc_hd__decap_12
XFILLER_0_8_15 VPWR VGND VPWR VGND sky130_ef_sc_hd__decap_12
X_4491_ _1705_ VGND VGND VPWR VPWR _0163_ sky130_fd_sc_hd__clkbuf_1
Xhold617 u_input_buffer.fifo_mem\[22\]\[9\] VGND VGND VPWR VPWR net829 sky130_fd_sc_hd__dlygate4sd3_1
Xhold606 u_input_buffer.fifo_mem\[11\]\[10\] VGND VGND VPWR VPWR net818 sky130_fd_sc_hd__dlygate4sd3_1
XFILLER_0_110_401 VGND VGND VPWR VPWR sky130_fd_sc_hd__decap_4
X_6230_ net630 _2512_ _2662_ VGND VGND VPWR VPWR _2670_ sky130_fd_sc_hd__mux2_1
XFILLER_0_100_53 VPWR VGND VPWR VGND sky130_ef_sc_hd__decap_12
Xhold639 u_input_buffer.fifo_mem\[48\]\[4\] VGND VGND VPWR VPWR net851 sky130_fd_sc_hd__dlygate4sd3_1
Xhold628 u_input_buffer.fifo_mem\[61\]\[8\] VGND VGND VPWR VPWR net840 sky130_fd_sc_hd__dlygate4sd3_1
XFILLER_0_100_97 VGND VGND VPWR VPWR sky130_fd_sc_hd__decap_8
X_6161_ net612 _2512_ _2625_ VGND VGND VPWR VPWR _2633_ sky130_fd_sc_hd__mux2_1
XFILLER_0_0_632 VPWR VGND VPWR VGND sky130_ef_sc_hd__decap_12
XFILLER_0_0_665 VGND VGND VPWR VPWR sky130_fd_sc_hd__decap_6
XTAP_900 VGND VPWR sky130_fd_sc_hd__tapvpwrvgnd_1
XTAP_944 VGND VPWR sky130_fd_sc_hd__tapvpwrvgnd_1
XTAP_933 VGND VPWR sky130_fd_sc_hd__tapvpwrvgnd_1
XTAP_922 VGND VPWR sky130_fd_sc_hd__tapvpwrvgnd_1
XTAP_911 VGND VPWR sky130_fd_sc_hd__tapvpwrvgnd_1
X_5112_ net730 _2018_ _2041_ VGND VGND VPWR VPWR _2057_ sky130_fd_sc_hd__mux2_1
X_6092_ _2595_ VGND VGND VPWR VPWR _0874_ sky130_fd_sc_hd__clkbuf_1
XTAP_977 VGND VPWR sky130_fd_sc_hd__tapvpwrvgnd_1
XTAP_955 VGND VPWR sky130_fd_sc_hd__tapvpwrvgnd_1
XTAP_966 VGND VPWR sky130_fd_sc_hd__tapvpwrvgnd_1
XFILLER_0_109_51 VGND VGND VPWR VPWR sky130_fd_sc_hd__decap_4
XTAP_999 VGND VPWR sky130_fd_sc_hd__tapvpwrvgnd_1
XTAP_988 VGND VPWR sky130_fd_sc_hd__tapvpwrvgnd_1
X_5043_ _2019_ VGND VGND VPWR VPWR _0401_ sky130_fd_sc_hd__clkbuf_1
XFILLER_0_18_93 VGND VGND VPWR VPWR sky130_fd_sc_hd__decap_3
X_8802_ clknet_leaf_0_clk _0891_ VGND VGND VPWR VPWR u_input_buffer.fifo_mem\[13\]\[8\]
+ sky130_fd_sc_hd__dfxtp_1
X_6994_ u_analytics_engine.data_in\[4\] _2893_ _3240_ _3241_ VGND VGND VPWR VPWR _1130_
+ sky130_fd_sc_hd__a22o_1
X_5945_ net727 _2512_ _2498_ VGND VGND VPWR VPWR _2513_ sky130_fd_sc_hd__mux2_1
X_8733_ clknet_leaf_111_clk _0822_ VGND VGND VPWR VPWR u_input_buffer.fifo_mem\[17\]\[3\]
+ sky130_fd_sc_hd__dfxtp_1
XFILLER_0_47_101 VGND VGND VPWR VPWR sky130_fd_sc_hd__fill_1
X_8664_ clknet_leaf_81_clk _0753_ VGND VGND VPWR VPWR u_input_buffer.fifo_mem\[22\]\[14\]
+ sky130_fd_sc_hd__dfxtp_1
X_5876_ _2472_ VGND VGND VPWR VPWR _0781_ sky130_fd_sc_hd__clkbuf_1
X_4827_ _1391_ net1306 _1893_ VGND VGND VPWR VPWR _1896_ sky130_fd_sc_hd__mux2_1
X_7615_ _3763_ VGND VGND VPWR VPWR _1229_ sky130_fd_sc_hd__clkbuf_1
XFILLER_0_63_649 VGND VGND VPWR VPWR sky130_fd_sc_hd__decap_3
X_8595_ clknet_leaf_69_clk _0684_ VGND VGND VPWR VPWR u_input_buffer.fifo_mem\[26\]\[9\]
+ sky130_fd_sc_hd__dfxtp_1
XFILLER_0_28_381 VGND VGND VPWR VPWR sky130_fd_sc_hd__fill_2
X_4758_ _1858_ VGND VGND VPWR VPWR _0277_ sky130_fd_sc_hd__clkbuf_1
X_7546_ _3726_ VGND VGND VPWR VPWR _1197_ sky130_fd_sc_hd__clkbuf_1
XFILLER_0_31_502 VGND VGND VPWR VPWR sky130_fd_sc_hd__fill_2
X_7477_ net401 _1432_ _3678_ VGND VGND VPWR VPWR _3688_ sky130_fd_sc_hd__mux2_1
XFILLER_0_16_587 VGND VGND VPWR VPWR sky130_fd_sc_hd__fill_1
X_4689_ _1397_ net663 _1817_ VGND VGND VPWR VPWR _1821_ sky130_fd_sc_hd__mux2_1
X_6428_ _2775_ VGND VGND VPWR VPWR _1030_ sky130_fd_sc_hd__clkbuf_1
X_9216_ net171 _1303_ net205 VGND VGND VPWR VPWR u_register_bank.sensor_enable\[17\]
+ sky130_fd_sc_hd__dfrtp_1
X_9147_ net177 _1235_ net209 VGND VGND VPWR VPWR u_register_bank.threshold_cfg\[29\]
+ sky130_fd_sc_hd__dfrtp_1
X_6359_ net315 _2504_ _2735_ VGND VGND VPWR VPWR _2739_ sky130_fd_sc_hd__mux2_1
X_9078_ clknet_leaf_42_clk _1166_ VGND VGND VPWR VPWR u_input_buffer.fifo_mem\[63\]\[8\]
+ sky130_fd_sc_hd__dfxtp_1
X_8029_ clknet_leaf_5_clk _0118_ VGND VGND VPWR VPWR u_input_buffer.fifo_mem\[61\]\[3\]
+ sky130_fd_sc_hd__dfxtp_1
XPHY_210 VGND VGND VPWR VPWR sky130_fd_sc_hd__decap_3
XFILLER_0_78_281 VGND VGND VPWR VPWR sky130_fd_sc_hd__fill_2
XFILLER_0_78_270 VGND VGND VPWR VPWR sky130_fd_sc_hd__fill_2
XFILLER_0_14_29 VPWR VGND VPWR VGND sky130_ef_sc_hd__decap_12
XPHY_221 VGND VGND VPWR VPWR sky130_fd_sc_hd__decap_3
XFILLER_0_38_156 VGND VGND VPWR VPWR sky130_fd_sc_hd__fill_2
XFILLER_0_109_589 VPWR VGND VPWR VGND sky130_ef_sc_hd__decap_12
XFILLER_0_34_362 VGND VGND VPWR VPWR sky130_fd_sc_hd__fill_2
XFILLER_0_62_682 VGND VGND VPWR VPWR sky130_fd_sc_hd__fill_1
XFILLER_0_104_272 VGND VGND VPWR VPWR sky130_fd_sc_hd__decap_4
XFILLER_0_39_26 VGND VGND VPWR VPWR sky130_fd_sc_hd__fill_2
Xhold3 u_sample_counter.sample_count\[23\] VGND VGND VPWR VPWR net215 sky130_fd_sc_hd__dlygate4sd3_1
X_3991_ _1346_ VGND VGND VPWR VPWR _0022_ sky130_fd_sc_hd__clkbuf_1
X_5730_ net983 _2256_ _2388_ VGND VGND VPWR VPWR _2395_ sky130_fd_sc_hd__mux2_1
XFILLER_0_9_529 VPWR VGND VPWR VGND sky130_ef_sc_hd__decap_12
XFILLER_0_84_273 VGND VGND VPWR VPWR sky130_fd_sc_hd__fill_1
XFILLER_0_29_178 VGND VGND VPWR VPWR sky130_fd_sc_hd__decap_4
X_5661_ _2358_ VGND VGND VPWR VPWR _0680_ sky130_fd_sc_hd__clkbuf_1
X_7400_ u_input_buffer.fifo_mem\[51\]\[15\] _2989_ _2992_ u_input_buffer.fifo_mem\[11\]\[15\]
+ _3636_ VGND VGND VPWR VPWR _3637_ sky130_fd_sc_hd__a221o_1
X_8380_ clknet_leaf_51_clk _0469_ VGND VGND VPWR VPWR u_input_buffer.fifo_mem\[39\]\[2\]
+ sky130_fd_sc_hd__dfxtp_1
X_5592_ _2321_ VGND VGND VPWR VPWR _0648_ sky130_fd_sc_hd__clkbuf_1
X_4612_ net334 _1700_ _1778_ VGND VGND VPWR VPWR _1779_ sky130_fd_sc_hd__mux2_1
X_4543_ _1740_ VGND VGND VPWR VPWR _0180_ sky130_fd_sc_hd__clkbuf_1
X_7331_ u_input_buffer.fifo_mem\[52\]\[13\] _3038_ _3040_ u_input_buffer.fifo_mem\[56\]\[13\]
+ VGND VGND VPWR VPWR _3570_ sky130_fd_sc_hd__a22o_1
Xhold403 u_input_buffer.fifo_mem\[50\]\[6\] VGND VGND VPWR VPWR net615 sky130_fd_sc_hd__dlygate4sd3_1
Xhold414 u_input_buffer.fifo_mem\[53\]\[15\] VGND VGND VPWR VPWR net626 sky130_fd_sc_hd__dlygate4sd3_1
X_7262_ u_input_buffer.fifo_mem\[54\]\[11\] _3077_ _3079_ u_input_buffer.fifo_mem\[46\]\[11\]
+ VGND VGND VPWR VPWR _3503_ sky130_fd_sc_hd__a22o_1
Xhold425 u_input_buffer.fifo_mem\[11\]\[12\] VGND VGND VPWR VPWR net637 sky130_fd_sc_hd__dlygate4sd3_1
Xhold436 u_input_buffer.fifo_mem\[0\]\[14\] VGND VGND VPWR VPWR net648 sky130_fd_sc_hd__dlygate4sd3_1
Xhold447 u_input_buffer.fifo_mem\[36\]\[1\] VGND VGND VPWR VPWR net659 sky130_fd_sc_hd__dlygate4sd3_1
Xhold458 u_input_buffer.fifo_mem\[44\]\[6\] VGND VGND VPWR VPWR net670 sky130_fd_sc_hd__dlygate4sd3_1
Xhold469 u_input_buffer.fifo_mem\[56\]\[8\] VGND VGND VPWR VPWR net681 sky130_fd_sc_hd__dlygate4sd3_1
X_9001_ clknet_leaf_103_clk _1090_ VGND VGND VPWR VPWR u_input_buffer.fifo_mem\[1\]\[15\]
+ sky130_fd_sc_hd__dfxtp_1
X_4474_ _1694_ VGND VGND VPWR VPWR _0157_ sky130_fd_sc_hd__clkbuf_1
Xmax_cap166 _1891_ VGND VGND VPWR VPWR net166 sky130_fd_sc_hd__buf_2
X_6213_ _2660_ VGND VGND VPWR VPWR _0930_ sky130_fd_sc_hd__clkbuf_1
XFILLER_0_110_253 VGND VGND VPWR VPWR sky130_fd_sc_hd__decap_8
XFILLER_0_96_65 VPWR VGND VPWR VGND sky130_ef_sc_hd__decap_12
XFILLER_0_0_462 VGND VGND VPWR VPWR sky130_fd_sc_hd__fill_1
X_7193_ u_input_buffer.fifo_mem\[41\]\[10\] _2918_ _2920_ u_input_buffer.fifo_mem\[45\]\[10\]
+ _3434_ VGND VGND VPWR VPWR _3435_ sky130_fd_sc_hd__a221o_1
X_6144_ _2623_ VGND VGND VPWR VPWR _0898_ sky130_fd_sc_hd__clkbuf_1
XTAP_730 VGND VPWR sky130_fd_sc_hd__tapvpwrvgnd_1
XTAP_741 VGND VPWR sky130_fd_sc_hd__tapvpwrvgnd_1
XTAP_752 VGND VPWR sky130_fd_sc_hd__tapvpwrvgnd_1
Xhold1103 u_input_buffer.fifo_mem\[59\]\[13\] VGND VGND VPWR VPWR net1315 sky130_fd_sc_hd__dlygate4sd3_1
XTAP_763 VGND VPWR sky130_fd_sc_hd__tapvpwrvgnd_1
XTAP_774 VGND VPWR sky130_fd_sc_hd__tapvpwrvgnd_1
XTAP_785 VGND VPWR sky130_fd_sc_hd__tapvpwrvgnd_1
X_6075_ _1600_ _2567_ VGND VGND VPWR VPWR _2586_ sky130_fd_sc_hd__nor2_4
X_5026_ _1432_ VGND VGND VPWR VPWR _2008_ sky130_fd_sc_hd__buf_4
XFILLER_0_31_3 VGND VGND VPWR VPWR sky130_fd_sc_hd__fill_2
XTAP_796 VGND VPWR sky130_fd_sc_hd__tapvpwrvgnd_1
Xclkbuf_leaf_92_clk clknet_3_2__leaf_clk VGND VGND VPWR VPWR clknet_leaf_92_clk sky130_fd_sc_hd__clkbuf_16
X_6977_ u_input_buffer.fifo_mem\[27\]\[4\] _3013_ _3015_ u_input_buffer.fifo_mem\[59\]\[4\]
+ _3224_ VGND VGND VPWR VPWR _3225_ sky130_fd_sc_hd__a221o_1
X_8716_ clknet_leaf_25_clk _0805_ VGND VGND VPWR VPWR u_input_buffer.fifo_mem\[18\]\[2\]
+ sky130_fd_sc_hd__dfxtp_1
X_5928_ _2501_ VGND VGND VPWR VPWR _0804_ sky130_fd_sc_hd__clkbuf_1
X_5859_ net616 _2248_ _2461_ VGND VGND VPWR VPWR _2464_ sky130_fd_sc_hd__mux2_1
X_8647_ clknet_leaf_90_clk _0736_ VGND VGND VPWR VPWR u_input_buffer.fifo_mem\[23\]\[13\]
+ sky130_fd_sc_hd__dfxtp_1
XFILLER_0_36_649 VGND VGND VPWR VPWR sky130_fd_sc_hd__fill_1
X_8578_ clknet_leaf_69_clk _0667_ VGND VGND VPWR VPWR u_input_buffer.fifo_mem\[27\]\[8\]
+ sky130_fd_sc_hd__dfxtp_1
XFILLER_0_16_362 VGND VGND VPWR VPWR sky130_fd_sc_hd__fill_2
X_7529_ _3717_ VGND VGND VPWR VPWR _1189_ sky130_fd_sc_hd__clkbuf_1
XFILLER_0_114_581 VGND VGND VPWR VPWR sky130_fd_sc_hd__decap_6
Xhold970 u_input_buffer.fifo_mem\[3\]\[14\] VGND VGND VPWR VPWR net1182 sky130_fd_sc_hd__dlygate4sd3_1
Xhold981 u_input_buffer.fifo_mem\[37\]\[10\] VGND VGND VPWR VPWR net1193 sky130_fd_sc_hd__dlygate4sd3_1
XFILLER_0_101_297 VGND VGND VPWR VPWR sky130_fd_sc_hd__fill_1
Xhold992 u_input_buffer.fifo_mem\[25\]\[15\] VGND VGND VPWR VPWR net1204 sky130_fd_sc_hd__dlygate4sd3_1
Xclkbuf_leaf_83_clk clknet_3_2__leaf_clk VGND VGND VPWR VPWR clknet_leaf_83_clk sky130_fd_sc_hd__clkbuf_16
XFILLER_0_66_251 VGND VGND VPWR VPWR sky130_fd_sc_hd__fill_1
XFILLER_0_41_49 VGND VGND VPWR VPWR sky130_fd_sc_hd__decap_6
XFILLER_0_54_457 VGND VGND VPWR VPWR sky130_fd_sc_hd__fill_1
XFILLER_0_81_276 VGND VGND VPWR VPWR sky130_fd_sc_hd__fill_1
XFILLER_0_35_671 VGND VGND VPWR VPWR sky130_fd_sc_hd__fill_1
XFILLER_0_22_343 VGND VGND VPWR VPWR sky130_fd_sc_hd__decap_4
X_4190_ _1492_ VGND VGND VPWR VPWR _0075_ sky130_fd_sc_hd__clkbuf_1
X_6900_ u_input_buffer.fifo_mem\[30\]\[2\] _3029_ _3031_ u_input_buffer.fifo_mem\[58\]\[2\]
+ VGND VGND VPWR VPWR _3150_ sky130_fd_sc_hd__a22o_1
X_7880_ clknet_leaf_59_clk net243 net197 VGND VGND VPWR VPWR u_register_bank.status_flags\[0\]
+ sky130_fd_sc_hd__dfrtp_1
Xclkbuf_leaf_74_clk clknet_3_3__leaf_clk VGND VGND VPWR VPWR clknet_leaf_74_clk sky130_fd_sc_hd__clkbuf_16
XFILLER_0_106_41 VPWR VGND VPWR VGND sky130_ef_sc_hd__decap_12
X_6831_ _3054_ _3064_ _3074_ _3082_ VGND VGND VPWR VPWR _3083_ sky130_fd_sc_hd__or4_1
XFILLER_0_89_398 VGND VGND VPWR VPWR sky130_fd_sc_hd__fill_2
XFILLER_0_82_67 VGND VGND VPWR VPWR sky130_fd_sc_hd__fill_1
XFILLER_0_106_85 VPWR VGND VPWR VGND sky130_ef_sc_hd__decap_12
X_3974_ _1337_ VGND VGND VPWR VPWR _0014_ sky130_fd_sc_hd__clkbuf_1
X_6762_ _2900_ _2991_ VGND VGND VPWR VPWR _3014_ sky130_fd_sc_hd__nor2_2
XFILLER_0_45_402 VGND VGND VPWR VPWR sky130_fd_sc_hd__fill_1
X_8501_ clknet_leaf_7_clk _0590_ VGND VGND VPWR VPWR u_input_buffer.fifo_mem\[32\]\[11\]
+ sky130_fd_sc_hd__dfxtp_1
X_5713_ _2385_ VGND VGND VPWR VPWR _0705_ sky130_fd_sc_hd__clkbuf_1
X_6693_ _2944_ VGND VGND VPWR VPWR _2945_ sky130_fd_sc_hd__clkbuf_4
X_8432_ clknet_leaf_31_clk _0521_ VGND VGND VPWR VPWR u_input_buffer.fifo_mem\[36\]\[6\]
+ sky130_fd_sc_hd__dfxtp_1
X_5644_ net1048 _2272_ _2333_ VGND VGND VPWR VPWR _2349_ sky130_fd_sc_hd__mux2_1
X_8363_ clknet_leaf_50_clk _0452_ VGND VGND VPWR VPWR u_input_buffer.fifo_mem\[40\]\[1\]
+ sky130_fd_sc_hd__dfxtp_1
XFILLER_0_32_129 VGND VGND VPWR VPWR sky130_fd_sc_hd__fill_2
X_7314_ u_input_buffer.fifo_mem\[1\]\[13\] _2931_ _3550_ _3552_ VGND VGND VPWR VPWR
+ _3553_ sky130_fd_sc_hd__a211o_1
X_5575_ _1463_ net1101 _2296_ VGND VGND VPWR VPWR _2312_ sky130_fd_sc_hd__mux2_1
Xhold200 u_input_buffer.fifo_mem\[3\]\[11\] VGND VGND VPWR VPWR net412 sky130_fd_sc_hd__dlygate4sd3_1
Xhold211 u_input_buffer.fifo_mem\[27\]\[11\] VGND VGND VPWR VPWR net423 sky130_fd_sc_hd__dlygate4sd3_1
Xhold244 u_input_buffer.fifo_mem\[43\]\[7\] VGND VGND VPWR VPWR net456 sky130_fd_sc_hd__dlygate4sd3_1
Xhold222 u_input_buffer.fifo_mem\[15\]\[5\] VGND VGND VPWR VPWR net434 sky130_fd_sc_hd__dlygate4sd3_1
Xhold233 u_input_buffer.fifo_mem\[48\]\[8\] VGND VGND VPWR VPWR net445 sky130_fd_sc_hd__dlygate4sd3_1
X_4526_ net653 _1728_ _1703_ VGND VGND VPWR VPWR _1729_ sky130_fd_sc_hd__mux2_1
X_8294_ clknet_leaf_107_clk _0383_ VGND VGND VPWR VPWR u_input_buffer.fifo_mem\[45\]\[12\]
+ sky130_fd_sc_hd__dfxtp_1
Xhold277 u_input_buffer.fifo_mem\[6\]\[5\] VGND VGND VPWR VPWR net489 sky130_fd_sc_hd__dlygate4sd3_1
Xhold266 u_input_buffer.fifo_mem\[43\]\[4\] VGND VGND VPWR VPWR net478 sky130_fd_sc_hd__dlygate4sd3_1
Xhold255 u_input_buffer.fifo_mem\[31\]\[2\] VGND VGND VPWR VPWR net467 sky130_fd_sc_hd__dlygate4sd3_1
X_4457_ net1197 _1606_ _1683_ VGND VGND VPWR VPWR _1686_ sky130_fd_sc_hd__mux2_1
X_7245_ _3479_ _3481_ _3483_ _3485_ VGND VGND VPWR VPWR _3486_ sky130_fd_sc_hd__or4_1
XFILLER_0_40_184 VGND VGND VPWR VPWR sky130_fd_sc_hd__fill_1
XFILLER_0_111_584 VPWR VGND VPWR VGND sky130_ef_sc_hd__decap_12
Xhold299 u_input_buffer.fifo_mem\[23\]\[4\] VGND VGND VPWR VPWR net511 sky130_fd_sc_hd__dlygate4sd3_1
X_7176_ u_input_buffer.fifo_mem\[6\]\[9\] _3035_ _3037_ u_input_buffer.fifo_mem\[28\]\[9\]
+ _3418_ VGND VGND VPWR VPWR _3419_ sky130_fd_sc_hd__a221o_1
XFILLER_0_0_270 VGND VGND VPWR VPWR sky130_fd_sc_hd__fill_2
Xhold288 u_input_buffer.fifo_mem\[12\]\[13\] VGND VGND VPWR VPWR net500 sky130_fd_sc_hd__dlygate4sd3_1
XTAP_560 VGND VPWR sky130_fd_sc_hd__tapvpwrvgnd_1
X_6127_ _1616_ net1074 _2607_ VGND VGND VPWR VPWR _2615_ sky130_fd_sc_hd__mux2_1
X_4388_ _1646_ VGND VGND VPWR VPWR _0119_ sky130_fd_sc_hd__clkbuf_1
XTAP_571 VGND VPWR sky130_fd_sc_hd__tapvpwrvgnd_1
XTAP_582 VGND VPWR sky130_fd_sc_hd__tapvpwrvgnd_1
XTAP_593 VGND VPWR sky130_fd_sc_hd__tapvpwrvgnd_1
X_6058_ _2577_ VGND VGND VPWR VPWR _0858_ sky130_fd_sc_hd__clkbuf_1
X_5009_ net512 _1996_ _1990_ VGND VGND VPWR VPWR _1997_ sky130_fd_sc_hd__mux2_1
Xclkbuf_leaf_65_clk clknet_3_6__leaf_clk VGND VGND VPWR VPWR clknet_leaf_65_clk sky130_fd_sc_hd__clkbuf_16
XFILLER_0_95_379 VPWR VGND VPWR VGND sky130_ef_sc_hd__decap_12
XFILLER_0_48_262 VGND VGND VPWR VPWR sky130_fd_sc_hd__fill_1
XFILLER_0_36_457 VGND VGND VPWR VPWR sky130_fd_sc_hd__decap_3
XFILLER_0_17_671 VGND VGND VPWR VPWR sky130_fd_sc_hd__fill_1
Xclkbuf_leaf_56_clk clknet_3_7__leaf_clk VGND VGND VPWR VPWR clknet_leaf_56_clk sky130_fd_sc_hd__clkbuf_16
XFILLER_0_59_505 VGND VGND VPWR VPWR sky130_fd_sc_hd__decap_8
XFILLER_0_99_685 VGND VGND VPWR VPWR sky130_fd_sc_hd__fill_1
XFILLER_0_98_195 VGND VGND VPWR VPWR sky130_fd_sc_hd__fill_1
XFILLER_0_86_357 VGND VGND VPWR VPWR sky130_fd_sc_hd__fill_2
XFILLER_0_109_150 VGND VGND VPWR VPWR sky130_fd_sc_hd__decap_3
XFILLER_0_6_329 VGND VGND VPWR VPWR sky130_fd_sc_hd__fill_2
XFILLER_0_14_118 VGND VGND VPWR VPWR sky130_fd_sc_hd__fill_2
XFILLER_0_42_416 VGND VGND VPWR VPWR sky130_fd_sc_hd__decap_4
XFILLER_0_2_513 VGND VGND VPWR VPWR sky130_fd_sc_hd__fill_1
X_5360_ _2189_ VGND VGND VPWR VPWR _0548_ sky130_fd_sc_hd__clkbuf_1
XFILLER_0_2_557 VPWR VGND VPWR VGND sky130_ef_sc_hd__decap_12
X_5291_ net659 _1992_ _2151_ VGND VGND VPWR VPWR _2153_ sky130_fd_sc_hd__mux2_1
XFILLER_0_65_9 VGND VGND VPWR VPWR sky130_fd_sc_hd__fill_2
X_4311_ net185 u_input_buffer.wr_ptr\[5\] VGND VGND VPWR VPWR _1590_ sky130_fd_sc_hd__nand2_2
X_7030_ _3270_ _3272_ _3274_ _3276_ VGND VGND VPWR VPWR _3277_ sky130_fd_sc_hd__or4_1
X_4242_ u_sample_counter.sample_count\[26\] u_sample_counter.sample_count\[27\] VGND
+ VGND VPWR VPWR _1527_ sky130_fd_sc_hd__nand2_1
XFILLER_0_77_89 VGND VGND VPWR VPWR sky130_fd_sc_hd__decap_4
X_4173_ _1481_ VGND VGND VPWR VPWR _0069_ sky130_fd_sc_hd__clkbuf_1
XFILLER_0_93_55 VGND VGND VPWR VPWR sky130_fd_sc_hd__fill_1
X_8981_ clknet_leaf_7_clk _1070_ VGND VGND VPWR VPWR u_input_buffer.fifo_mem\[2\]\[11\]
+ sky130_fd_sc_hd__dfxtp_1
X_7932_ clknet_leaf_33_clk _0022_ VGND VGND VPWR VPWR u_sensor_interface.sensor_array\[1\]\[4\]
+ sky130_fd_sc_hd__dfxtp_1
XFILLER_0_93_77 VGND VGND VPWR VPWR sky130_fd_sc_hd__fill_1
Xclkbuf_leaf_47_clk clknet_3_7__leaf_clk VGND VGND VPWR VPWR clknet_leaf_47_clk sky130_fd_sc_hd__clkbuf_16
XFILLER_0_77_313 VGND VGND VPWR VPWR sky130_fd_sc_hd__fill_2
XFILLER_0_26_71 VGND VGND VPWR VPWR sky130_fd_sc_hd__fill_1
X_7863_ _3931_ VGND VGND VPWR VPWR _1309_ sky130_fd_sc_hd__clkbuf_1
X_7794_ net161 u_analytics_engine.data_in\[7\] _3893_ VGND VGND VPWR VPWR _3895_ sky130_fd_sc_hd__mux2_1
X_6814_ _3065_ VGND VGND VPWR VPWR _3066_ sky130_fd_sc_hd__clkbuf_4
X_6745_ _2996_ VGND VGND VPWR VPWR _2997_ sky130_fd_sc_hd__clkbuf_4
X_3957_ _1328_ VGND VGND VPWR VPWR _0006_ sky130_fd_sc_hd__clkbuf_1
XFILLER_0_9_167 VGND VGND VPWR VPWR sky130_fd_sc_hd__fill_1
XFILLER_0_18_424 VGND VGND VPWR VPWR sky130_fd_sc_hd__fill_2
X_6676_ u_input_buffer.fifo_mem\[41\]\[0\] _2919_ _2921_ u_input_buffer.fifo_mem\[45\]\[0\]
+ _2927_ VGND VGND VPWR VPWR _2928_ sky130_fd_sc_hd__a221o_1
X_8415_ clknet_leaf_20_clk _0504_ VGND VGND VPWR VPWR u_input_buffer.fifo_mem\[37\]\[5\]
+ sky130_fd_sc_hd__dfxtp_1
X_5627_ _2340_ VGND VGND VPWR VPWR _0664_ sky130_fd_sc_hd__clkbuf_1
XFILLER_0_5_373 VGND VGND VPWR VPWR sky130_fd_sc_hd__decap_3
XFILLER_0_115_197 VGND VGND VPWR VPWR sky130_fd_sc_hd__fill_2
X_8346_ clknet_leaf_20_clk _0435_ VGND VGND VPWR VPWR u_input_buffer.fifo_mem\[41\]\[0\]
+ sky130_fd_sc_hd__dfxtp_1
X_5558_ _2303_ VGND VGND VPWR VPWR _0632_ sky130_fd_sc_hd__clkbuf_1
X_4509_ _1717_ VGND VGND VPWR VPWR _0169_ sky130_fd_sc_hd__clkbuf_1
X_8277_ clknet_leaf_101_clk _0366_ VGND VGND VPWR VPWR u_input_buffer.fifo_mem\[46\]\[11\]
+ sky130_fd_sc_hd__dfxtp_1
XFILLER_0_41_493 VGND VGND VPWR VPWR sky130_fd_sc_hd__fill_2
X_5489_ net1018 _2262_ _2244_ VGND VGND VPWR VPWR _2263_ sky130_fd_sc_hd__mux2_1
X_7228_ u_analytics_engine.data_in\[10\] _2892_ _3468_ _3469_ VGND VGND VPWR VPWR
+ _1136_ sky130_fd_sc_hd__a22o_1
X_7159_ u_input_buffer.fifo_mem\[14\]\[9\] _2958_ _2961_ u_input_buffer.fifo_mem\[42\]\[9\]
+ VGND VGND VPWR VPWR _3402_ sky130_fd_sc_hd__a22o_1
XTAP_390 VGND VPWR sky130_fd_sc_hd__tapvpwrvgnd_1
Xclkbuf_leaf_38_clk clknet_3_5__leaf_clk VGND VGND VPWR VPWR clknet_leaf_38_clk sky130_fd_sc_hd__clkbuf_16
XTAP_1512 VGND VPWR sky130_fd_sc_hd__tapvpwrvgnd_1
XTAP_1523 VGND VPWR sky130_fd_sc_hd__tapvpwrvgnd_1
XTAP_1501 VGND VPWR sky130_fd_sc_hd__tapvpwrvgnd_1
XFILLER_0_96_666 VPWR VGND VPWR VGND sky130_ef_sc_hd__decap_12
XPHY_30 VGND VGND VPWR VPWR sky130_fd_sc_hd__decap_3
XTAP_1567 VGND VPWR sky130_fd_sc_hd__tapvpwrvgnd_1
XTAP_1556 VGND VPWR sky130_fd_sc_hd__tapvpwrvgnd_1
XTAP_1545 VGND VPWR sky130_fd_sc_hd__tapvpwrvgnd_1
XTAP_1534 VGND VPWR sky130_fd_sc_hd__tapvpwrvgnd_1
XFILLER_0_56_519 VGND VGND VPWR VPWR sky130_fd_sc_hd__fill_2
XPHY_41 VGND VGND VPWR VPWR sky130_fd_sc_hd__decap_3
XPHY_52 VGND VGND VPWR VPWR sky130_fd_sc_hd__decap_3
XPHY_63 VGND VGND VPWR VPWR sky130_fd_sc_hd__decap_3
XPHY_74 VGND VGND VPWR VPWR sky130_fd_sc_hd__decap_3
XTAP_1589 VGND VPWR sky130_fd_sc_hd__tapvpwrvgnd_1
XTAP_1578 VGND VPWR sky130_fd_sc_hd__tapvpwrvgnd_1
XPHY_85 VGND VGND VPWR VPWR sky130_fd_sc_hd__decap_3
XPHY_96 VGND VGND VPWR VPWR sky130_fd_sc_hd__decap_3
XFILLER_0_24_438 VGND VGND VPWR VPWR sky130_fd_sc_hd__fill_1
XFILLER_0_106_197 VGND VGND VPWR VPWR sky130_fd_sc_hd__fill_2
XFILLER_0_20_600 VGND VGND VPWR VPWR sky130_fd_sc_hd__decap_4
Xclkbuf_leaf_29_clk clknet_3_5__leaf_clk VGND VGND VPWR VPWR clknet_leaf_29_clk sky130_fd_sc_hd__clkbuf_16
X_4860_ net752 _1706_ _1912_ VGND VGND VPWR VPWR _1914_ sky130_fd_sc_hd__mux2_1
XANTENNA_39 net131 VGND VGND VPWR VPWR sky130_fd_sc_hd__diode_2
XANTENNA_28 net71 VGND VGND VPWR VPWR sky130_fd_sc_hd__diode_2
X_4791_ _1876_ VGND VGND VPWR VPWR _0292_ sky130_fd_sc_hd__clkbuf_1
XANTENNA_17 net7 VGND VGND VPWR VPWR sky130_fd_sc_hd__diode_2
XFILLER_0_27_243 VGND VGND VPWR VPWR sky130_fd_sc_hd__fill_2
X_6530_ _2829_ VGND VGND VPWR VPWR _1078_ sky130_fd_sc_hd__clkbuf_1
X_6461_ net592 _1396_ _2789_ VGND VGND VPWR VPWR _2793_ sky130_fd_sc_hd__mux2_1
XFILLER_0_11_600 VPWR VGND VPWR VGND sky130_ef_sc_hd__decap_12
X_5412_ _2216_ VGND VGND VPWR VPWR _0573_ sky130_fd_sc_hd__clkbuf_1
X_6392_ _2756_ VGND VGND VPWR VPWR _1013_ sky130_fd_sc_hd__clkbuf_1
X_8200_ clknet_leaf_98_clk _0289_ VGND VGND VPWR VPWR u_input_buffer.fifo_mem\[51\]\[14\]
+ sky130_fd_sc_hd__dfxtp_1
X_9180_ net172 _1268_ VGND VGND VPWR VPWR net137 sky130_fd_sc_hd__dfxtp_2
X_8131_ clknet_leaf_42_clk _0220_ VGND VGND VPWR VPWR u_input_buffer.fifo_mem\[55\]\[9\]
+ sky130_fd_sc_hd__dfxtp_1
X_5343_ net1149 _2010_ _2168_ VGND VGND VPWR VPWR _2180_ sky130_fd_sc_hd__mux2_1
Xoutput124 net124 VGND VGND VPWR VPWR cfg_rdata[19] sky130_fd_sc_hd__clkbuf_4
Xoutput146 net146 VGND VGND VPWR VPWR data_valid_out sky130_fd_sc_hd__clkbuf_4
Xoutput135 net135 VGND VGND VPWR VPWR cfg_rdata[29] sky130_fd_sc_hd__clkbuf_4
XFILLER_0_112_178 VGND VGND VPWR VPWR sky130_fd_sc_hd__fill_1
Xoutput157 net157 VGND VGND VPWR VPWR processed_data_out[3] sky130_fd_sc_hd__clkbuf_4
X_8062_ clknet_leaf_68_clk _0151_ VGND VGND VPWR VPWR u_input_buffer.fifo_mem\[59\]\[4\]
+ sky130_fd_sc_hd__dfxtp_1
X_5274_ _2143_ VGND VGND VPWR VPWR _0508_ sky130_fd_sc_hd__clkbuf_1
X_7013_ u_input_buffer.fifo_mem\[47\]\[5\] _2880_ _3007_ _3009_ u_input_buffer.fifo_mem\[24\]\[5\]
+ VGND VGND VPWR VPWR _3260_ sky130_fd_sc_hd__a32o_1
X_4225_ _1515_ VGND VGND VPWR VPWR _0087_ sky130_fd_sc_hd__clkbuf_1
X_4156_ _1468_ VGND VGND VPWR VPWR _1469_ sky130_fd_sc_hd__buf_2
X_8964_ clknet_leaf_88_clk _1053_ VGND VGND VPWR VPWR u_input_buffer.fifo_mem\[3\]\[10\]
+ sky130_fd_sc_hd__dfxtp_1
X_4087_ u_sensor_interface.sensor_array\[0\]\[5\] u_sensor_interface.sensor_array\[1\]\[5\]
+ _1318_ VGND VGND VPWR VPWR _1410_ sky130_fd_sc_hd__mux2_1
X_8895_ clknet_leaf_53_clk _0984_ VGND VGND VPWR VPWR u_input_buffer.fifo_mem\[7\]\[5\]
+ sky130_fd_sc_hd__dfxtp_1
X_7915_ clknet_leaf_62_clk _0005_ VGND VGND VPWR VPWR u_sensor_interface.sensor_array\[2\]\[3\]
+ sky130_fd_sc_hd__dfxtp_2
X_7846_ _3922_ VGND VGND VPWR VPWR _1301_ sky130_fd_sc_hd__clkbuf_1
XFILLER_0_108_418 VGND VGND VPWR VPWR sky130_fd_sc_hd__fill_2
XFILLER_0_65_349 VGND VGND VPWR VPWR sky130_fd_sc_hd__decap_4
X_7777_ _3885_ net138 _3781_ VGND VGND VPWR VPWR _3886_ sky130_fd_sc_hd__mux2_1
X_4989_ _1451_ net1135 _1970_ VGND VGND VPWR VPWR _1984_ sky130_fd_sc_hd__mux2_1
XFILLER_0_46_530 VGND VGND VPWR VPWR sky130_fd_sc_hd__fill_2
X_6728_ _2979_ VGND VGND VPWR VPWR _2980_ sky130_fd_sc_hd__buf_4
XFILLER_0_33_202 VGND VGND VPWR VPWR sky130_fd_sc_hd__decap_3
XFILLER_0_73_393 VGND VGND VPWR VPWR sky130_fd_sc_hd__fill_1
X_6659_ _2873_ _2876_ _2877_ _2872_ VGND VGND VPWR VPWR _2911_ sky130_fd_sc_hd__and4bb_1
XFILLER_0_21_419 VGND VGND VPWR VPWR sky130_fd_sc_hd__fill_2
XFILLER_0_14_471 VGND VGND VPWR VPWR sky130_fd_sc_hd__decap_4
X_8329_ clknet_leaf_96_clk _0418_ VGND VGND VPWR VPWR u_input_buffer.fifo_mem\[43\]\[15\]
+ sky130_fd_sc_hd__dfxtp_1
XFILLER_0_103_178 VGND VGND VPWR VPWR sky130_fd_sc_hd__decap_4
XFILLER_0_17_18 VPWR VGND VPWR VGND sky130_ef_sc_hd__decap_12
XFILLER_0_96_430 VGND VGND VPWR VPWR sky130_fd_sc_hd__decap_3
XFILLER_0_96_452 VGND VGND VPWR VPWR sky130_fd_sc_hd__fill_2
XTAP_1331 VGND VPWR sky130_fd_sc_hd__tapvpwrvgnd_1
XTAP_1320 VGND VPWR sky130_fd_sc_hd__tapvpwrvgnd_1
XTAP_1375 VGND VPWR sky130_fd_sc_hd__tapvpwrvgnd_1
XTAP_1353 VGND VPWR sky130_fd_sc_hd__tapvpwrvgnd_1
XTAP_1364 VGND VPWR sky130_fd_sc_hd__tapvpwrvgnd_1
XTAP_1342 VGND VPWR sky130_fd_sc_hd__tapvpwrvgnd_1
XFILLER_0_83_113 VGND VGND VPWR VPWR sky130_fd_sc_hd__fill_2
XTAP_1397 VGND VPWR sky130_fd_sc_hd__tapvpwrvgnd_1
XTAP_1386 VGND VPWR sky130_fd_sc_hd__tapvpwrvgnd_1
XFILLER_0_92_680 VGND VGND VPWR VPWR sky130_fd_sc_hd__fill_2
XFILLER_0_37_585 VPWR VGND VPWR VGND sky130_ef_sc_hd__decap_12
Xinput15 cfg_wdata[12] VGND VGND VPWR VPWR net15 sky130_fd_sc_hd__buf_2
XFILLER_0_107_440 VGND VGND VPWR VPWR sky130_fd_sc_hd__fill_2
Xinput37 cfg_wdata[3] VGND VGND VPWR VPWR net37 sky130_fd_sc_hd__clkbuf_4
Xinput26 cfg_wdata[22] VGND VGND VPWR VPWR net26 sky130_fd_sc_hd__dlymetal6s2s_1
XFILLER_0_12_419 VGND VGND VPWR VPWR sky130_fd_sc_hd__fill_1
Xinput48 sensor_data_in[11] VGND VGND VPWR VPWR net48 sky130_fd_sc_hd__buf_1
Xinput59 sensor_data_in[21] VGND VGND VPWR VPWR net59 sky130_fd_sc_hd__buf_1
XFILLER_0_52_566 VGND VGND VPWR VPWR sky130_fd_sc_hd__fill_1
X_4010_ _1322_ VGND VGND VPWR VPWR _1356_ sky130_fd_sc_hd__buf_8
X_5961_ _2523_ VGND VGND VPWR VPWR _0815_ sky130_fd_sc_hd__clkbuf_1
X_8680_ clknet_leaf_102_clk _0769_ VGND VGND VPWR VPWR u_input_buffer.fifo_mem\[21\]\[14\]
+ sky130_fd_sc_hd__dfxtp_1
X_7700_ _3826_ net118 _3817_ VGND VGND VPWR VPWR _3827_ sky130_fd_sc_hd__mux2_1
X_4912_ net568 _1720_ _1934_ VGND VGND VPWR VPWR _1943_ sky130_fd_sc_hd__mux2_1
XFILLER_0_114_41 VPWR VGND VPWR VGND sky130_ef_sc_hd__decap_12
X_5892_ _2481_ VGND VGND VPWR VPWR _0788_ sky130_fd_sc_hd__clkbuf_1
XFILLER_0_75_625 VGND VGND VPWR VPWR sky130_fd_sc_hd__fill_1
X_7631_ _3771_ VGND VGND VPWR VPWR _1237_ sky130_fd_sc_hd__clkbuf_1
XFILLER_0_114_85 VGND VGND VPWR VPWR sky130_fd_sc_hd__decap_6
X_4843_ _1439_ net1268 _1892_ VGND VGND VPWR VPWR _1904_ sky130_fd_sc_hd__mux2_1
XFILLER_0_7_446 VGND VGND VPWR VPWR sky130_fd_sc_hd__fill_2
X_7562_ _3734_ VGND VGND VPWR VPWR _1205_ sky130_fd_sc_hd__clkbuf_1
X_4774_ _1866_ VGND VGND VPWR VPWR _0285_ sky130_fd_sc_hd__clkbuf_1
X_7493_ net4 _3696_ net3 VGND VGND VPWR VPWR _3697_ sky130_fd_sc_hd__and3b_1
X_6513_ net900 _1450_ _2806_ VGND VGND VPWR VPWR _2820_ sky130_fd_sc_hd__mux2_1
X_6444_ _2783_ VGND VGND VPWR VPWR _1038_ sky130_fd_sc_hd__clkbuf_1
Xclkbuf_leaf_9_clk clknet_3_1__leaf_clk VGND VGND VPWR VPWR clknet_leaf_9_clk sky130_fd_sc_hd__clkbuf_16
XFILLER_0_3_641 VPWR VGND VPWR VGND sky130_ef_sc_hd__decap_12
XFILLER_0_61_3 VGND VGND VPWR VPWR sky130_fd_sc_hd__decap_8
XFILLER_0_3_685 VGND VGND VPWR VPWR sky130_fd_sc_hd__fill_1
X_9163_ net168 _1251_ VGND VGND VPWR VPWR net118 sky130_fd_sc_hd__dfxtp_2
X_6375_ net623 _2520_ _2734_ VGND VGND VPWR VPWR _2747_ sky130_fd_sc_hd__mux2_1
X_5326_ _2171_ VGND VGND VPWR VPWR _0532_ sky130_fd_sc_hd__clkbuf_1
X_9094_ net179 _1182_ net210 VGND VGND VPWR VPWR u_register_bank.window_cfg\[8\] sky130_fd_sc_hd__dfrtp_1
X_8114_ clknet_leaf_69_clk _0203_ VGND VGND VPWR VPWR u_input_buffer.fifo_mem\[56\]\[8\]
+ sky130_fd_sc_hd__dfxtp_1
X_8045_ clknet_leaf_42_clk _0134_ VGND VGND VPWR VPWR u_input_buffer.fifo_mem\[60\]\[3\]
+ sky130_fd_sc_hd__dfxtp_1
X_5257_ _1385_ net1273 _2133_ VGND VGND VPWR VPWR _2135_ sky130_fd_sc_hd__mux2_1
X_4208_ net244 _1501_ VGND VGND VPWR VPWR _0082_ sky130_fd_sc_hd__xnor2_1
X_5188_ _2098_ VGND VGND VPWR VPWR _0467_ sky130_fd_sc_hd__clkbuf_1
X_4139_ _1451_ _1454_ _1320_ VGND VGND VPWR VPWR _1455_ sky130_fd_sc_hd__mux2_1
XFILLER_0_78_430 VGND VGND VPWR VPWR sky130_fd_sc_hd__fill_2
X_8947_ clknet_leaf_14_clk _1036_ VGND VGND VPWR VPWR u_input_buffer.fifo_mem\[4\]\[9\]
+ sky130_fd_sc_hd__dfxtp_1
XFILLER_0_78_452 VGND VGND VPWR VPWR sky130_fd_sc_hd__fill_2
XFILLER_0_66_603 VPWR VGND VPWR VGND sky130_ef_sc_hd__decap_12
XFILLER_0_93_411 VGND VGND VPWR VPWR sky130_fd_sc_hd__decap_4
XFILLER_0_78_474 VGND VGND VPWR VPWR sky130_fd_sc_hd__fill_2
X_8878_ clknet_leaf_66_clk _0967_ VGND VGND VPWR VPWR u_input_buffer.fifo_mem\[8\]\[4\]
+ sky130_fd_sc_hd__dfxtp_1
XFILLER_0_38_305 VGND VGND VPWR VPWR sky130_fd_sc_hd__decap_3
X_7829_ _3913_ VGND VGND VPWR VPWR _1293_ sky130_fd_sc_hd__clkbuf_1
XFILLER_0_81_617 VGND VGND VPWR VPWR sky130_fd_sc_hd__decap_6
XFILLER_0_34_522 VGND VGND VPWR VPWR sky130_fd_sc_hd__fill_1
Xfanout181 net182 VGND VGND VPWR VPWR net181 sky130_fd_sc_hd__buf_2
Xfanout192 net200 VGND VGND VPWR VPWR net192 sky130_fd_sc_hd__clkbuf_4
Xfanout170 net171 VGND VGND VPWR VPWR net170 sky130_fd_sc_hd__buf_2
XFILLER_0_88_216 VGND VGND VPWR VPWR sky130_fd_sc_hd__fill_2
XFILLER_0_57_603 VGND VGND VPWR VPWR sky130_fd_sc_hd__decap_6
XTAP_1150 VGND VPWR sky130_fd_sc_hd__tapvpwrvgnd_1
XTAP_1183 VGND VPWR sky130_fd_sc_hd__tapvpwrvgnd_1
XTAP_1172 VGND VPWR sky130_fd_sc_hd__tapvpwrvgnd_1
XTAP_1161 VGND VPWR sky130_fd_sc_hd__tapvpwrvgnd_1
Xclkbuf_3_4__f_clk clknet_0_clk VGND VGND VPWR VPWR clknet_3_4__leaf_clk sky130_fd_sc_hd__clkbuf_16
XTAP_1194 VGND VPWR sky130_fd_sc_hd__tapvpwrvgnd_1
XFILLER_0_72_639 VGND VGND VPWR VPWR sky130_fd_sc_hd__decap_4
XFILLER_0_107_281 VGND VGND VPWR VPWR sky130_fd_sc_hd__fill_2
XFILLER_0_8_27 VGND VGND VPWR VPWR sky130_fd_sc_hd__fill_1
X_4490_ net345 _1700_ _1704_ VGND VGND VPWR VPWR _1705_ sky130_fd_sc_hd__mux2_1
Xhold607 u_input_buffer.fifo_mem\[20\]\[3\] VGND VGND VPWR VPWR net819 sky130_fd_sc_hd__dlygate4sd3_1
Xhold618 u_input_buffer.fifo_mem\[30\]\[2\] VGND VGND VPWR VPWR net830 sky130_fd_sc_hd__dlygate4sd3_1
XFILLER_0_69_57 VGND VGND VPWR VPWR sky130_fd_sc_hd__decap_6
XFILLER_0_25_588 VGND VGND VPWR VPWR sky130_fd_sc_hd__fill_1
Xhold629 u_input_buffer.fifo_mem\[36\]\[3\] VGND VGND VPWR VPWR net841 sky130_fd_sc_hd__dlygate4sd3_1
XFILLER_0_100_65 VPWR VGND VPWR VGND sky130_ef_sc_hd__decap_12
X_6160_ _2632_ VGND VGND VPWR VPWR _0905_ sky130_fd_sc_hd__clkbuf_1
XFILLER_0_0_655 VGND VGND VPWR VPWR sky130_fd_sc_hd__decap_6
XTAP_901 VGND VPWR sky130_fd_sc_hd__tapvpwrvgnd_1
XTAP_934 VGND VPWR sky130_fd_sc_hd__tapvpwrvgnd_1
XTAP_923 VGND VPWR sky130_fd_sc_hd__tapvpwrvgnd_1
XTAP_912 VGND VPWR sky130_fd_sc_hd__tapvpwrvgnd_1
X_5111_ _2056_ VGND VGND VPWR VPWR _0432_ sky130_fd_sc_hd__clkbuf_1
X_6091_ net665 _2512_ _2587_ VGND VGND VPWR VPWR _2595_ sky130_fd_sc_hd__mux2_1
XTAP_978 VGND VPWR sky130_fd_sc_hd__tapvpwrvgnd_1
XTAP_956 VGND VPWR sky130_fd_sc_hd__tapvpwrvgnd_1
XTAP_967 VGND VPWR sky130_fd_sc_hd__tapvpwrvgnd_1
XTAP_945 VGND VPWR sky130_fd_sc_hd__tapvpwrvgnd_1
XTAP_989 VGND VPWR sky130_fd_sc_hd__tapvpwrvgnd_1
X_5042_ net865 _2018_ _1989_ VGND VGND VPWR VPWR _2019_ sky130_fd_sc_hd__mux2_1
X_8801_ clknet_leaf_1_clk _0890_ VGND VGND VPWR VPWR u_input_buffer.fifo_mem\[13\]\[7\]
+ sky130_fd_sc_hd__dfxtp_1
X_6993_ net807 _3086_ _3088_ VGND VGND VPWR VPWR _3241_ sky130_fd_sc_hd__o21a_1
X_5944_ _1420_ VGND VGND VPWR VPWR _2512_ sky130_fd_sc_hd__buf_4
X_8732_ clknet_leaf_111_clk _0821_ VGND VGND VPWR VPWR u_input_buffer.fifo_mem\[17\]\[2\]
+ sky130_fd_sc_hd__dfxtp_1
X_8663_ clknet_leaf_85_clk _0752_ VGND VGND VPWR VPWR u_input_buffer.fifo_mem\[22\]\[13\]
+ sky130_fd_sc_hd__dfxtp_1
X_5875_ net479 _2264_ _2460_ VGND VGND VPWR VPWR _2472_ sky130_fd_sc_hd__mux2_1
X_4826_ _1895_ VGND VGND VPWR VPWR _0308_ sky130_fd_sc_hd__clkbuf_1
X_7614_ net27 u_register_bank.threshold_cfg\[23\] _3759_ VGND VGND VPWR VPWR _3763_
+ sky130_fd_sc_hd__mux2_1
X_8594_ clknet_leaf_69_clk _0683_ VGND VGND VPWR VPWR u_input_buffer.fifo_mem\[26\]\[8\]
+ sky130_fd_sc_hd__dfxtp_1
XFILLER_0_63_617 VGND VGND VPWR VPWR sky130_fd_sc_hd__decap_8
XFILLER_0_47_179 VGND VGND VPWR VPWR sky130_fd_sc_hd__fill_1
X_7545_ net27 u_register_bank.window_cfg\[23\] _3722_ VGND VGND VPWR VPWR _3726_ sky130_fd_sc_hd__mux2_1
XFILLER_0_62_116 VGND VGND VPWR VPWR sky130_fd_sc_hd__decap_4
X_4757_ net1240 _1708_ _1855_ VGND VGND VPWR VPWR _1858_ sky130_fd_sc_hd__mux2_1
X_7476_ _3687_ VGND VGND VPWR VPWR _1166_ sky130_fd_sc_hd__clkbuf_1
X_4688_ _1820_ VGND VGND VPWR VPWR _0245_ sky130_fd_sc_hd__clkbuf_1
XFILLER_0_113_262 VGND VGND VPWR VPWR sky130_fd_sc_hd__fill_1
X_6427_ net609 _1396_ _2771_ VGND VGND VPWR VPWR _2775_ sky130_fd_sc_hd__mux2_1
X_9215_ net169 _1302_ net201 VGND VGND VPWR VPWR u_register_bank.sensor_enable\[16\]
+ sky130_fd_sc_hd__dfrtp_1
XFILLER_0_31_569 VGND VGND VPWR VPWR sky130_fd_sc_hd__fill_2
X_6358_ _2738_ VGND VGND VPWR VPWR _0997_ sky130_fd_sc_hd__clkbuf_1
XFILLER_0_101_435 VGND VGND VPWR VPWR sky130_fd_sc_hd__fill_2
X_9146_ net176 _1234_ net208 VGND VGND VPWR VPWR u_register_bank.threshold_cfg\[28\]
+ sky130_fd_sc_hd__dfrtp_1
XFILLER_0_11_260 VGND VGND VPWR VPWR sky130_fd_sc_hd__decap_6
X_5309_ net869 _2010_ _2150_ VGND VGND VPWR VPWR _2162_ sky130_fd_sc_hd__mux2_1
X_9077_ clknet_leaf_49_clk _1165_ VGND VGND VPWR VPWR u_input_buffer.fifo_mem\[63\]\[7\]
+ sky130_fd_sc_hd__dfxtp_1
X_6289_ _2701_ VGND VGND VPWR VPWR _0965_ sky130_fd_sc_hd__clkbuf_1
X_8028_ clknet_leaf_21_clk _0117_ VGND VGND VPWR VPWR u_input_buffer.fifo_mem\[61\]\[2\]
+ sky130_fd_sc_hd__dfxtp_1
XPHY_200 VGND VGND VPWR VPWR sky130_fd_sc_hd__decap_3
XPHY_222 VGND VGND VPWR VPWR sky130_fd_sc_hd__decap_3
XPHY_211 VGND VGND VPWR VPWR sky130_fd_sc_hd__decap_3
XFILLER_0_66_455 VGND VGND VPWR VPWR sky130_fd_sc_hd__decap_3
XFILLER_0_39_669 VGND VGND VPWR VPWR sky130_fd_sc_hd__decap_3
XFILLER_0_30_29 VGND VGND VPWR VPWR sky130_fd_sc_hd__decap_4
Xhold4 u_sample_counter.sample_count\[31\] VGND VGND VPWR VPWR net216 sky130_fd_sc_hd__dlygate4sd3_1
XFILLER_0_89_569 VGND VGND VPWR VPWR sky130_fd_sc_hd__fill_2
X_3990_ net376 net58 _1345_ VGND VGND VPWR VPWR _1346_ sky130_fd_sc_hd__mux2_1
XFILLER_0_84_241 VGND VGND VPWR VPWR sky130_fd_sc_hd__decap_8
X_5660_ net1038 _2254_ _2352_ VGND VGND VPWR VPWR _2358_ sky130_fd_sc_hd__mux2_1
XFILLER_0_115_505 VGND VGND VPWR VPWR sky130_fd_sc_hd__fill_2
X_4611_ _1777_ VGND VGND VPWR VPWR _1778_ sky130_fd_sc_hd__buf_4
X_5591_ net700 _2254_ _2315_ VGND VGND VPWR VPWR _2321_ sky130_fd_sc_hd__mux2_1
XFILLER_0_4_213 VGND VGND VPWR VPWR sky130_fd_sc_hd__fill_1
XFILLER_0_25_341 VGND VGND VPWR VPWR sky130_fd_sc_hd__fill_1
XFILLER_0_13_503 VGND VGND VPWR VPWR sky130_fd_sc_hd__fill_1
X_7330_ u_input_buffer.fifo_mem\[7\]\[13\] _3024_ _3026_ u_input_buffer.fifo_mem\[22\]\[13\]
+ _3568_ VGND VGND VPWR VPWR _3569_ sky130_fd_sc_hd__a221o_1
XFILLER_0_25_363 VGND VGND VPWR VPWR sky130_fd_sc_hd__decap_8
X_4542_ _1385_ net1010 _1738_ VGND VGND VPWR VPWR _1740_ sky130_fd_sc_hd__mux2_1
XFILLER_0_53_683 VGND VGND VPWR VPWR sky130_fd_sc_hd__decap_3
Xhold404 u_input_buffer.fifo_mem\[20\]\[2\] VGND VGND VPWR VPWR net616 sky130_fd_sc_hd__dlygate4sd3_1
Xhold415 u_input_buffer.fifo_mem\[27\]\[5\] VGND VGND VPWR VPWR net627 sky130_fd_sc_hd__dlygate4sd3_1
Xhold426 u_input_buffer.fifo_mem\[58\]\[8\] VGND VGND VPWR VPWR net638 sky130_fd_sc_hd__dlygate4sd3_1
X_7261_ u_input_buffer.fifo_mem\[26\]\[11\] _3065_ _3067_ u_input_buffer.fifo_mem\[62\]\[11\]
+ _3501_ VGND VGND VPWR VPWR _3502_ sky130_fd_sc_hd__a221o_1
X_4473_ u_input_buffer.fifo_mem\[59\]\[10\] _1622_ _1682_ VGND VGND VPWR VPWR _1694_
+ sky130_fd_sc_hd__mux2_1
Xhold448 u_input_buffer.fifo_mem\[11\]\[4\] VGND VGND VPWR VPWR net660 sky130_fd_sc_hd__dlygate4sd3_1
X_9000_ clknet_leaf_103_clk _1089_ VGND VGND VPWR VPWR u_input_buffer.fifo_mem\[1\]\[14\]
+ sky130_fd_sc_hd__dfxtp_1
Xhold459 u_input_buffer.fifo_mem\[7\]\[15\] VGND VGND VPWR VPWR net671 sky130_fd_sc_hd__dlygate4sd3_1
X_6212_ net835 _2528_ _2643_ VGND VGND VPWR VPWR _2660_ sky130_fd_sc_hd__mux2_1
Xmax_cap167 _3735_ VGND VGND VPWR VPWR net167 sky130_fd_sc_hd__clkbuf_2
Xhold437 u_input_buffer.fifo_mem\[44\]\[12\] VGND VGND VPWR VPWR net649 sky130_fd_sc_hd__dlygate4sd3_1
XFILLER_0_96_77 VGND VGND VPWR VPWR sky130_fd_sc_hd__decap_6
XFILLER_0_0_441 VGND VGND VPWR VPWR sky130_fd_sc_hd__decap_6
X_7192_ u_input_buffer.fifo_mem\[37\]\[10\] _2922_ _2925_ u_input_buffer.fifo_mem\[9\]\[10\]
+ VGND VGND VPWR VPWR _3434_ sky130_fd_sc_hd__a22o_1
X_6143_ _1632_ net1087 _2606_ VGND VGND VPWR VPWR _2623_ sky130_fd_sc_hd__mux2_1
XTAP_731 VGND VPWR sky130_fd_sc_hd__tapvpwrvgnd_1
XTAP_720 VGND VPWR sky130_fd_sc_hd__tapvpwrvgnd_1
XTAP_742 VGND VPWR sky130_fd_sc_hd__tapvpwrvgnd_1
Xhold1104 u_input_buffer.fifo_mem\[49\]\[6\] VGND VGND VPWR VPWR net1316 sky130_fd_sc_hd__dlygate4sd3_1
XFILLER_0_29_93 VGND VGND VPWR VPWR sky130_fd_sc_hd__fill_1
XTAP_753 VGND VPWR sky130_fd_sc_hd__tapvpwrvgnd_1
XTAP_764 VGND VPWR sky130_fd_sc_hd__tapvpwrvgnd_1
XTAP_775 VGND VPWR sky130_fd_sc_hd__tapvpwrvgnd_1
XTAP_786 VGND VPWR sky130_fd_sc_hd__tapvpwrvgnd_1
X_6074_ _2585_ VGND VGND VPWR VPWR _0866_ sky130_fd_sc_hd__clkbuf_1
X_5025_ _2007_ VGND VGND VPWR VPWR _0395_ sky130_fd_sc_hd__clkbuf_1
XTAP_797 VGND VPWR sky130_fd_sc_hd__tapvpwrvgnd_1
X_6976_ u_input_buffer.fifo_mem\[31\]\[4\] _3017_ _3020_ u_input_buffer.fifo_mem\[38\]\[4\]
+ VGND VGND VPWR VPWR _3224_ sky130_fd_sc_hd__a22o_1
X_8715_ clknet_leaf_25_clk _0804_ VGND VGND VPWR VPWR u_input_buffer.fifo_mem\[18\]\[1\]
+ sky130_fd_sc_hd__dfxtp_1
X_5927_ net1016 _2500_ _2498_ VGND VGND VPWR VPWR _2501_ sky130_fd_sc_hd__mux2_1
XFILLER_0_0_50 VGND VGND VPWR VPWR sky130_fd_sc_hd__fill_2
X_5858_ _2463_ VGND VGND VPWR VPWR _0772_ sky130_fd_sc_hd__clkbuf_1
X_8646_ clknet_leaf_91_clk _0735_ VGND VGND VPWR VPWR u_input_buffer.fifo_mem\[23\]\[12\]
+ sky130_fd_sc_hd__dfxtp_1
X_5789_ net1040 _2246_ _2425_ VGND VGND VPWR VPWR _2427_ sky130_fd_sc_hd__mux2_1
X_8577_ clknet_leaf_45_clk _0666_ VGND VGND VPWR VPWR u_input_buffer.fifo_mem\[27\]\[7\]
+ sky130_fd_sc_hd__dfxtp_1
X_4809_ _1885_ VGND VGND VPWR VPWR _0301_ sky130_fd_sc_hd__clkbuf_1
XFILLER_0_16_330 VGND VGND VPWR VPWR sky130_fd_sc_hd__decap_4
XFILLER_0_16_374 VGND VGND VPWR VPWR sky130_fd_sc_hd__fill_1
X_7528_ net18 u_register_bank.window_cfg\[15\] _3711_ VGND VGND VPWR VPWR _3717_ sky130_fd_sc_hd__mux2_1
X_7459_ net508 _1376_ _3678_ VGND VGND VPWR VPWR _3679_ sky130_fd_sc_hd__mux2_1
XFILLER_0_101_254 VGND VGND VPWR VPWR sky130_fd_sc_hd__decap_3
Xhold960 u_input_buffer.fifo_mem\[45\]\[4\] VGND VGND VPWR VPWR net1172 sky130_fd_sc_hd__dlygate4sd3_1
Xhold971 u_input_buffer.fifo_mem\[62\]\[12\] VGND VGND VPWR VPWR net1183 sky130_fd_sc_hd__dlygate4sd3_1
Xhold982 u_input_buffer.fifo_mem\[5\]\[3\] VGND VGND VPWR VPWR net1194 sky130_fd_sc_hd__dlygate4sd3_1
Xhold993 u_input_buffer.fifo_mem\[18\]\[8\] VGND VGND VPWR VPWR net1205 sky130_fd_sc_hd__dlygate4sd3_1
X_9129_ net170 _1217_ net202 VGND VGND VPWR VPWR u_analytics_engine.threshold\[11\]
+ sky130_fd_sc_hd__dfrtp_2
XFILLER_0_98_333 VGND VGND VPWR VPWR sky130_fd_sc_hd__fill_2
XFILLER_0_86_539 VGND VGND VPWR VPWR sky130_fd_sc_hd__fill_2
XFILLER_0_86_528 VGND VGND VPWR VPWR sky130_fd_sc_hd__decap_4
XFILLER_0_27_617 VGND VGND VPWR VPWR sky130_fd_sc_hd__decap_4
XFILLER_0_26_105 VGND VGND VPWR VPWR sky130_fd_sc_hd__fill_1
XFILLER_0_41_108 VGND VGND VPWR VPWR sky130_fd_sc_hd__fill_1
XFILLER_0_112_519 VGND VGND VPWR VPWR sky130_fd_sc_hd__fill_2
XFILLER_0_50_675 VGND VGND VPWR VPWR sky130_fd_sc_hd__fill_1
XFILLER_0_106_53 VPWR VGND VPWR VGND sky130_ef_sc_hd__decap_12
X_6830_ u_input_buffer.fifo_mem\[63\]\[0\] _2887_ _3076_ u_input_buffer.fifo_mem\[55\]\[0\]
+ _3081_ VGND VGND VPWR VPWR _3082_ sky130_fd_sc_hd__a221o_1
XFILLER_0_106_97 VGND VGND VPWR VPWR sky130_fd_sc_hd__fill_2
XFILLER_0_15_51 VGND VGND VPWR VPWR sky130_fd_sc_hd__decap_4
X_6761_ _3012_ VGND VGND VPWR VPWR _3013_ sky130_fd_sc_hd__clkbuf_4
X_3973_ u_sensor_interface.sensor_array\[2\]\[12\] net84 _1334_ VGND VGND VPWR VPWR
+ _1337_ sky130_fd_sc_hd__mux2_1
X_8500_ clknet_leaf_13_clk _0589_ VGND VGND VPWR VPWR u_input_buffer.fifo_mem\[32\]\[10\]
+ sky130_fd_sc_hd__dfxtp_1
X_5712_ _1630_ net1034 _2369_ VGND VGND VPWR VPWR _2385_ sky130_fd_sc_hd__mux2_1
X_6692_ _2907_ _2930_ VGND VGND VPWR VPWR _2944_ sky130_fd_sc_hd__nor2_4
XFILLER_0_115_302 VGND VGND VPWR VPWR sky130_fd_sc_hd__decap_6
X_8431_ clknet_leaf_32_clk _0520_ VGND VGND VPWR VPWR u_input_buffer.fifo_mem\[36\]\[5\]
+ sky130_fd_sc_hd__dfxtp_1
XFILLER_0_72_233 VGND VGND VPWR VPWR sky130_fd_sc_hd__fill_1
X_5643_ _2348_ VGND VGND VPWR VPWR _0672_ sky130_fd_sc_hd__clkbuf_1
XFILLER_0_33_609 VGND VGND VPWR VPWR sky130_fd_sc_hd__decap_6
X_8362_ clknet_leaf_50_clk _0451_ VGND VGND VPWR VPWR u_input_buffer.fifo_mem\[40\]\[0\]
+ sky130_fd_sc_hd__dfxtp_1
XFILLER_0_72_277 VGND VGND VPWR VPWR sky130_fd_sc_hd__fill_2
X_5574_ _2311_ VGND VGND VPWR VPWR _0640_ sky130_fd_sc_hd__clkbuf_1
XFILLER_0_31_72 VGND VGND VPWR VPWR sky130_fd_sc_hd__fill_1
XFILLER_0_115_368 VGND VGND VPWR VPWR sky130_fd_sc_hd__decap_6
Xhold201 u_input_buffer.fifo_mem\[43\]\[14\] VGND VGND VPWR VPWR net413 sky130_fd_sc_hd__dlygate4sd3_1
X_4525_ _1450_ VGND VGND VPWR VPWR _1728_ sky130_fd_sc_hd__buf_4
X_7313_ u_input_buffer.fifo_mem\[29\]\[13\] _2938_ _2940_ u_input_buffer.fifo_mem\[13\]\[13\]
+ _3551_ VGND VGND VPWR VPWR _3552_ sky130_fd_sc_hd__a221o_1
Xhold212 u_input_buffer.fifo_mem\[40\]\[0\] VGND VGND VPWR VPWR net424 sky130_fd_sc_hd__dlygate4sd3_1
Xhold234 u_input_buffer.fifo_mem\[54\]\[7\] VGND VGND VPWR VPWR net446 sky130_fd_sc_hd__dlygate4sd3_1
Xhold223 u_input_buffer.fifo_mem\[3\]\[5\] VGND VGND VPWR VPWR net435 sky130_fd_sc_hd__dlygate4sd3_1
XFILLER_0_13_366 VGND VGND VPWR VPWR sky130_fd_sc_hd__decap_3
X_8293_ clknet_leaf_1_clk _0382_ VGND VGND VPWR VPWR u_input_buffer.fifo_mem\[45\]\[11\]
+ sky130_fd_sc_hd__dfxtp_1
XFILLER_0_40_141 VGND VGND VPWR VPWR sky130_fd_sc_hd__fill_1
Xhold245 u_input_buffer.fifo_mem\[35\]\[6\] VGND VGND VPWR VPWR net457 sky130_fd_sc_hd__dlygate4sd3_1
Xhold278 u_input_buffer.fifo_mem\[4\]\[2\] VGND VGND VPWR VPWR net490 sky130_fd_sc_hd__dlygate4sd3_1
X_4456_ _1685_ VGND VGND VPWR VPWR _0148_ sky130_fd_sc_hd__clkbuf_1
Xhold256 u_input_buffer.fifo_mem\[23\]\[11\] VGND VGND VPWR VPWR net468 sky130_fd_sc_hd__dlygate4sd3_1
X_7244_ u_input_buffer.fifo_mem\[51\]\[11\] _2989_ _2992_ u_input_buffer.fifo_mem\[11\]\[11\]
+ _3484_ VGND VGND VPWR VPWR _3485_ sky130_fd_sc_hd__a221o_1
Xhold267 u_input_buffer.fifo_mem\[20\]\[10\] VGND VGND VPWR VPWR net479 sky130_fd_sc_hd__dlygate4sd3_1
XFILLER_0_111_596 VPWR VGND VPWR VGND sky130_ef_sc_hd__decap_12
X_7175_ u_input_buffer.fifo_mem\[52\]\[9\] _3039_ _3041_ u_input_buffer.fifo_mem\[56\]\[9\]
+ VGND VGND VPWR VPWR _3418_ sky130_fd_sc_hd__a22o_1
X_4387_ _1403_ net1165 _1641_ VGND VGND VPWR VPWR _1646_ sky130_fd_sc_hd__mux2_1
Xhold289 u_input_buffer.fifo_mem\[15\]\[15\] VGND VGND VPWR VPWR net501 sky130_fd_sc_hd__dlygate4sd3_1
XTAP_550 VGND VPWR sky130_fd_sc_hd__tapvpwrvgnd_1
XTAP_561 VGND VPWR sky130_fd_sc_hd__tapvpwrvgnd_1
X_6126_ _2614_ VGND VGND VPWR VPWR _0889_ sky130_fd_sc_hd__clkbuf_1
XTAP_572 VGND VPWR sky130_fd_sc_hd__tapvpwrvgnd_1
XTAP_583 VGND VPWR sky130_fd_sc_hd__tapvpwrvgnd_1
XTAP_594 VGND VPWR sky130_fd_sc_hd__tapvpwrvgnd_1
X_6057_ net387 _2512_ _2569_ VGND VGND VPWR VPWR _2577_ sky130_fd_sc_hd__mux2_1
X_5008_ _1396_ VGND VGND VPWR VPWR _1996_ sky130_fd_sc_hd__buf_4
X_6959_ u_input_buffer.fifo_mem\[41\]\[4\] _2919_ _2921_ u_input_buffer.fifo_mem\[45\]\[4\]
+ _3206_ VGND VGND VPWR VPWR _3207_ sky130_fd_sc_hd__a221o_1
XFILLER_0_63_222 VGND VGND VPWR VPWR sky130_fd_sc_hd__fill_2
X_8629_ clknet_leaf_80_clk _0718_ VGND VGND VPWR VPWR u_input_buffer.fifo_mem\[24\]\[11\]
+ sky130_fd_sc_hd__dfxtp_1
XFILLER_0_91_575 VGND VGND VPWR VPWR sky130_fd_sc_hd__decap_3
XFILLER_0_106_379 VGND VGND VPWR VPWR sky130_fd_sc_hd__decap_4
XFILLER_0_102_530 VGND VGND VPWR VPWR sky130_fd_sc_hd__fill_2
Xhold790 u_input_buffer.fifo_mem\[51\]\[5\] VGND VGND VPWR VPWR net1002 sky130_fd_sc_hd__dlygate4sd3_1
XFILLER_0_98_130 VGND VGND VPWR VPWR sky130_fd_sc_hd__fill_2
XFILLER_0_54_211 VGND VGND VPWR VPWR sky130_fd_sc_hd__fill_2
XFILLER_0_82_531 VGND VGND VPWR VPWR sky130_fd_sc_hd__fill_1
XFILLER_0_54_222 VGND VGND VPWR VPWR sky130_fd_sc_hd__fill_1
XFILLER_0_112_316 VGND VGND VPWR VPWR sky130_fd_sc_hd__decap_3
X_5290_ _2152_ VGND VGND VPWR VPWR _0515_ sky130_fd_sc_hd__clkbuf_1
XFILLER_0_2_569 VPWR VGND VPWR VGND sky130_ef_sc_hd__decap_12
XFILLER_0_22_185 VGND VGND VPWR VPWR sky130_fd_sc_hd__fill_2
X_4310_ u_input_buffer.wr_ptr\[4\] VGND VGND VPWR VPWR _1589_ sky130_fd_sc_hd__inv_2
X_4241_ _1525_ _1526_ VGND VGND VPWR VPWR _0092_ sky130_fd_sc_hd__nor2_1
X_4172_ _1479_ _1480_ VGND VGND VPWR VPWR _1481_ sky130_fd_sc_hd__and2_1
X_8980_ clknet_leaf_13_clk _1069_ VGND VGND VPWR VPWR u_input_buffer.fifo_mem\[2\]\[10\]
+ sky130_fd_sc_hd__dfxtp_1
X_7931_ clknet_leaf_27_clk _0021_ VGND VGND VPWR VPWR u_sensor_interface.sensor_array\[1\]\[3\]
+ sky130_fd_sc_hd__dfxtp_1
XFILLER_0_89_185 VGND VGND VPWR VPWR sky130_fd_sc_hd__fill_2
X_7862_ net27 u_register_bank.sensor_enable\[23\] _3927_ VGND VGND VPWR VPWR _3931_
+ sky130_fd_sc_hd__mux2_1
X_7793_ _3894_ VGND VGND VPWR VPWR _1276_ sky130_fd_sc_hd__clkbuf_1
X_6813_ _2906_ _2959_ VGND VGND VPWR VPWR _3065_ sky130_fd_sc_hd__nor2_4
X_3956_ u_sensor_interface.sensor_array\[2\]\[4\] net75 _1323_ VGND VGND VPWR VPWR
+ _1328_ sky130_fd_sc_hd__mux2_1
X_6744_ _2930_ _2949_ VGND VGND VPWR VPWR _2996_ sky130_fd_sc_hd__nor2_4
XFILLER_0_45_200 VGND VGND VPWR VPWR sky130_fd_sc_hd__decap_3
XFILLER_0_85_391 VGND VGND VPWR VPWR sky130_fd_sc_hd__fill_1
X_6675_ u_input_buffer.fifo_mem\[37\]\[0\] _2923_ _2926_ u_input_buffer.fifo_mem\[9\]\[0\]
+ VGND VGND VPWR VPWR _2927_ sky130_fd_sc_hd__a22o_1
XFILLER_0_45_222 VGND VGND VPWR VPWR sky130_fd_sc_hd__fill_2
XFILLER_0_115_132 VGND VGND VPWR VPWR sky130_fd_sc_hd__decap_8
X_5626_ net627 _2254_ _2334_ VGND VGND VPWR VPWR _2340_ sky130_fd_sc_hd__mux2_1
X_8414_ clknet_leaf_21_clk _0503_ VGND VGND VPWR VPWR u_input_buffer.fifo_mem\[37\]\[4\]
+ sky130_fd_sc_hd__dfxtp_1
XFILLER_0_45_266 VGND VGND VPWR VPWR sky130_fd_sc_hd__fill_1
XFILLER_0_14_631 VPWR VGND VPWR VGND sky130_ef_sc_hd__decap_12
XFILLER_0_13_130 VGND VGND VPWR VPWR sky130_fd_sc_hd__fill_2
X_5557_ _1409_ net1230 _2297_ VGND VGND VPWR VPWR _2303_ sky130_fd_sc_hd__mux2_1
X_8345_ clknet_leaf_12_clk _0434_ VGND VGND VPWR VPWR u_input_buffer.fifo_mem\[42\]\[15\]
+ sky130_fd_sc_hd__dfxtp_1
X_4508_ net931 _1716_ _1704_ VGND VGND VPWR VPWR _1717_ sky130_fd_sc_hd__mux2_1
X_5488_ _1432_ VGND VGND VPWR VPWR _2262_ sky130_fd_sc_hd__clkbuf_4
X_8276_ clknet_leaf_101_clk _0365_ VGND VGND VPWR VPWR u_input_buffer.fifo_mem\[46\]\[10\]
+ sky130_fd_sc_hd__dfxtp_1
X_4439_ net1051 _1626_ _1660_ VGND VGND VPWR VPWR _1674_ sky130_fd_sc_hd__mux2_1
X_7227_ net775 _3085_ _3087_ VGND VGND VPWR VPWR _3469_ sky130_fd_sc_hd__o21a_1
XFILLER_0_6_93 VGND VGND VPWR VPWR sky130_fd_sc_hd__fill_1
X_7158_ u_input_buffer.fifo_mem\[1\]\[9\] _2932_ _3398_ _3400_ VGND VGND VPWR VPWR
+ _3401_ sky130_fd_sc_hd__a211o_1
X_7089_ _3327_ _3329_ _3331_ _3333_ VGND VGND VPWR VPWR _3334_ sky130_fd_sc_hd__or4_1
XTAP_391 VGND VPWR sky130_fd_sc_hd__tapvpwrvgnd_1
XTAP_380 VGND VPWR sky130_fd_sc_hd__tapvpwrvgnd_1
X_6109_ u_input_buffer.wr_ptr\[5\] _1589_ net185 VGND VGND VPWR VPWR _2604_ sky130_fd_sc_hd__and3b_1
XTAP_1513 VGND VPWR sky130_fd_sc_hd__tapvpwrvgnd_1
XTAP_1524 VGND VPWR sky130_fd_sc_hd__tapvpwrvgnd_1
XTAP_1502 VGND VPWR sky130_fd_sc_hd__tapvpwrvgnd_1
XPHY_20 VGND VGND VPWR VPWR sky130_fd_sc_hd__decap_3
XPHY_31 VGND VGND VPWR VPWR sky130_fd_sc_hd__decap_3
XTAP_1557 VGND VPWR sky130_fd_sc_hd__tapvpwrvgnd_1
XTAP_1546 VGND VPWR sky130_fd_sc_hd__tapvpwrvgnd_1
XTAP_1535 VGND VPWR sky130_fd_sc_hd__tapvpwrvgnd_1
XFILLER_0_96_678 VGND VGND VPWR VPWR sky130_fd_sc_hd__decap_4
XPHY_42 VGND VGND VPWR VPWR sky130_fd_sc_hd__decap_3
XPHY_53 VGND VGND VPWR VPWR sky130_fd_sc_hd__decap_3
XPHY_64 VGND VGND VPWR VPWR sky130_fd_sc_hd__decap_3
XTAP_1579 VGND VPWR sky130_fd_sc_hd__tapvpwrvgnd_1
XTAP_1568 VGND VPWR sky130_fd_sc_hd__tapvpwrvgnd_1
XPHY_75 VGND VGND VPWR VPWR sky130_fd_sc_hd__decap_3
XPHY_86 VGND VGND VPWR VPWR sky130_fd_sc_hd__decap_3
XPHY_97 VGND VGND VPWR VPWR sky130_fd_sc_hd__decap_3
XFILLER_0_24_406 VGND VGND VPWR VPWR sky130_fd_sc_hd__fill_2
XFILLER_0_32_461 VGND VGND VPWR VPWR sky130_fd_sc_hd__decap_3
XFILLER_0_102_371 VGND VGND VPWR VPWR sky130_fd_sc_hd__fill_1
XFILLER_0_20_645 VGND VGND VPWR VPWR sky130_fd_sc_hd__decap_4
XFILLER_0_2_29 VPWR VGND VPWR VGND sky130_ef_sc_hd__decap_12
XFILLER_0_87_612 VGND VGND VPWR VPWR sky130_fd_sc_hd__decap_4
X_4790_ net545 _1706_ _1874_ VGND VGND VPWR VPWR _1876_ sky130_fd_sc_hd__mux2_1
XFILLER_0_67_391 VGND VGND VPWR VPWR sky130_fd_sc_hd__fill_1
XFILLER_0_7_617 VPWR VGND VPWR VGND sky130_ef_sc_hd__decap_12
XANTENNA_29 net71 VGND VGND VPWR VPWR sky130_fd_sc_hd__diode_2
XANTENNA_18 net7 VGND VGND VPWR VPWR sky130_fd_sc_hd__diode_2
XFILLER_0_12_41 VPWR VGND VPWR VGND sky130_ef_sc_hd__decap_12
XFILLER_0_6_149 VGND VGND VPWR VPWR sky130_fd_sc_hd__decap_4
X_6460_ _2792_ VGND VGND VPWR VPWR _1045_ sky130_fd_sc_hd__clkbuf_1
XFILLER_0_12_85 VPWR VGND VPWR VGND sky130_ef_sc_hd__decap_12
XFILLER_0_27_299 VGND VGND VPWR VPWR sky130_fd_sc_hd__decap_4
XFILLER_0_70_589 VPWR VGND VPWR VGND sky130_ef_sc_hd__decap_12
X_5411_ _1439_ net1212 _2204_ VGND VGND VPWR VPWR _2216_ sky130_fd_sc_hd__mux2_1
X_6391_ _1606_ net1157 _2753_ VGND VGND VPWR VPWR _2756_ sky130_fd_sc_hd__mux2_1
Xoutput114 net114 VGND VGND VPWR VPWR cfg_rdata[0] sky130_fd_sc_hd__clkbuf_4
Xoutput125 net125 VGND VGND VPWR VPWR cfg_rdata[1] sky130_fd_sc_hd__clkbuf_4
XFILLER_0_112_135 VGND VGND VPWR VPWR sky130_fd_sc_hd__fill_2
X_5342_ _2179_ VGND VGND VPWR VPWR _0540_ sky130_fd_sc_hd__clkbuf_1
X_8130_ clknet_leaf_41_clk _0219_ VGND VGND VPWR VPWR u_input_buffer.fifo_mem\[55\]\[8\]
+ sky130_fd_sc_hd__dfxtp_1
XFILLER_0_11_612 VGND VGND VPWR VPWR sky130_fd_sc_hd__decap_4
X_8061_ clknet_leaf_70_clk _0150_ VGND VGND VPWR VPWR u_input_buffer.fifo_mem\[59\]\[3\]
+ sky130_fd_sc_hd__dfxtp_1
Xoutput158 net158 VGND VGND VPWR VPWR processed_data_out[4] sky130_fd_sc_hd__clkbuf_4
XFILLER_0_10_144 VGND VGND VPWR VPWR sky130_fd_sc_hd__fill_1
Xoutput147 net147 VGND VGND VPWR VPWR irq_alert sky130_fd_sc_hd__clkbuf_4
Xoutput136 net136 VGND VGND VPWR VPWR cfg_rdata[2] sky130_fd_sc_hd__clkbuf_4
X_5273_ _1433_ net1047 _2133_ VGND VGND VPWR VPWR _2143_ sky130_fd_sc_hd__mux2_1
X_7012_ _3243_ _3245_ _3249_ _3258_ VGND VGND VPWR VPWR _3259_ sky130_fd_sc_hd__or4_4
X_4224_ _1513_ _1514_ VGND VGND VPWR VPWR _1515_ sky130_fd_sc_hd__and2b_1
X_4155_ u_input_buffer.data_in\[15\] VGND VGND VPWR VPWR _1468_ sky130_fd_sc_hd__clkbuf_4
XFILLER_0_97_409 VGND VGND VPWR VPWR sky130_fd_sc_hd__decap_8
X_4086_ _1408_ VGND VGND VPWR VPWR _1409_ sky130_fd_sc_hd__buf_2
X_8963_ clknet_leaf_70_clk _1052_ VGND VGND VPWR VPWR u_input_buffer.fifo_mem\[3\]\[9\]
+ sky130_fd_sc_hd__dfxtp_1
X_7914_ clknet_leaf_58_clk _0004_ VGND VGND VPWR VPWR u_sensor_interface.sensor_array\[2\]\[2\]
+ sky130_fd_sc_hd__dfxtp_2
X_8894_ clknet_leaf_54_clk _0983_ VGND VGND VPWR VPWR u_input_buffer.fifo_mem\[7\]\[4\]
+ sky130_fd_sc_hd__dfxtp_1
XFILLER_0_78_656 VGND VGND VPWR VPWR sky130_fd_sc_hd__fill_2
XFILLER_0_78_678 VGND VGND VPWR VPWR sky130_fd_sc_hd__decap_8
XFILLER_0_65_306 VGND VGND VPWR VPWR sky130_fd_sc_hd__fill_2
X_7845_ net18 u_register_bank.sensor_enable\[15\] _3916_ VGND VGND VPWR VPWR _3922_
+ sky130_fd_sc_hd__mux2_1
X_4988_ _1983_ VGND VGND VPWR VPWR _0382_ sky130_fd_sc_hd__clkbuf_1
X_7776_ u_register_bank.window_cfg\[31\] _3698_ net167 u_register_bank.threshold_cfg\[31\]
+ _3884_ VGND VGND VPWR VPWR _3885_ sky130_fd_sc_hd__a221o_1
XFILLER_0_92_169 VGND VGND VPWR VPWR sky130_fd_sc_hd__fill_2
XFILLER_0_80_309 VGND VGND VPWR VPWR sky130_fd_sc_hd__fill_1
XFILLER_0_18_277 VGND VGND VPWR VPWR sky130_fd_sc_hd__decap_4
X_6727_ _2930_ _2978_ VGND VGND VPWR VPWR _2979_ sky130_fd_sc_hd__nor2_4
X_6658_ _2885_ _2882_ VGND VGND VPWR VPWR _2910_ sky130_fd_sc_hd__and2b_1
XFILLER_0_103_113 VGND VGND VPWR VPWR sky130_fd_sc_hd__fill_1
X_5609_ net767 _2272_ _2314_ VGND VGND VPWR VPWR _2330_ sky130_fd_sc_hd__mux2_1
X_8328_ clknet_leaf_96_clk _0417_ VGND VGND VPWR VPWR u_input_buffer.fifo_mem\[43\]\[14\]
+ sky130_fd_sc_hd__dfxtp_1
X_6589_ u_input_buffer.count\[6\] u_input_buffer.count\[5\] u_input_buffer.count\[4\]
+ _1593_ VGND VGND VPWR VPWR _2860_ sky130_fd_sc_hd__or4_4
XFILLER_0_111_190 VGND VGND VPWR VPWR sky130_fd_sc_hd__fill_2
X_8259_ clknet_leaf_64_clk _0348_ VGND VGND VPWR VPWR u_input_buffer.fifo_mem\[47\]\[9\]
+ sky130_fd_sc_hd__dfxtp_1
XFILLER_0_88_409 VGND VGND VPWR VPWR sky130_fd_sc_hd__fill_2
XTAP_1332 VGND VPWR sky130_fd_sc_hd__tapvpwrvgnd_1
XTAP_1321 VGND VPWR sky130_fd_sc_hd__tapvpwrvgnd_1
XTAP_1310 VGND VPWR sky130_fd_sc_hd__tapvpwrvgnd_1
XFILLER_0_69_667 VGND VGND VPWR VPWR sky130_fd_sc_hd__decap_4
XFILLER_0_96_497 VGND VGND VPWR VPWR sky130_fd_sc_hd__decap_4
XTAP_1354 VGND VPWR sky130_fd_sc_hd__tapvpwrvgnd_1
XTAP_1365 VGND VPWR sky130_fd_sc_hd__tapvpwrvgnd_1
XTAP_1343 VGND VPWR sky130_fd_sc_hd__tapvpwrvgnd_1
XFILLER_0_84_615 VGND VGND VPWR VPWR sky130_fd_sc_hd__fill_2
XTAP_1398 VGND VPWR sky130_fd_sc_hd__tapvpwrvgnd_1
XTAP_1387 VGND VPWR sky130_fd_sc_hd__tapvpwrvgnd_1
XTAP_1376 VGND VPWR sky130_fd_sc_hd__tapvpwrvgnd_1
XFILLER_0_64_350 VGND VGND VPWR VPWR sky130_fd_sc_hd__fill_1
XFILLER_0_37_575 VGND VGND VPWR VPWR sky130_fd_sc_hd__fill_1
XFILLER_0_52_512 VGND VGND VPWR VPWR sky130_fd_sc_hd__fill_2
Xinput16 cfg_wdata[13] VGND VGND VPWR VPWR net16 sky130_fd_sc_hd__dlymetal6s2s_1
XFILLER_0_3_108 VGND VGND VPWR VPWR sky130_fd_sc_hd__decap_4
Xinput27 cfg_wdata[23] VGND VGND VPWR VPWR net27 sky130_fd_sc_hd__buf_2
XFILLER_0_37_597 VGND VGND VPWR VPWR sky130_fd_sc_hd__decap_4
Xinput38 cfg_wdata[4] VGND VGND VPWR VPWR net38 sky130_fd_sc_hd__buf_2
Xinput49 sensor_data_in[12] VGND VGND VPWR VPWR net49 sky130_fd_sc_hd__clkbuf_1
XFILLER_0_24_269 VGND VGND VPWR VPWR sky130_fd_sc_hd__fill_2
XFILLER_0_59_122 VGND VGND VPWR VPWR sky130_fd_sc_hd__decap_4
X_5960_ net1152 _2522_ _2497_ VGND VGND VPWR VPWR _2523_ sky130_fd_sc_hd__mux2_1
X_4911_ _1942_ VGND VGND VPWR VPWR _0346_ sky130_fd_sc_hd__clkbuf_1
X_5891_ net1130 _2246_ _2479_ VGND VGND VPWR VPWR _2481_ sky130_fd_sc_hd__mux2_1
XFILLER_0_87_497 VGND VGND VPWR VPWR sky130_fd_sc_hd__decap_6
XFILLER_0_75_615 VGND VGND VPWR VPWR sky130_fd_sc_hd__fill_1
X_7630_ net36 u_register_bank.threshold_cfg\[31\] _3736_ VGND VGND VPWR VPWR _3771_
+ sky130_fd_sc_hd__mux2_1
XFILLER_0_114_53 VGND VGND VPWR VPWR sky130_fd_sc_hd__decap_8
XFILLER_0_74_147 VGND VGND VPWR VPWR sky130_fd_sc_hd__decap_4
X_4842_ _1903_ VGND VGND VPWR VPWR _0316_ sky130_fd_sc_hd__clkbuf_1
XFILLER_0_62_309 VGND VGND VPWR VPWR sky130_fd_sc_hd__fill_2
X_4773_ net297 _1724_ _1854_ VGND VGND VPWR VPWR _1866_ sky130_fd_sc_hd__mux2_1
X_7561_ net36 u_register_bank.window_cfg\[31\] _3699_ VGND VGND VPWR VPWR _3734_ sky130_fd_sc_hd__mux2_1
X_7492_ net2 net1 _3695_ VGND VGND VPWR VPWR _3696_ sky130_fd_sc_hd__nor3_4
XFILLER_0_99_55 VGND VGND VPWR VPWR sky130_fd_sc_hd__fill_1
X_6512_ _2819_ VGND VGND VPWR VPWR _1070_ sky130_fd_sc_hd__clkbuf_1
X_6443_ net778 _1444_ _2770_ VGND VGND VPWR VPWR _2783_ sky130_fd_sc_hd__mux2_1
XFILLER_0_3_653 VPWR VGND VPWR VGND sky130_ef_sc_hd__decap_12
XFILLER_0_113_499 VGND VGND VPWR VPWR sky130_fd_sc_hd__decap_4
XFILLER_0_101_617 VPWR VGND VPWR VGND sky130_ef_sc_hd__decap_12
XFILLER_0_23_291 VGND VGND VPWR VPWR sky130_fd_sc_hd__fill_2
X_9162_ net172 _1250_ VGND VGND VPWR VPWR net117 sky130_fd_sc_hd__dfxtp_2
X_6374_ _2746_ VGND VGND VPWR VPWR _1005_ sky130_fd_sc_hd__clkbuf_1
X_8113_ clknet_leaf_56_clk _0202_ VGND VGND VPWR VPWR u_input_buffer.fifo_mem\[56\]\[7\]
+ sky130_fd_sc_hd__dfxtp_1
X_5325_ net586 _1992_ _2169_ VGND VGND VPWR VPWR _2171_ sky130_fd_sc_hd__mux2_1
X_9093_ net181 _1181_ net210 VGND VGND VPWR VPWR u_register_bank.window_cfg\[7\] sky130_fd_sc_hd__dfrtp_1
X_8044_ clknet_leaf_44_clk _0133_ VGND VGND VPWR VPWR u_input_buffer.fifo_mem\[60\]\[2\]
+ sky130_fd_sc_hd__dfxtp_1
X_5256_ _2134_ VGND VGND VPWR VPWR _0499_ sky130_fd_sc_hd__clkbuf_1
X_4207_ _1503_ VGND VGND VPWR VPWR _0081_ sky130_fd_sc_hd__clkbuf_1
X_5187_ net808 _1988_ _2097_ VGND VGND VPWR VPWR _2098_ sky130_fd_sc_hd__mux2_1
X_4138_ _1453_ u_sensor_interface.sensor_array\[3\]\[12\] net113 VGND VGND VPWR VPWR
+ _1454_ sky130_fd_sc_hd__mux2_1
X_4069_ _1391_ _1394_ _0000_ VGND VGND VPWR VPWR _1395_ sky130_fd_sc_hd__mux2_1
X_8946_ clknet_leaf_14_clk _1035_ VGND VGND VPWR VPWR u_input_buffer.fifo_mem\[4\]\[8\]
+ sky130_fd_sc_hd__dfxtp_1
XFILLER_0_64_80 VGND VGND VPWR VPWR sky130_fd_sc_hd__fill_1
X_8877_ clknet_leaf_65_clk _0966_ VGND VGND VPWR VPWR u_input_buffer.fifo_mem\[8\]\[3\]
+ sky130_fd_sc_hd__dfxtp_1
XFILLER_0_66_615 VGND VGND VPWR VPWR sky130_fd_sc_hd__decap_4
X_7828_ net41 u_register_bank.sensor_enable\[7\] _3905_ VGND VGND VPWR VPWR _3913_
+ sky130_fd_sc_hd__mux2_1
XFILLER_0_19_542 VGND VGND VPWR VPWR sky130_fd_sc_hd__fill_1
X_7759_ u_register_bank.status_flags\[27\] _3849_ _3843_ u_register_bank.sensor_enable\[27\]
+ VGND VGND VPWR VPWR _3872_ sky130_fd_sc_hd__a22o_1
XFILLER_0_80_139 VGND VGND VPWR VPWR sky130_fd_sc_hd__fill_1
XFILLER_0_34_589 VGND VGND VPWR VPWR sky130_fd_sc_hd__decap_4
XFILLER_0_100_661 VGND VGND VPWR VPWR sky130_fd_sc_hd__decap_6
Xfanout182 net183 VGND VGND VPWR VPWR net182 sky130_fd_sc_hd__clkbuf_2
Xfanout171 net183 VGND VGND VPWR VPWR net171 sky130_fd_sc_hd__buf_2
Xfanout193 net194 VGND VGND VPWR VPWR net193 sky130_fd_sc_hd__buf_4
XTAP_1140 VGND VPWR sky130_fd_sc_hd__tapvpwrvgnd_1
XFILLER_0_56_114 VGND VGND VPWR VPWR sky130_fd_sc_hd__decap_4
XTAP_1173 VGND VPWR sky130_fd_sc_hd__tapvpwrvgnd_1
XTAP_1162 VGND VPWR sky130_fd_sc_hd__tapvpwrvgnd_1
XTAP_1151 VGND VPWR sky130_fd_sc_hd__tapvpwrvgnd_1
XTAP_1195 VGND VPWR sky130_fd_sc_hd__tapvpwrvgnd_1
XTAP_1184 VGND VPWR sky130_fd_sc_hd__tapvpwrvgnd_1
XFILLER_0_114_6 VPWR VGND VPWR VGND sky130_ef_sc_hd__decap_12
Xhold608 u_input_buffer.fifo_mem\[19\]\[7\] VGND VGND VPWR VPWR net820 sky130_fd_sc_hd__dlygate4sd3_1
XFILLER_0_12_217 VGND VGND VPWR VPWR sky130_fd_sc_hd__fill_1
XFILLER_0_110_414 VGND VGND VPWR VPWR sky130_fd_sc_hd__fill_2
XFILLER_0_12_239 VGND VGND VPWR VPWR sky130_fd_sc_hd__decap_3
Xhold619 u_input_buffer.fifo_mem\[45\]\[14\] VGND VGND VPWR VPWR net831 sky130_fd_sc_hd__dlygate4sd3_1
XFILLER_0_100_77 VGND VGND VPWR VPWR sky130_fd_sc_hd__decap_6
X_6090_ _2594_ VGND VGND VPWR VPWR _0873_ sky130_fd_sc_hd__clkbuf_1
XTAP_935 VGND VPWR sky130_fd_sc_hd__tapvpwrvgnd_1
XTAP_924 VGND VPWR sky130_fd_sc_hd__tapvpwrvgnd_1
XTAP_913 VGND VPWR sky130_fd_sc_hd__tapvpwrvgnd_1
XFILLER_0_0_678 VGND VGND VPWR VPWR sky130_fd_sc_hd__fill_2
X_5110_ net543 _2016_ _2041_ VGND VGND VPWR VPWR _2056_ sky130_fd_sc_hd__mux2_1
XTAP_902 VGND VPWR sky130_fd_sc_hd__tapvpwrvgnd_1
XTAP_957 VGND VPWR sky130_fd_sc_hd__tapvpwrvgnd_1
XTAP_968 VGND VPWR sky130_fd_sc_hd__tapvpwrvgnd_1
XTAP_946 VGND VPWR sky130_fd_sc_hd__tapvpwrvgnd_1
X_5041_ _1462_ VGND VGND VPWR VPWR _2018_ sky130_fd_sc_hd__clkbuf_4
XTAP_979 VGND VPWR sky130_fd_sc_hd__tapvpwrvgnd_1
XFILLER_0_18_62 VGND VGND VPWR VPWR sky130_fd_sc_hd__decap_4
X_8800_ clknet_leaf_1_clk _0889_ VGND VGND VPWR VPWR u_input_buffer.fifo_mem\[13\]\[6\]
+ sky130_fd_sc_hd__dfxtp_1
X_6992_ _3221_ _3230_ _3239_ VGND VGND VPWR VPWR _3240_ sky130_fd_sc_hd__or3_1
X_8731_ clknet_leaf_111_clk _0820_ VGND VGND VPWR VPWR u_input_buffer.fifo_mem\[17\]\[1\]
+ sky130_fd_sc_hd__dfxtp_1
X_5943_ _2511_ VGND VGND VPWR VPWR _0809_ sky130_fd_sc_hd__clkbuf_1
X_5874_ _2471_ VGND VGND VPWR VPWR _0780_ sky130_fd_sc_hd__clkbuf_1
X_8662_ clknet_leaf_85_clk _0751_ VGND VGND VPWR VPWR u_input_buffer.fifo_mem\[22\]\[12\]
+ sky130_fd_sc_hd__dfxtp_1
XFILLER_0_34_94 VGND VGND VPWR VPWR sky130_fd_sc_hd__fill_1
X_4825_ _1385_ net1304 _1893_ VGND VGND VPWR VPWR _1895_ sky130_fd_sc_hd__mux2_1
X_8593_ clknet_leaf_43_clk _0682_ VGND VGND VPWR VPWR u_input_buffer.fifo_mem\[26\]\[7\]
+ sky130_fd_sc_hd__dfxtp_1
X_7613_ _3762_ VGND VGND VPWR VPWR _1228_ sky130_fd_sc_hd__clkbuf_1
XFILLER_0_47_169 VGND VGND VPWR VPWR sky130_fd_sc_hd__fill_1
X_7544_ _3725_ VGND VGND VPWR VPWR _1196_ sky130_fd_sc_hd__clkbuf_1
XFILLER_0_43_320 VGND VGND VPWR VPWR sky130_fd_sc_hd__decap_4
X_4756_ _1857_ VGND VGND VPWR VPWR _0276_ sky130_fd_sc_hd__clkbuf_1
XFILLER_0_7_277 VGND VGND VPWR VPWR sky130_fd_sc_hd__decap_3
XFILLER_0_71_673 VGND VGND VPWR VPWR sky130_fd_sc_hd__decap_3
X_7475_ net1177 _1426_ _3678_ VGND VGND VPWR VPWR _3687_ sky130_fd_sc_hd__mux2_1
XFILLER_0_16_589 VPWR VGND VPWR VGND sky130_ef_sc_hd__decap_12
X_4687_ _1391_ net722 _1817_ VGND VGND VPWR VPWR _1820_ sky130_fd_sc_hd__mux2_1
XFILLER_0_113_241 VGND VGND VPWR VPWR sky130_fd_sc_hd__fill_1
X_6426_ _2774_ VGND VGND VPWR VPWR _1029_ sky130_fd_sc_hd__clkbuf_1
XFILLER_0_3_461 VPWR VGND VPWR VGND sky130_ef_sc_hd__decap_12
X_9214_ net168 _1301_ net205 VGND VGND VPWR VPWR u_register_bank.sensor_enable\[15\]
+ sky130_fd_sc_hd__dfrtp_1
X_6357_ net995 _2502_ _2735_ VGND VGND VPWR VPWR _2738_ sky130_fd_sc_hd__mux2_1
X_9145_ net175 _1233_ net207 VGND VGND VPWR VPWR u_register_bank.threshold_cfg\[27\]
+ sky130_fd_sc_hd__dfrtp_1
X_5308_ _2161_ VGND VGND VPWR VPWR _0524_ sky130_fd_sc_hd__clkbuf_1
X_9076_ clknet_leaf_48_clk _1164_ VGND VGND VPWR VPWR u_input_buffer.fifo_mem\[63\]\[6\]
+ sky130_fd_sc_hd__dfxtp_1
X_6288_ net363 _2502_ _2698_ VGND VGND VPWR VPWR _2701_ sky130_fd_sc_hd__mux2_1
X_5239_ net692 _2008_ _2115_ VGND VGND VPWR VPWR _2125_ sky130_fd_sc_hd__mux2_1
X_8027_ clknet_leaf_5_clk _0116_ VGND VGND VPWR VPWR u_input_buffer.fifo_mem\[61\]\[1\]
+ sky130_fd_sc_hd__dfxtp_1
XPHY_201 VGND VGND VPWR VPWR sky130_fd_sc_hd__decap_3
X_8929_ clknet_leaf_0_clk _1018_ VGND VGND VPWR VPWR u_input_buffer.fifo_mem\[5\]\[7\]
+ sky130_fd_sc_hd__dfxtp_1
XPHY_223 VGND VGND VPWR VPWR sky130_fd_sc_hd__decap_3
XPHY_212 VGND VGND VPWR VPWR sky130_fd_sc_hd__decap_3
XFILLER_0_66_445 VGND VGND VPWR VPWR sky130_fd_sc_hd__fill_1
XFILLER_0_26_309 VGND VGND VPWR VPWR sky130_fd_sc_hd__fill_2
Xhold5 u_sample_counter.sample_count\[18\] VGND VGND VPWR VPWR net217 sky130_fd_sc_hd__dlygate4sd3_1
XFILLER_0_69_261 VGND VGND VPWR VPWR sky130_fd_sc_hd__decap_3
XFILLER_0_84_231 VGND VGND VPWR VPWR sky130_fd_sc_hd__fill_2
XFILLER_0_84_253 VGND VGND VPWR VPWR sky130_fd_sc_hd__decap_4
X_4610_ _1776_ VGND VGND VPWR VPWR _1777_ sky130_fd_sc_hd__buf_2
X_5590_ _2320_ VGND VGND VPWR VPWR _0647_ sky130_fd_sc_hd__clkbuf_1
XFILLER_0_53_651 VGND VGND VPWR VPWR sky130_fd_sc_hd__fill_1
XFILLER_0_25_386 VGND VGND VPWR VPWR sky130_fd_sc_hd__fill_2
X_4541_ _1739_ VGND VGND VPWR VPWR _0179_ sky130_fd_sc_hd__clkbuf_1
XFILLER_0_53_673 VGND VGND VPWR VPWR sky130_fd_sc_hd__fill_1
Xhold405 u_input_buffer.fifo_mem\[30\]\[0\] VGND VGND VPWR VPWR net617 sky130_fd_sc_hd__dlygate4sd3_1
Xhold427 u_input_buffer.fifo_mem\[31\]\[0\] VGND VGND VPWR VPWR net639 sky130_fd_sc_hd__dlygate4sd3_1
XFILLER_0_80_481 VGND VGND VPWR VPWR sky130_fd_sc_hd__fill_1
Xhold416 u_input_buffer.fifo_mem\[60\]\[4\] VGND VGND VPWR VPWR net628 sky130_fd_sc_hd__dlygate4sd3_1
X_4472_ _1693_ VGND VGND VPWR VPWR _0156_ sky130_fd_sc_hd__clkbuf_1
X_7260_ u_input_buffer.fifo_mem\[3\]\[11\] _3069_ _3071_ u_input_buffer.fifo_mem\[60\]\[11\]
+ VGND VGND VPWR VPWR _3501_ sky130_fd_sc_hd__a22o_1
XFILLER_0_13_559 VGND VGND VPWR VPWR sky130_fd_sc_hd__fill_1
XFILLER_0_20_74 VGND VGND VPWR VPWR sky130_fd_sc_hd__decap_8
XFILLER_0_52_194 VGND VGND VPWR VPWR sky130_fd_sc_hd__fill_2
Xhold449 u_input_buffer.fifo_mem\[50\]\[4\] VGND VGND VPWR VPWR net661 sky130_fd_sc_hd__dlygate4sd3_1
Xhold438 u_input_buffer.fifo_mem\[45\]\[8\] VGND VGND VPWR VPWR net650 sky130_fd_sc_hd__dlygate4sd3_1
X_7191_ u_input_buffer.fifo_mem\[33\]\[10\] _2897_ _2903_ u_input_buffer.fifo_mem\[61\]\[10\]
+ _3432_ VGND VGND VPWR VPWR _3433_ sky130_fd_sc_hd__a221o_1
X_6211_ _2659_ VGND VGND VPWR VPWR _0929_ sky130_fd_sc_hd__clkbuf_1
XFILLER_0_110_244 VGND VGND VPWR VPWR sky130_fd_sc_hd__decap_8
X_6142_ _2622_ VGND VGND VPWR VPWR _0897_ sky130_fd_sc_hd__clkbuf_1
XTAP_710 VGND VPWR sky130_fd_sc_hd__tapvpwrvgnd_1
XFILLER_0_0_475 VGND VGND VPWR VPWR sky130_fd_sc_hd__fill_1
XTAP_732 VGND VPWR sky130_fd_sc_hd__tapvpwrvgnd_1
XTAP_721 VGND VPWR sky130_fd_sc_hd__tapvpwrvgnd_1
XTAP_743 VGND VPWR sky130_fd_sc_hd__tapvpwrvgnd_1
Xhold1105 u_input_buffer.wr_ptr\[4\] VGND VGND VPWR VPWR net1317 sky130_fd_sc_hd__dlygate4sd3_1
XTAP_754 VGND VPWR sky130_fd_sc_hd__tapvpwrvgnd_1
XTAP_765 VGND VPWR sky130_fd_sc_hd__tapvpwrvgnd_1
XTAP_776 VGND VPWR sky130_fd_sc_hd__tapvpwrvgnd_1
X_6073_ net501 _2528_ _2568_ VGND VGND VPWR VPWR _2585_ sky130_fd_sc_hd__mux2_1
X_5024_ net963 _2006_ _1990_ VGND VGND VPWR VPWR _2007_ sky130_fd_sc_hd__mux2_1
XTAP_787 VGND VPWR sky130_fd_sc_hd__tapvpwrvgnd_1
XTAP_798 VGND VPWR sky130_fd_sc_hd__tapvpwrvgnd_1
XFILLER_0_95_518 VGND VGND VPWR VPWR sky130_fd_sc_hd__fill_1
X_6975_ u_input_buffer.fifo_mem\[8\]\[4\] _3004_ _3006_ u_input_buffer.fifo_mem\[19\]\[4\]
+ _3222_ VGND VGND VPWR VPWR _3223_ sky130_fd_sc_hd__a221o_1
X_8714_ clknet_leaf_25_clk _0803_ VGND VGND VPWR VPWR u_input_buffer.fifo_mem\[18\]\[0\]
+ sky130_fd_sc_hd__dfxtp_1
X_5926_ _1384_ VGND VGND VPWR VPWR _2500_ sky130_fd_sc_hd__buf_4
XFILLER_0_0_73 VGND VGND VPWR VPWR sky130_fd_sc_hd__fill_1
X_8645_ clknet_leaf_90_clk _0734_ VGND VGND VPWR VPWR u_input_buffer.fifo_mem\[23\]\[11\]
+ sky130_fd_sc_hd__dfxtp_1
XFILLER_0_36_607 VGND VGND VPWR VPWR sky130_fd_sc_hd__decap_4
X_5857_ net1150 _2246_ _2461_ VGND VGND VPWR VPWR _2463_ sky130_fd_sc_hd__mux2_1
XFILLER_0_90_212 VGND VGND VPWR VPWR sky130_fd_sc_hd__decap_3
XFILLER_0_90_201 VGND VGND VPWR VPWR sky130_fd_sc_hd__fill_2
XFILLER_0_63_426 VGND VGND VPWR VPWR sky130_fd_sc_hd__decap_4
X_5788_ _2426_ VGND VGND VPWR VPWR _0739_ sky130_fd_sc_hd__clkbuf_1
X_8576_ clknet_leaf_67_clk _0665_ VGND VGND VPWR VPWR u_input_buffer.fifo_mem\[27\]\[6\]
+ sky130_fd_sc_hd__dfxtp_1
X_4808_ net296 _1724_ _1873_ VGND VGND VPWR VPWR _1885_ sky130_fd_sc_hd__mux2_1
XFILLER_0_28_191 VGND VGND VPWR VPWR sky130_fd_sc_hd__decap_4
XFILLER_0_44_651 VGND VGND VPWR VPWR sky130_fd_sc_hd__fill_1
X_7527_ _3716_ VGND VGND VPWR VPWR _1188_ sky130_fd_sc_hd__clkbuf_1
XFILLER_0_43_161 VGND VGND VPWR VPWR sky130_fd_sc_hd__fill_1
X_4739_ _1847_ VGND VGND VPWR VPWR _0269_ sky130_fd_sc_hd__clkbuf_1
X_7458_ _3677_ VGND VGND VPWR VPWR _3678_ sky130_fd_sc_hd__buf_4
XFILLER_0_9_82 VGND VGND VPWR VPWR sky130_fd_sc_hd__fill_2
X_6409_ _1624_ net1187 _2752_ VGND VGND VPWR VPWR _2765_ sky130_fd_sc_hd__mux2_1
XFILLER_0_12_581 VGND VGND VPWR VPWR sky130_fd_sc_hd__decap_4
X_7389_ u_input_buffer.fifo_mem\[53\]\[15\] _2933_ _2935_ u_input_buffer.fifo_mem\[57\]\[15\]
+ VGND VGND VPWR VPWR _3626_ sky130_fd_sc_hd__a22o_1
Xhold950 u_input_buffer.fifo_mem\[45\]\[10\] VGND VGND VPWR VPWR net1162 sky130_fd_sc_hd__dlygate4sd3_1
Xhold961 u_input_buffer.fifo_mem\[13\]\[5\] VGND VGND VPWR VPWR net1173 sky130_fd_sc_hd__dlygate4sd3_1
Xhold972 u_input_buffer.fifo_mem\[25\]\[5\] VGND VGND VPWR VPWR net1184 sky130_fd_sc_hd__dlygate4sd3_1
Xhold983 u_input_buffer.fifo_mem\[17\]\[2\] VGND VGND VPWR VPWR net1195 sky130_fd_sc_hd__dlygate4sd3_1
Xhold994 u_input_buffer.fifo_mem\[13\]\[6\] VGND VGND VPWR VPWR net1206 sky130_fd_sc_hd__dlygate4sd3_1
X_9128_ net170 _1216_ net202 VGND VGND VPWR VPWR u_analytics_engine.threshold\[10\]
+ sky130_fd_sc_hd__dfrtp_1
X_9059_ clknet_leaf_31_clk _1148_ VGND VGND VPWR VPWR u_sensor_interface.sensor_array\[3\]\[6\]
+ sky130_fd_sc_hd__dfxtp_1
XFILLER_0_39_445 VGND VGND VPWR VPWR sky130_fd_sc_hd__decap_3
XFILLER_0_94_540 VGND VGND VPWR VPWR sky130_fd_sc_hd__fill_2
XFILLER_0_66_253 VGND VGND VPWR VPWR sky130_fd_sc_hd__decap_8
XFILLER_0_41_29 VGND VGND VPWR VPWR sky130_fd_sc_hd__decap_4
XFILLER_0_109_333 VGND VGND VPWR VPWR sky130_fd_sc_hd__decap_3
XFILLER_0_81_223 VGND VGND VPWR VPWR sky130_fd_sc_hd__fill_1
XFILLER_0_105_561 VGND VGND VPWR VPWR sky130_fd_sc_hd__decap_3
XFILLER_0_10_529 VGND VGND VPWR VPWR sky130_fd_sc_hd__decap_3
XFILLER_0_5_18 VPWR VGND VPWR VGND sky130_ef_sc_hd__decap_12
XFILLER_0_66_15 VGND VGND VPWR VPWR sky130_fd_sc_hd__fill_1
XFILLER_0_106_65 VGND VGND VPWR VPWR sky130_fd_sc_hd__fill_2
X_6760_ _2906_ _2991_ VGND VGND VPWR VPWR _3012_ sky130_fd_sc_hd__nor2_2
X_3972_ _1336_ VGND VGND VPWR VPWR _0013_ sky130_fd_sc_hd__clkbuf_1
XFILLER_0_57_242 VGND VGND VPWR VPWR sky130_fd_sc_hd__fill_2
X_5711_ _2384_ VGND VGND VPWR VPWR _0704_ sky130_fd_sc_hd__clkbuf_1
X_6691_ _2942_ VGND VGND VPWR VPWR _2943_ sky130_fd_sc_hd__clkbuf_4
X_8430_ clknet_leaf_28_clk _0519_ VGND VGND VPWR VPWR u_input_buffer.fifo_mem\[36\]\[4\]
+ sky130_fd_sc_hd__dfxtp_1
XFILLER_0_5_501 VGND VGND VPWR VPWR sky130_fd_sc_hd__decap_3
X_5642_ net784 _2270_ _2333_ VGND VGND VPWR VPWR _2348_ sky130_fd_sc_hd__mux2_1
X_5573_ _1457_ net1200 _2296_ VGND VGND VPWR VPWR _2311_ sky130_fd_sc_hd__mux2_1
X_8361_ clknet_leaf_99_clk _0450_ VGND VGND VPWR VPWR u_input_buffer.fifo_mem\[41\]\[15\]
+ sky130_fd_sc_hd__dfxtp_1
X_7312_ u_input_buffer.fifo_mem\[17\]\[13\] _2942_ _2944_ u_input_buffer.fifo_mem\[5\]\[13\]
+ VGND VGND VPWR VPWR _3551_ sky130_fd_sc_hd__a22o_1
Xhold202 u_sensor_interface.sensor_array\[3\]\[13\] VGND VGND VPWR VPWR net414 sky130_fd_sc_hd__dlygate4sd3_1
X_4524_ _1727_ VGND VGND VPWR VPWR _0174_ sky130_fd_sc_hd__clkbuf_1
Xhold224 u_input_buffer.fifo_mem\[2\]\[2\] VGND VGND VPWR VPWR net436 sky130_fd_sc_hd__dlygate4sd3_1
X_8292_ clknet_leaf_106_clk _0381_ VGND VGND VPWR VPWR u_input_buffer.fifo_mem\[45\]\[10\]
+ sky130_fd_sc_hd__dfxtp_1
Xhold213 u_input_buffer.fifo_mem\[47\]\[15\] VGND VGND VPWR VPWR net425 sky130_fd_sc_hd__dlygate4sd3_1
Xhold235 u_input_buffer.fifo_mem\[2\]\[11\] VGND VGND VPWR VPWR net447 sky130_fd_sc_hd__dlygate4sd3_1
Xhold268 u_input_buffer.fifo_mem\[15\]\[0\] VGND VGND VPWR VPWR net480 sky130_fd_sc_hd__dlygate4sd3_1
Xhold246 u_input_buffer.fifo_mem\[30\]\[1\] VGND VGND VPWR VPWR net458 sky130_fd_sc_hd__dlygate4sd3_1
X_4455_ net1299 _1604_ _1683_ VGND VGND VPWR VPWR _1685_ sky130_fd_sc_hd__mux2_1
Xhold257 u_input_buffer.fifo_mem\[46\]\[9\] VGND VGND VPWR VPWR net469 sky130_fd_sc_hd__dlygate4sd3_1
X_7243_ u_input_buffer.fifo_mem\[50\]\[11\] _2994_ _2996_ u_input_buffer.fifo_mem\[4\]\[11\]
+ VGND VGND VPWR VPWR _3484_ sky130_fd_sc_hd__a22o_1
X_7174_ u_input_buffer.fifo_mem\[7\]\[9\] _3025_ _3027_ u_input_buffer.fifo_mem\[22\]\[9\]
+ _3416_ VGND VGND VPWR VPWR _3417_ sky130_fd_sc_hd__a221o_1
Xhold279 u_input_buffer.fifo_mem\[34\]\[15\] VGND VGND VPWR VPWR net491 sky130_fd_sc_hd__dlygate4sd3_1
X_4386_ _1645_ VGND VGND VPWR VPWR _0118_ sky130_fd_sc_hd__clkbuf_1
XTAP_540 VGND VPWR sky130_fd_sc_hd__tapvpwrvgnd_1
XTAP_551 VGND VPWR sky130_fd_sc_hd__tapvpwrvgnd_1
X_6125_ _1614_ net1206 _2607_ VGND VGND VPWR VPWR _2614_ sky130_fd_sc_hd__mux2_1
XFILLER_0_99_109 VGND VGND VPWR VPWR sky130_fd_sc_hd__decap_3
XTAP_573 VGND VPWR sky130_fd_sc_hd__tapvpwrvgnd_1
XTAP_562 VGND VPWR sky130_fd_sc_hd__tapvpwrvgnd_1
XTAP_584 VGND VPWR sky130_fd_sc_hd__tapvpwrvgnd_1
X_6056_ _2576_ VGND VGND VPWR VPWR _0857_ sky130_fd_sc_hd__clkbuf_1
XTAP_595 VGND VPWR sky130_fd_sc_hd__tapvpwrvgnd_1
X_5007_ _1995_ VGND VGND VPWR VPWR _0389_ sky130_fd_sc_hd__clkbuf_1
XFILLER_0_95_315 VGND VGND VPWR VPWR sky130_fd_sc_hd__fill_1
XFILLER_0_68_507 VGND VGND VPWR VPWR sky130_fd_sc_hd__decap_4
XFILLER_0_95_337 VGND VGND VPWR VPWR sky130_fd_sc_hd__fill_1
X_6958_ u_input_buffer.fifo_mem\[37\]\[4\] _2923_ _2926_ u_input_buffer.fifo_mem\[9\]\[4\]
+ VGND VGND VPWR VPWR _3206_ sky130_fd_sc_hd__a22o_1
X_6889_ u_input_buffer.fifo_mem\[34\]\[2\] _2966_ _2969_ u_input_buffer.fifo_mem\[48\]\[2\]
+ _3138_ VGND VGND VPWR VPWR _3139_ sky130_fd_sc_hd__a221o_1
X_5909_ net742 _2264_ _2478_ VGND VGND VPWR VPWR _2490_ sky130_fd_sc_hd__mux2_1
XFILLER_0_91_565 VGND VGND VPWR VPWR sky130_fd_sc_hd__fill_1
X_8628_ clknet_leaf_76_clk _0717_ VGND VGND VPWR VPWR u_input_buffer.fifo_mem\[24\]\[10\]
+ sky130_fd_sc_hd__dfxtp_1
X_8559_ clknet_leaf_52_clk _0648_ VGND VGND VPWR VPWR u_input_buffer.fifo_mem\[28\]\[5\]
+ sky130_fd_sc_hd__dfxtp_1
XFILLER_0_63_278 VGND VGND VPWR VPWR sky130_fd_sc_hd__fill_2
XFILLER_0_16_150 VGND VGND VPWR VPWR sky130_fd_sc_hd__fill_1
XFILLER_0_32_643 VGND VGND VPWR VPWR sky130_fd_sc_hd__fill_1
XFILLER_0_102_586 VGND VGND VPWR VPWR sky130_fd_sc_hd__fill_2
Xhold791 u_input_buffer.fifo_mem\[63\]\[5\] VGND VGND VPWR VPWR net1003 sky130_fd_sc_hd__dlygate4sd3_1
Xhold780 u_input_buffer.fifo_mem\[9\]\[9\] VGND VGND VPWR VPWR net992 sky130_fd_sc_hd__dlygate4sd3_1
XFILLER_0_6_3 VPWR VGND VPWR VGND sky130_ef_sc_hd__decap_12
XFILLER_0_31_197 VGND VGND VPWR VPWR sky130_fd_sc_hd__fill_2
XFILLER_0_36_29 VGND VGND VPWR VPWR sky130_fd_sc_hd__decap_3
XFILLER_0_98_197 VGND VGND VPWR VPWR sky130_fd_sc_hd__fill_1
XFILLER_0_54_245 VGND VGND VPWR VPWR sky130_fd_sc_hd__decap_3
XFILLER_0_82_587 VGND VGND VPWR VPWR sky130_fd_sc_hd__fill_1
XFILLER_0_112_339 VGND VGND VPWR VPWR sky130_fd_sc_hd__decap_6
XFILLER_0_22_197 VGND VGND VPWR VPWR sky130_fd_sc_hd__decap_3
X_4240_ net252 _1522_ VGND VGND VPWR VPWR _1526_ sky130_fd_sc_hd__and2_1
X_4171_ u_sample_counter.sample_count\[3\] _1477_ VGND VGND VPWR VPWR _1480_ sky130_fd_sc_hd__or2_1
XFILLER_0_93_57 VPWR VGND VPWR VGND sky130_ef_sc_hd__decap_12
X_7930_ clknet_leaf_111_clk _0020_ VGND VGND VPWR VPWR u_sensor_interface.sensor_array\[1\]\[2\]
+ sky130_fd_sc_hd__dfxtp_2
XFILLER_0_89_164 VGND VGND VPWR VPWR sky130_fd_sc_hd__fill_1
X_7861_ _3930_ VGND VGND VPWR VPWR _1308_ sky130_fd_sc_hd__clkbuf_1
X_6812_ u_input_buffer.fifo_mem\[10\]\[0\] _3056_ _3058_ u_input_buffer.fifo_mem\[44\]\[0\]
+ _3063_ VGND VGND VPWR VPWR _3064_ sky130_fd_sc_hd__a221o_1
XFILLER_0_89_175 VGND VGND VPWR VPWR sky130_fd_sc_hd__fill_2
XFILLER_0_77_337 VGND VGND VPWR VPWR sky130_fd_sc_hd__decap_3
X_7792_ net1321 u_analytics_engine.data_in\[6\] _3893_ VGND VGND VPWR VPWR _3894_
+ sky130_fd_sc_hd__mux2_1
X_3955_ _1327_ VGND VGND VPWR VPWR _0005_ sky130_fd_sc_hd__clkbuf_1
X_6743_ _2994_ VGND VGND VPWR VPWR _2995_ sky130_fd_sc_hd__clkbuf_4
X_6674_ _2925_ VGND VGND VPWR VPWR _2926_ sky130_fd_sc_hd__clkbuf_4
XFILLER_0_9_169 VGND VGND VPWR VPWR sky130_fd_sc_hd__fill_2
XFILLER_0_42_83 VGND VGND VPWR VPWR sky130_fd_sc_hd__fill_1
X_5625_ _2339_ VGND VGND VPWR VPWR _0663_ sky130_fd_sc_hd__clkbuf_1
X_8413_ clknet_leaf_21_clk _0502_ VGND VGND VPWR VPWR u_input_buffer.fifo_mem\[37\]\[3\]
+ sky130_fd_sc_hd__dfxtp_1
XFILLER_0_84_3 VPWR VGND VPWR VGND sky130_ef_sc_hd__decap_12
XFILLER_0_14_610 VGND VGND VPWR VPWR sky130_fd_sc_hd__fill_1
XFILLER_0_26_470 VGND VGND VPWR VPWR sky130_fd_sc_hd__decap_6
X_8344_ clknet_leaf_13_clk _0433_ VGND VGND VPWR VPWR u_input_buffer.fifo_mem\[42\]\[14\]
+ sky130_fd_sc_hd__dfxtp_1
XFILLER_0_14_643 VGND VGND VPWR VPWR sky130_fd_sc_hd__fill_1
X_5556_ _2302_ VGND VGND VPWR VPWR _0631_ sky130_fd_sc_hd__clkbuf_1
X_4507_ _1414_ VGND VGND VPWR VPWR _1716_ sky130_fd_sc_hd__clkbuf_4
X_8275_ clknet_leaf_41_clk _0364_ VGND VGND VPWR VPWR u_input_buffer.fifo_mem\[46\]\[9\]
+ sky130_fd_sc_hd__dfxtp_1
X_5487_ _2261_ VGND VGND VPWR VPWR _0603_ sky130_fd_sc_hd__clkbuf_1
X_4438_ _1673_ VGND VGND VPWR VPWR _0142_ sky130_fd_sc_hd__clkbuf_1
X_7226_ _3449_ _3458_ _3467_ VGND VGND VPWR VPWR _3468_ sky130_fd_sc_hd__or3_1
X_4369_ net1159 _1632_ _1601_ VGND VGND VPWR VPWR _1633_ sky130_fd_sc_hd__mux2_1
X_7157_ u_input_buffer.fifo_mem\[29\]\[9\] _2939_ _2941_ u_input_buffer.fifo_mem\[13\]\[9\]
+ _3399_ VGND VGND VPWR VPWR _3400_ sky130_fd_sc_hd__a221o_1
X_7088_ u_input_buffer.fifo_mem\[51\]\[7\] _2990_ _2993_ u_input_buffer.fifo_mem\[11\]\[7\]
+ _3332_ VGND VGND VPWR VPWR _3333_ sky130_fd_sc_hd__a221o_1
XTAP_392 VGND VPWR sky130_fd_sc_hd__tapvpwrvgnd_1
XTAP_381 VGND VPWR sky130_fd_sc_hd__tapvpwrvgnd_1
XTAP_370 VGND VPWR sky130_fd_sc_hd__tapvpwrvgnd_1
X_6108_ _2603_ VGND VGND VPWR VPWR _0882_ sky130_fd_sc_hd__clkbuf_1
X_6039_ u_input_buffer.wr_ptr\[5\] u_input_buffer.wr_ptr\[4\] net185 VGND VGND VPWR
+ VPWR _2566_ sky130_fd_sc_hd__or3b_1
XTAP_1514 VGND VPWR sky130_fd_sc_hd__tapvpwrvgnd_1
XTAP_1503 VGND VPWR sky130_fd_sc_hd__tapvpwrvgnd_1
XPHY_21 VGND VGND VPWR VPWR sky130_fd_sc_hd__decap_3
XPHY_10 VGND VGND VPWR VPWR sky130_fd_sc_hd__decap_3
XTAP_1547 VGND VPWR sky130_fd_sc_hd__tapvpwrvgnd_1
XTAP_1536 VGND VPWR sky130_fd_sc_hd__tapvpwrvgnd_1
XTAP_1525 VGND VPWR sky130_fd_sc_hd__tapvpwrvgnd_1
XPHY_32 VGND VGND VPWR VPWR sky130_fd_sc_hd__decap_3
XPHY_43 VGND VGND VPWR VPWR sky130_fd_sc_hd__decap_3
XPHY_54 VGND VGND VPWR VPWR sky130_fd_sc_hd__decap_3
XPHY_65 VGND VGND VPWR VPWR sky130_fd_sc_hd__decap_3
XTAP_1569 VGND VPWR sky130_fd_sc_hd__tapvpwrvgnd_1
XTAP_1558 VGND VPWR sky130_fd_sc_hd__tapvpwrvgnd_1
XPHY_76 VGND VGND VPWR VPWR sky130_fd_sc_hd__decap_3
XPHY_87 VGND VGND VPWR VPWR sky130_fd_sc_hd__decap_3
XPHY_98 VGND VGND VPWR VPWR sky130_fd_sc_hd__decap_3
XFILLER_0_36_212 VGND VGND VPWR VPWR sky130_fd_sc_hd__decap_4
XFILLER_0_102_361 VGND VGND VPWR VPWR sky130_fd_sc_hd__decap_3
XFILLER_0_99_473 VGND VGND VPWR VPWR sky130_fd_sc_hd__decap_6
XFILLER_0_7_629 VPWR VGND VPWR VGND sky130_ef_sc_hd__decap_12
XANTENNA_19 net7 VGND VGND VPWR VPWR sky130_fd_sc_hd__diode_2
Xclkbuf_leaf_106_clk clknet_3_0__leaf_clk VGND VGND VPWR VPWR clknet_leaf_106_clk
+ sky130_fd_sc_hd__clkbuf_16
XFILLER_0_103_55 VGND VGND VPWR VPWR sky130_fd_sc_hd__fill_1
XFILLER_0_12_53 VGND VGND VPWR VPWR sky130_fd_sc_hd__fill_1
XFILLER_0_6_139 VGND VGND VPWR VPWR sky130_fd_sc_hd__fill_1
XFILLER_0_15_418 VGND VGND VPWR VPWR sky130_fd_sc_hd__decap_4
XFILLER_0_12_97 VGND VGND VPWR VPWR sky130_fd_sc_hd__decap_4
XFILLER_0_113_615 VGND VGND VPWR VPWR sky130_fd_sc_hd__fill_1
X_5410_ _2215_ VGND VGND VPWR VPWR _0572_ sky130_fd_sc_hd__clkbuf_1
X_6390_ _2755_ VGND VGND VPWR VPWR _1012_ sky130_fd_sc_hd__clkbuf_1
Xoutput115 net115 VGND VGND VPWR VPWR cfg_rdata[10] sky130_fd_sc_hd__clkbuf_4
X_5341_ net597 _2008_ _2169_ VGND VGND VPWR VPWR _2179_ sky130_fd_sc_hd__mux2_1
XFILLER_0_70_9 VPWR VGND VPWR VGND sky130_ef_sc_hd__decap_12
Xoutput126 net126 VGND VGND VPWR VPWR cfg_rdata[20] sky130_fd_sc_hd__clkbuf_4
Xoutput159 net159 VGND VGND VPWR VPWR processed_data_out[5] sky130_fd_sc_hd__clkbuf_4
Xoutput148 net148 VGND VGND VPWR VPWR processed_data_out[0] sky130_fd_sc_hd__clkbuf_4
X_8060_ clknet_leaf_45_clk _0149_ VGND VGND VPWR VPWR u_input_buffer.fifo_mem\[59\]\[2\]
+ sky130_fd_sc_hd__dfxtp_1
XFILLER_0_23_495 VGND VGND VPWR VPWR sky130_fd_sc_hd__decap_8
Xoutput137 net137 VGND VGND VPWR VPWR cfg_rdata[30] sky130_fd_sc_hd__clkbuf_4
X_7011_ _3251_ _3253_ _3255_ _3257_ VGND VGND VPWR VPWR _3258_ sky130_fd_sc_hd__or4_2
X_5272_ _2142_ VGND VGND VPWR VPWR _0507_ sky130_fd_sc_hd__clkbuf_1
X_4223_ u_sample_counter.sample_count\[19\] u_sample_counter.sample_count\[20\] _1507_
+ u_sample_counter.sample_count\[21\] VGND VGND VPWR VPWR _1514_ sky130_fd_sc_hd__a31o_1
X_4154_ _1467_ VGND VGND VPWR VPWR _0064_ sky130_fd_sc_hd__clkbuf_1
X_4085_ u_input_buffer.data_in\[5\] VGND VGND VPWR VPWR _1408_ sky130_fd_sc_hd__buf_4
X_8962_ clknet_leaf_42_clk _1051_ VGND VGND VPWR VPWR u_input_buffer.fifo_mem\[3\]\[8\]
+ sky130_fd_sc_hd__dfxtp_1
X_7913_ clknet_leaf_22_clk _0003_ VGND VGND VPWR VPWR u_sensor_interface.sensor_array\[2\]\[1\]
+ sky130_fd_sc_hd__dfxtp_1
X_8893_ clknet_leaf_65_clk _0982_ VGND VGND VPWR VPWR u_input_buffer.fifo_mem\[7\]\[3\]
+ sky130_fd_sc_hd__dfxtp_1
XFILLER_0_77_145 VGND VGND VPWR VPWR sky130_fd_sc_hd__fill_1
X_7844_ _3921_ VGND VGND VPWR VPWR _1300_ sky130_fd_sc_hd__clkbuf_1
X_7775_ u_register_bank.status_flags\[31\] _3774_ _3777_ u_register_bank.sensor_enable\[31\]
+ VGND VGND VPWR VPWR _3884_ sky130_fd_sc_hd__a22o_1
X_4987_ _1445_ net855 _1970_ VGND VGND VPWR VPWR _1983_ sky130_fd_sc_hd__mux2_1
X_6726_ _2872_ _2873_ _2901_ VGND VGND VPWR VPWR _2978_ sky130_fd_sc_hd__or3_4
XFILLER_0_18_267 VGND VGND VPWR VPWR sky130_fd_sc_hd__fill_1
XFILLER_0_46_587 VGND VGND VPWR VPWR sky130_fd_sc_hd__fill_1
X_6657_ _2908_ VGND VGND VPWR VPWR _2909_ sky130_fd_sc_hd__clkbuf_4
XFILLER_0_61_557 VGND VGND VPWR VPWR sky130_fd_sc_hd__decap_3
X_6588_ _2859_ VGND VGND VPWR VPWR _1106_ sky130_fd_sc_hd__clkbuf_1
X_5608_ _2329_ VGND VGND VPWR VPWR _0656_ sky130_fd_sc_hd__clkbuf_1
X_8327_ clknet_leaf_13_clk _0416_ VGND VGND VPWR VPWR u_input_buffer.fifo_mem\[43\]\[13\]
+ sky130_fd_sc_hd__dfxtp_1
X_5539_ net871 _2272_ _2276_ VGND VGND VPWR VPWR _2292_ sky130_fd_sc_hd__mux2_1
XFILLER_0_112_681 VGND VGND VPWR VPWR sky130_fd_sc_hd__decap_4
XFILLER_0_111_180 VGND VGND VPWR VPWR sky130_fd_sc_hd__fill_1
X_8258_ clknet_leaf_77_clk _0347_ VGND VGND VPWR VPWR u_input_buffer.fifo_mem\[47\]\[8\]
+ sky130_fd_sc_hd__dfxtp_1
X_8189_ clknet_leaf_16_clk _0278_ VGND VGND VPWR VPWR u_input_buffer.fifo_mem\[51\]\[3\]
+ sky130_fd_sc_hd__dfxtp_1
X_7209_ u_input_buffer.fifo_mem\[8\]\[10\] _3003_ _3005_ u_input_buffer.fifo_mem\[19\]\[10\]
+ _3450_ VGND VGND VPWR VPWR _3451_ sky130_fd_sc_hd__a221o_1
XFILLER_0_68_101 VGND VGND VPWR VPWR sky130_fd_sc_hd__fill_1
XTAP_1322 VGND VPWR sky130_fd_sc_hd__tapvpwrvgnd_1
XTAP_1311 VGND VPWR sky130_fd_sc_hd__tapvpwrvgnd_1
XTAP_1300 VGND VPWR sky130_fd_sc_hd__tapvpwrvgnd_1
XTAP_1355 VGND VPWR sky130_fd_sc_hd__tapvpwrvgnd_1
XTAP_1366 VGND VPWR sky130_fd_sc_hd__tapvpwrvgnd_1
XTAP_1344 VGND VPWR sky130_fd_sc_hd__tapvpwrvgnd_1
XTAP_1333 VGND VPWR sky130_fd_sc_hd__tapvpwrvgnd_1
XFILLER_0_56_307 VGND VGND VPWR VPWR sky130_fd_sc_hd__fill_1
XTAP_1399 VGND VPWR sky130_fd_sc_hd__tapvpwrvgnd_1
XTAP_1388 VGND VPWR sky130_fd_sc_hd__tapvpwrvgnd_1
XTAP_1377 VGND VPWR sky130_fd_sc_hd__tapvpwrvgnd_1
XFILLER_0_92_660 VPWR VGND VPWR VGND sky130_ef_sc_hd__decap_12
Xinput28 cfg_wdata[24] VGND VGND VPWR VPWR net28 sky130_fd_sc_hd__buf_2
Xinput17 cfg_wdata[14] VGND VGND VPWR VPWR net17 sky130_fd_sc_hd__clkbuf_2
Xinput39 cfg_wdata[5] VGND VGND VPWR VPWR net39 sky130_fd_sc_hd__buf_1
XFILLER_0_58_27 VGND VGND VPWR VPWR sky130_fd_sc_hd__fill_1
XFILLER_0_20_432 VGND VGND VPWR VPWR sky130_fd_sc_hd__fill_2
XFILLER_0_20_443 VGND VGND VPWR VPWR sky130_fd_sc_hd__decap_3
X_5890_ _2480_ VGND VGND VPWR VPWR _0787_ sky130_fd_sc_hd__clkbuf_1
X_4910_ net706 _1718_ _1934_ VGND VGND VPWR VPWR _1942_ sky130_fd_sc_hd__mux2_1
X_4841_ _1433_ net1300 _1893_ VGND VGND VPWR VPWR _1903_ sky130_fd_sc_hd__mux2_1
XFILLER_0_75_649 VGND VGND VPWR VPWR sky130_fd_sc_hd__fill_1
XFILLER_0_74_137 VGND VGND VPWR VPWR sky130_fd_sc_hd__decap_3
X_4772_ _1865_ VGND VGND VPWR VPWR _0284_ sky130_fd_sc_hd__clkbuf_1
X_7560_ _3733_ VGND VGND VPWR VPWR _1204_ sky130_fd_sc_hd__clkbuf_1
X_7491_ net6 net5 net8 net7 VGND VGND VPWR VPWR _3695_ sky130_fd_sc_hd__or4_1
XFILLER_0_83_682 VGND VGND VPWR VPWR sky130_fd_sc_hd__decap_4
X_6511_ net447 _1444_ _2806_ VGND VGND VPWR VPWR _2819_ sky130_fd_sc_hd__mux2_1
XFILLER_0_113_401 VGND VGND VPWR VPWR sky130_fd_sc_hd__fill_2
X_6442_ _2782_ VGND VGND VPWR VPWR _1037_ sky130_fd_sc_hd__clkbuf_1
XFILLER_0_43_557 VGND VGND VPWR VPWR sky130_fd_sc_hd__decap_3
X_9230_ net173 _1317_ net204 VGND VGND VPWR VPWR u_register_bank.sensor_enable\[31\]
+ sky130_fd_sc_hd__dfrtp_1
XFILLER_0_70_365 VGND VGND VPWR VPWR sky130_fd_sc_hd__fill_1
X_9161_ net168 _1249_ VGND VGND VPWR VPWR net116 sky130_fd_sc_hd__dfxtp_1
X_8112_ clknet_leaf_57_clk _0201_ VGND VGND VPWR VPWR u_input_buffer.fifo_mem\[56\]\[6\]
+ sky130_fd_sc_hd__dfxtp_1
XFILLER_0_101_629 VGND VGND VPWR VPWR sky130_fd_sc_hd__decap_6
XFILLER_0_3_665 VGND VGND VPWR VPWR sky130_fd_sc_hd__decap_6
XFILLER_0_23_281 VGND VGND VPWR VPWR sky130_fd_sc_hd__fill_1
X_6373_ net520 _2518_ _2734_ VGND VGND VPWR VPWR _2746_ sky130_fd_sc_hd__mux2_1
X_5324_ _2170_ VGND VGND VPWR VPWR _0531_ sky130_fd_sc_hd__clkbuf_1
X_9092_ net179 _1180_ net210 VGND VGND VPWR VPWR u_register_bank.window_cfg\[6\] sky130_fd_sc_hd__dfrtp_1
XFILLER_0_2_186 VGND VGND VPWR VPWR sky130_fd_sc_hd__fill_2
XFILLER_0_2_197 VGND VGND VPWR VPWR sky130_fd_sc_hd__fill_2
X_8043_ clknet_leaf_40_clk _0132_ VGND VGND VPWR VPWR u_input_buffer.fifo_mem\[60\]\[1\]
+ sky130_fd_sc_hd__dfxtp_1
X_5255_ _1377_ net1086 _2133_ VGND VGND VPWR VPWR _2134_ sky130_fd_sc_hd__mux2_1
XFILLER_0_11_487 VPWR VGND VPWR VGND sky130_ef_sc_hd__decap_12
X_4206_ _1501_ _1502_ VGND VGND VPWR VPWR _1503_ sky130_fd_sc_hd__and2_1
X_5186_ _2096_ VGND VGND VPWR VPWR _2097_ sky130_fd_sc_hd__clkbuf_4
X_4137_ _1452_ u_sensor_interface.sensor_array\[2\]\[12\] net112 VGND VGND VPWR VPWR
+ _1453_ sky130_fd_sc_hd__mux2_1
XFILLER_0_3_51 VGND VGND VPWR VPWR sky130_fd_sc_hd__decap_4
X_4068_ _1393_ u_sensor_interface.sensor_array\[3\]\[2\] _1381_ VGND VGND VPWR VPWR
+ _1394_ sky130_fd_sc_hd__mux2_1
X_8945_ clknet_leaf_38_clk _1034_ VGND VGND VPWR VPWR u_input_buffer.fifo_mem\[4\]\[7\]
+ sky130_fd_sc_hd__dfxtp_1
X_8876_ clknet_leaf_60_clk _0965_ VGND VGND VPWR VPWR u_input_buffer.fifo_mem\[8\]\[2\]
+ sky130_fd_sc_hd__dfxtp_1
X_7827_ _3912_ VGND VGND VPWR VPWR _1292_ sky130_fd_sc_hd__clkbuf_1
XFILLER_0_108_206 VGND VGND VPWR VPWR sky130_fd_sc_hd__fill_2
X_7758_ _3871_ VGND VGND VPWR VPWR _1264_ sky130_fd_sc_hd__clkbuf_1
X_6709_ _2960_ VGND VGND VPWR VPWR _2961_ sky130_fd_sc_hd__clkbuf_4
X_7689_ _3818_ VGND VGND VPWR VPWR _1248_ sky130_fd_sc_hd__clkbuf_1
XFILLER_0_61_376 VGND VGND VPWR VPWR sky130_fd_sc_hd__decap_4
Xfanout183 net9 VGND VGND VPWR VPWR net183 sky130_fd_sc_hd__buf_2
Xfanout172 net173 VGND VGND VPWR VPWR net172 sky130_fd_sc_hd__buf_2
Xfanout194 net200 VGND VGND VPWR VPWR net194 sky130_fd_sc_hd__clkbuf_4
XFILLER_0_44_29 VGND VGND VPWR VPWR sky130_fd_sc_hd__decap_4
XTAP_1141 VGND VPWR sky130_fd_sc_hd__tapvpwrvgnd_1
XTAP_1130 VGND VPWR sky130_fd_sc_hd__tapvpwrvgnd_1
XTAP_1174 VGND VPWR sky130_fd_sc_hd__tapvpwrvgnd_1
XTAP_1163 VGND VPWR sky130_fd_sc_hd__tapvpwrvgnd_1
XTAP_1152 VGND VPWR sky130_fd_sc_hd__tapvpwrvgnd_1
XFILLER_0_56_137 VGND VGND VPWR VPWR sky130_fd_sc_hd__decap_3
XTAP_1196 VGND VPWR sky130_fd_sc_hd__tapvpwrvgnd_1
XTAP_1185 VGND VPWR sky130_fd_sc_hd__tapvpwrvgnd_1
XFILLER_0_71_107 VGND VGND VPWR VPWR sky130_fd_sc_hd__decap_4
XFILLER_0_60_39 VGND VGND VPWR VPWR sky130_fd_sc_hd__fill_2
XFILLER_0_56_159 VGND VGND VPWR VPWR sky130_fd_sc_hd__fill_2
XFILLER_0_71_118 VGND VGND VPWR VPWR sky130_fd_sc_hd__decap_4
XFILLER_0_65_671 VGND VGND VPWR VPWR sky130_fd_sc_hd__fill_1
XFILLER_0_114_209 VPWR VGND VPWR VGND sky130_ef_sc_hd__decap_12
XFILLER_0_8_29 VPWR VGND VPWR VGND sky130_ef_sc_hd__decap_12
XFILLER_0_52_321 VGND VGND VPWR VPWR sky130_fd_sc_hd__fill_2
XFILLER_0_52_343 VGND VGND VPWR VPWR sky130_fd_sc_hd__decap_4
Xhold609 u_input_buffer.fifo_mem\[23\]\[8\] VGND VGND VPWR VPWR net821 sky130_fd_sc_hd__dlygate4sd3_1
XFILLER_0_0_602 VGND VGND VPWR VPWR sky130_fd_sc_hd__decap_3
XTAP_925 VGND VPWR sky130_fd_sc_hd__tapvpwrvgnd_1
XTAP_914 VGND VPWR sky130_fd_sc_hd__tapvpwrvgnd_1
XTAP_903 VGND VPWR sky130_fd_sc_hd__tapvpwrvgnd_1
XTAP_958 VGND VPWR sky130_fd_sc_hd__tapvpwrvgnd_1
XTAP_947 VGND VPWR sky130_fd_sc_hd__tapvpwrvgnd_1
XTAP_936 VGND VPWR sky130_fd_sc_hd__tapvpwrvgnd_1
X_5040_ _2017_ VGND VGND VPWR VPWR _0400_ sky130_fd_sc_hd__clkbuf_1
XTAP_969 VGND VPWR sky130_fd_sc_hd__tapvpwrvgnd_1
XFILLER_0_18_41 VGND VGND VPWR VPWR sky130_fd_sc_hd__decap_4
XFILLER_0_18_85 VGND VGND VPWR VPWR sky130_fd_sc_hd__decap_8
X_6991_ _3232_ _3234_ _3236_ _3238_ VGND VGND VPWR VPWR _3239_ sky130_fd_sc_hd__or4_1
X_5942_ net736 _2510_ _2498_ VGND VGND VPWR VPWR _2511_ sky130_fd_sc_hd__mux2_1
X_8730_ clknet_leaf_111_clk _0819_ VGND VGND VPWR VPWR u_input_buffer.fifo_mem\[17\]\[0\]
+ sky130_fd_sc_hd__dfxtp_1
XFILLER_0_47_104 VGND VGND VPWR VPWR sky130_fd_sc_hd__fill_2
X_5873_ net594 _2262_ _2461_ VGND VGND VPWR VPWR _2471_ sky130_fd_sc_hd__mux2_1
X_8661_ clknet_leaf_81_clk _0750_ VGND VGND VPWR VPWR u_input_buffer.fifo_mem\[22\]\[11\]
+ sky130_fd_sc_hd__dfxtp_1
X_4824_ _1894_ VGND VGND VPWR VPWR _0307_ sky130_fd_sc_hd__clkbuf_1
XFILLER_0_75_457 VGND VGND VPWR VPWR sky130_fd_sc_hd__fill_1
X_8592_ clknet_leaf_45_clk _0681_ VGND VGND VPWR VPWR u_input_buffer.fifo_mem\[26\]\[6\]
+ sky130_fd_sc_hd__dfxtp_1
X_7612_ net26 u_register_bank.threshold_cfg\[22\] _3759_ VGND VGND VPWR VPWR _3762_
+ sky130_fd_sc_hd__mux2_1
X_4755_ net1042 _1706_ _1855_ VGND VGND VPWR VPWR _1857_ sky130_fd_sc_hd__mux2_1
X_7543_ net26 u_register_bank.window_cfg\[22\] _3722_ VGND VGND VPWR VPWR _3725_ sky130_fd_sc_hd__mux2_1
XFILLER_0_7_245 VGND VGND VPWR VPWR sky130_fd_sc_hd__decap_4
XFILLER_0_7_234 VGND VGND VPWR VPWR sky130_fd_sc_hd__fill_2
XFILLER_0_7_289 VGND VGND VPWR VPWR sky130_fd_sc_hd__fill_1
X_7474_ _3686_ VGND VGND VPWR VPWR _1165_ sky130_fd_sc_hd__clkbuf_1
XFILLER_0_16_579 VGND VGND VPWR VPWR sky130_fd_sc_hd__decap_4
X_9213_ net169 _1300_ net202 VGND VGND VPWR VPWR u_register_bank.sensor_enable\[14\]
+ sky130_fd_sc_hd__dfrtp_1
X_4686_ _1819_ VGND VGND VPWR VPWR _0244_ sky130_fd_sc_hd__clkbuf_1
X_6425_ net490 _1390_ _2771_ VGND VGND VPWR VPWR _2774_ sky130_fd_sc_hd__mux2_1
XFILLER_0_31_538 VGND VGND VPWR VPWR sky130_fd_sc_hd__decap_3
XFILLER_0_113_275 VGND VGND VPWR VPWR sky130_fd_sc_hd__decap_4
X_6356_ _2737_ VGND VGND VPWR VPWR _0996_ sky130_fd_sc_hd__clkbuf_1
XFILLER_0_3_473 VGND VGND VPWR VPWR sky130_fd_sc_hd__decap_6
X_9144_ net174 _1232_ net206 VGND VGND VPWR VPWR u_register_bank.threshold_cfg\[26\]
+ sky130_fd_sc_hd__dfrtp_1
X_5307_ net389 _2008_ _2151_ VGND VGND VPWR VPWR _2161_ sky130_fd_sc_hd__mux2_1
X_9075_ clknet_leaf_49_clk _1163_ VGND VGND VPWR VPWR u_input_buffer.fifo_mem\[63\]\[5\]
+ sky130_fd_sc_hd__dfxtp_1
X_6287_ _2700_ VGND VGND VPWR VPWR _0964_ sky130_fd_sc_hd__clkbuf_1
X_8026_ clknet_leaf_5_clk _0115_ VGND VGND VPWR VPWR u_input_buffer.fifo_mem\[61\]\[0\]
+ sky130_fd_sc_hd__dfxtp_1
X_5238_ _2124_ VGND VGND VPWR VPWR _0491_ sky130_fd_sc_hd__clkbuf_1
X_5169_ _2087_ VGND VGND VPWR VPWR _0459_ sky130_fd_sc_hd__clkbuf_1
Xclkbuf_leaf_95_clk clknet_3_3__leaf_clk VGND VGND VPWR VPWR clknet_leaf_95_clk sky130_fd_sc_hd__clkbuf_16
XFILLER_0_78_251 VGND VGND VPWR VPWR sky130_fd_sc_hd__fill_1
X_8928_ clknet_leaf_0_clk _1017_ VGND VGND VPWR VPWR u_input_buffer.fifo_mem\[5\]\[6\]
+ sky130_fd_sc_hd__dfxtp_1
XFILLER_0_39_605 VGND VGND VPWR VPWR sky130_fd_sc_hd__decap_6
XPHY_224 VGND VGND VPWR VPWR sky130_fd_sc_hd__decap_3
XPHY_213 VGND VGND VPWR VPWR sky130_fd_sc_hd__decap_3
XPHY_202 VGND VGND VPWR VPWR sky130_fd_sc_hd__decap_3
X_8859_ clknet_leaf_21_clk _0948_ VGND VGND VPWR VPWR u_input_buffer.fifo_mem\[9\]\[1\]
+ sky130_fd_sc_hd__dfxtp_1
XFILLER_0_38_115 VGND VGND VPWR VPWR sky130_fd_sc_hd__fill_1
XFILLER_0_109_526 VGND VGND VPWR VPWR sky130_fd_sc_hd__decap_3
XFILLER_0_109_559 VGND VGND VPWR VPWR sky130_fd_sc_hd__fill_1
XFILLER_0_93_276 VGND VGND VPWR VPWR sky130_fd_sc_hd__fill_1
XFILLER_0_19_362 VGND VGND VPWR VPWR sky130_fd_sc_hd__decap_4
XFILLER_0_81_449 VGND VGND VPWR VPWR sky130_fd_sc_hd__fill_1
XFILLER_0_46_192 VGND VGND VPWR VPWR sky130_fd_sc_hd__decap_4
XFILLER_0_62_674 VGND VGND VPWR VPWR sky130_fd_sc_hd__decap_8
Xhold6 u_sample_counter.sample_count\[8\] VGND VGND VPWR VPWR net218 sky130_fd_sc_hd__dlygate4sd3_1
XFILLER_0_89_505 VGND VGND VPWR VPWR sky130_fd_sc_hd__decap_4
Xclkbuf_leaf_86_clk clknet_3_2__leaf_clk VGND VGND VPWR VPWR clknet_leaf_86_clk sky130_fd_sc_hd__clkbuf_16
XFILLER_0_84_221 VGND VGND VPWR VPWR sky130_fd_sc_hd__fill_1
XFILLER_0_115_518 VGND VGND VPWR VPWR sky130_fd_sc_hd__decap_3
XFILLER_0_111_55 VGND VGND VPWR VPWR sky130_fd_sc_hd__fill_1
XFILLER_0_105_3 VPWR VGND VPWR VGND sky130_ef_sc_hd__decap_12
XFILLER_0_25_376 VGND VGND VPWR VPWR sky130_fd_sc_hd__fill_1
X_4540_ _1377_ net967 _1738_ VGND VGND VPWR VPWR _1739_ sky130_fd_sc_hd__mux2_1
Xclkbuf_leaf_10_clk clknet_3_1__leaf_clk VGND VGND VPWR VPWR clknet_leaf_10_clk sky130_fd_sc_hd__clkbuf_16
Xhold417 u_input_buffer.fifo_mem\[14\]\[6\] VGND VGND VPWR VPWR net629 sky130_fd_sc_hd__dlygate4sd3_1
Xhold406 u_input_buffer.fifo_mem\[24\]\[2\] VGND VGND VPWR VPWR net618 sky130_fd_sc_hd__dlygate4sd3_1
X_4471_ net1251 _1620_ _1683_ VGND VGND VPWR VPWR _1693_ sky130_fd_sc_hd__mux2_1
XFILLER_0_20_64 VGND VGND VPWR VPWR sky130_fd_sc_hd__decap_6
Xhold439 u_input_buffer.fifo_mem\[52\]\[5\] VGND VGND VPWR VPWR net651 sky130_fd_sc_hd__dlygate4sd3_1
XFILLER_0_110_223 VGND VGND VPWR VPWR sky130_fd_sc_hd__decap_3
Xhold428 u_input_buffer.fifo_mem\[48\]\[10\] VGND VGND VPWR VPWR net640 sky130_fd_sc_hd__dlygate4sd3_1
X_7190_ u_input_buffer.fifo_mem\[21\]\[10\] _2908_ _2912_ u_input_buffer.fifo_mem\[25\]\[10\]
+ VGND VGND VPWR VPWR _3432_ sky130_fd_sc_hd__a22o_1
X_6210_ net796 _2526_ _2643_ VGND VGND VPWR VPWR _2659_ sky130_fd_sc_hd__mux2_1
XFILLER_0_40_357 VGND VGND VPWR VPWR sky130_fd_sc_hd__fill_1
X_6141_ _1630_ net1096 _2606_ VGND VGND VPWR VPWR _2622_ sky130_fd_sc_hd__mux2_1
XFILLER_0_0_454 VGND VGND VPWR VPWR sky130_fd_sc_hd__decap_8
XFILLER_0_21_571 VGND VGND VPWR VPWR sky130_fd_sc_hd__fill_2
XFILLER_0_21_582 VPWR VGND VPWR VGND sky130_ef_sc_hd__decap_12
XTAP_700 VGND VPWR sky130_fd_sc_hd__tapvpwrvgnd_1
XTAP_711 VGND VPWR sky130_fd_sc_hd__tapvpwrvgnd_1
XTAP_733 VGND VPWR sky130_fd_sc_hd__tapvpwrvgnd_1
XTAP_722 VGND VPWR sky130_fd_sc_hd__tapvpwrvgnd_1
Xhold1106 net159 VGND VGND VPWR VPWR net1318 sky130_fd_sc_hd__dlygate4sd3_1
XTAP_744 VGND VPWR sky130_fd_sc_hd__tapvpwrvgnd_1
XTAP_755 VGND VPWR sky130_fd_sc_hd__tapvpwrvgnd_1
XTAP_766 VGND VPWR sky130_fd_sc_hd__tapvpwrvgnd_1
XTAP_777 VGND VPWR sky130_fd_sc_hd__tapvpwrvgnd_1
X_6072_ _2584_ VGND VGND VPWR VPWR _0865_ sky130_fd_sc_hd__clkbuf_1
X_5023_ _1426_ VGND VGND VPWR VPWR _2006_ sky130_fd_sc_hd__buf_4
Xclkbuf_leaf_77_clk clknet_3_3__leaf_clk VGND VGND VPWR VPWR clknet_leaf_77_clk sky130_fd_sc_hd__clkbuf_16
XTAP_788 VGND VPWR sky130_fd_sc_hd__tapvpwrvgnd_1
XTAP_799 VGND VPWR sky130_fd_sc_hd__tapvpwrvgnd_1
X_6974_ u_input_buffer.fifo_mem\[47\]\[4\] _2880_ _3007_ _3009_ u_input_buffer.fifo_mem\[24\]\[4\]
+ VGND VGND VPWR VPWR _3222_ sky130_fd_sc_hd__a32o_1
X_5925_ _2499_ VGND VGND VPWR VPWR _0803_ sky130_fd_sc_hd__clkbuf_1
XFILLER_0_75_221 VGND VGND VPWR VPWR sky130_fd_sc_hd__decap_3
X_8713_ clknet_leaf_92_clk _0802_ VGND VGND VPWR VPWR u_input_buffer.fifo_mem\[19\]\[15\]
+ sky130_fd_sc_hd__dfxtp_1
X_5856_ _2462_ VGND VGND VPWR VPWR _0771_ sky130_fd_sc_hd__clkbuf_1
XFILLER_0_8_521 VGND VGND VPWR VPWR sky130_fd_sc_hd__decap_8
X_8644_ clknet_leaf_71_clk _0733_ VGND VGND VPWR VPWR u_input_buffer.fifo_mem\[23\]\[10\]
+ sky130_fd_sc_hd__dfxtp_1
X_4807_ _1884_ VGND VGND VPWR VPWR _0300_ sky130_fd_sc_hd__clkbuf_1
XFILLER_0_63_416 VGND VGND VPWR VPWR sky130_fd_sc_hd__fill_1
X_5787_ net949 _2240_ _2425_ VGND VGND VPWR VPWR _2426_ sky130_fd_sc_hd__mux2_1
X_8575_ clknet_leaf_46_clk _0664_ VGND VGND VPWR VPWR u_input_buffer.fifo_mem\[27\]\[5\]
+ sky130_fd_sc_hd__dfxtp_1
XFILLER_0_63_449 VGND VGND VPWR VPWR sky130_fd_sc_hd__decap_6
XFILLER_0_71_460 VGND VGND VPWR VPWR sky130_fd_sc_hd__fill_2
X_7526_ net17 u_register_bank.window_cfg\[14\] _3711_ VGND VGND VPWR VPWR _3716_ sky130_fd_sc_hd__mux2_1
X_4738_ net388 _1724_ _1835_ VGND VGND VPWR VPWR _1847_ sky130_fd_sc_hd__mux2_1
XFILLER_0_71_482 VGND VGND VPWR VPWR sky130_fd_sc_hd__fill_1
X_4669_ _1809_ VGND VGND VPWR VPWR _0237_ sky130_fd_sc_hd__clkbuf_1
X_7457_ _1592_ _1932_ VGND VGND VPWR VPWR _3677_ sky130_fd_sc_hd__nor2_4
X_6408_ _2764_ VGND VGND VPWR VPWR _1021_ sky130_fd_sc_hd__clkbuf_1
Xhold940 u_input_buffer.fifo_mem\[18\]\[12\] VGND VGND VPWR VPWR net1152 sky130_fd_sc_hd__dlygate4sd3_1
XFILLER_0_101_223 VGND VGND VPWR VPWR sky130_fd_sc_hd__fill_1
Xhold973 u_input_buffer.fifo_mem\[7\]\[2\] VGND VGND VPWR VPWR net1185 sky130_fd_sc_hd__dlygate4sd3_1
Xhold951 u_input_buffer.fifo_mem\[37\]\[5\] VGND VGND VPWR VPWR net1163 sky130_fd_sc_hd__dlygate4sd3_1
X_9127_ net174 _1215_ net206 VGND VGND VPWR VPWR u_analytics_engine.threshold\[9\]
+ sky130_fd_sc_hd__dfrtp_2
Xhold962 u_input_buffer.fifo_mem\[57\]\[12\] VGND VGND VPWR VPWR net1174 sky130_fd_sc_hd__dlygate4sd3_1
XFILLER_0_3_292 VGND VGND VPWR VPWR sky130_fd_sc_hd__fill_1
X_7388_ u_input_buffer.fifo_mem\[41\]\[15\] _2918_ _2920_ u_input_buffer.fifo_mem\[45\]\[15\]
+ _3624_ VGND VGND VPWR VPWR _3625_ sky130_fd_sc_hd__a221o_1
X_6339_ net1147 _2518_ _2716_ VGND VGND VPWR VPWR _2728_ sky130_fd_sc_hd__mux2_1
Xhold995 u_input_buffer.fifo_mem\[29\]\[4\] VGND VGND VPWR VPWR net1207 sky130_fd_sc_hd__dlygate4sd3_1
Xhold984 u_input_buffer.fifo_mem\[21\]\[1\] VGND VGND VPWR VPWR net1196 sky130_fd_sc_hd__dlygate4sd3_1
X_9058_ clknet_leaf_111_clk _1147_ VGND VGND VPWR VPWR u_sensor_interface.sensor_array\[3\]\[5\]
+ sky130_fd_sc_hd__dfxtp_1
X_8009_ clknet_leaf_76_clk _0098_ net190 VGND VGND VPWR VPWR u_analytics_engine.threshold_cross
+ sky130_fd_sc_hd__dfrtp_1
Xclkbuf_leaf_68_clk clknet_3_6__leaf_clk VGND VGND VPWR VPWR clknet_leaf_68_clk sky130_fd_sc_hd__clkbuf_16
XFILLER_0_98_368 VGND VGND VPWR VPWR sky130_fd_sc_hd__decap_3
XFILLER_0_81_202 VGND VGND VPWR VPWR sky130_fd_sc_hd__fill_1
XFILLER_0_26_129 VGND VGND VPWR VPWR sky130_fd_sc_hd__fill_2
XFILLER_0_35_641 VGND VGND VPWR VPWR sky130_fd_sc_hd__decap_3
Xclkbuf_leaf_59_clk clknet_3_7__leaf_clk VGND VGND VPWR VPWR clknet_leaf_59_clk sky130_fd_sc_hd__clkbuf_16
XFILLER_0_82_15 VPWR VGND VPWR VGND sky130_ef_sc_hd__decap_12
X_3971_ u_sensor_interface.sensor_array\[2\]\[11\] net83 _1334_ VGND VGND VPWR VPWR
+ _1336_ sky130_fd_sc_hd__mux2_1
X_5710_ _1628_ net1117 _2369_ VGND VGND VPWR VPWR _2384_ sky130_fd_sc_hd__mux2_1
XFILLER_0_72_202 VGND VGND VPWR VPWR sky130_fd_sc_hd__fill_2
X_6690_ _2894_ _2906_ VGND VGND VPWR VPWR _2942_ sky130_fd_sc_hd__nor2_4
XFILLER_0_45_427 VGND VGND VPWR VPWR sky130_fd_sc_hd__fill_1
XFILLER_0_115_315 VGND VGND VPWR VPWR sky130_fd_sc_hd__decap_3
X_5641_ _2347_ VGND VGND VPWR VPWR _0671_ sky130_fd_sc_hd__clkbuf_1
XFILLER_0_115_348 VGND VGND VPWR VPWR sky130_fd_sc_hd__fill_1
XFILLER_0_115_337 VGND VGND VPWR VPWR sky130_fd_sc_hd__fill_2
XFILLER_0_60_419 VGND VGND VPWR VPWR sky130_fd_sc_hd__fill_1
X_5572_ _2310_ VGND VGND VPWR VPWR _0639_ sky130_fd_sc_hd__clkbuf_1
X_8360_ clknet_leaf_100_clk _0449_ VGND VGND VPWR VPWR u_input_buffer.fifo_mem\[41\]\[14\]
+ sky130_fd_sc_hd__dfxtp_1
XFILLER_0_41_600 VGND VGND VPWR VPWR sky130_fd_sc_hd__decap_4
X_8291_ clknet_leaf_20_clk _0380_ VGND VGND VPWR VPWR u_input_buffer.fifo_mem\[45\]\[9\]
+ sky130_fd_sc_hd__dfxtp_1
X_7311_ u_input_buffer.fifo_mem\[53\]\[13\] _2933_ _2935_ u_input_buffer.fifo_mem\[57\]\[13\]
+ VGND VGND VPWR VPWR _3550_ sky130_fd_sc_hd__a22o_1
X_4523_ net405 _1726_ _1703_ VGND VGND VPWR VPWR _1727_ sky130_fd_sc_hd__mux2_1
Xhold214 u_input_buffer.fifo_mem\[44\]\[9\] VGND VGND VPWR VPWR net426 sky130_fd_sc_hd__dlygate4sd3_1
Xhold225 u_input_buffer.fifo_mem\[50\]\[7\] VGND VGND VPWR VPWR net437 sky130_fd_sc_hd__dlygate4sd3_1
XFILLER_0_79_6 VGND VGND VPWR VPWR sky130_fd_sc_hd__decap_8
X_7242_ u_input_buffer.fifo_mem\[12\]\[11\] _2979_ _2981_ u_input_buffer.fifo_mem\[18\]\[11\]
+ _3482_ VGND VGND VPWR VPWR _3483_ sky130_fd_sc_hd__a221o_1
Xhold203 u_input_buffer.fifo_mem\[56\]\[14\] VGND VGND VPWR VPWR net415 sky130_fd_sc_hd__dlygate4sd3_1
Xhold258 u_input_buffer.fifo_mem\[14\]\[0\] VGND VGND VPWR VPWR net470 sky130_fd_sc_hd__dlygate4sd3_1
X_4454_ _1684_ VGND VGND VPWR VPWR _0147_ sky130_fd_sc_hd__clkbuf_1
Xhold247 u_input_buffer.fifo_mem\[52\]\[3\] VGND VGND VPWR VPWR net459 sky130_fd_sc_hd__dlygate4sd3_1
Xhold236 u_sensor_interface.sensor_array\[3\]\[15\] VGND VGND VPWR VPWR net448 sky130_fd_sc_hd__dlygate4sd3_1
Xhold269 u_input_buffer.fifo_mem\[32\]\[11\] VGND VGND VPWR VPWR net481 sky130_fd_sc_hd__dlygate4sd3_1
X_7173_ u_input_buffer.fifo_mem\[30\]\[9\] _3029_ _3031_ u_input_buffer.fifo_mem\[58\]\[9\]
+ VGND VGND VPWR VPWR _3416_ sky130_fd_sc_hd__a22o_1
X_4385_ _1397_ net1233 _1641_ VGND VGND VPWR VPWR _1645_ sky130_fd_sc_hd__mux2_1
XTAP_530 VGND VPWR sky130_fd_sc_hd__tapvpwrvgnd_1
XTAP_541 VGND VPWR sky130_fd_sc_hd__tapvpwrvgnd_1
XTAP_552 VGND VPWR sky130_fd_sc_hd__tapvpwrvgnd_1
X_6124_ _2613_ VGND VGND VPWR VPWR _0888_ sky130_fd_sc_hd__clkbuf_1
X_6055_ net294 _2510_ _2569_ VGND VGND VPWR VPWR _2576_ sky130_fd_sc_hd__mux2_1
XTAP_574 VGND VPWR sky130_fd_sc_hd__tapvpwrvgnd_1
XTAP_563 VGND VPWR sky130_fd_sc_hd__tapvpwrvgnd_1
XTAP_585 VGND VPWR sky130_fd_sc_hd__tapvpwrvgnd_1
X_5006_ net1246 _1994_ _1990_ VGND VGND VPWR VPWR _1995_ sky130_fd_sc_hd__mux2_1
XTAP_596 VGND VPWR sky130_fd_sc_hd__tapvpwrvgnd_1
X_6957_ u_input_buffer.fifo_mem\[33\]\[4\] _2898_ _2904_ u_input_buffer.fifo_mem\[61\]\[4\]
+ _3204_ VGND VGND VPWR VPWR _3205_ sky130_fd_sc_hd__a221o_1
XFILLER_0_72_92 VGND VGND VPWR VPWR sky130_fd_sc_hd__fill_1
XFILLER_0_72_81 VGND VGND VPWR VPWR sky130_fd_sc_hd__decap_3
X_6888_ u_input_buffer.fifo_mem\[16\]\[2\] _2971_ _2973_ u_input_buffer.fifo_mem\[49\]\[2\]
+ _2975_ VGND VGND VPWR VPWR _3138_ sky130_fd_sc_hd__a221o_1
X_5908_ _2489_ VGND VGND VPWR VPWR _0796_ sky130_fd_sc_hd__clkbuf_1
XFILLER_0_91_555 VGND VGND VPWR VPWR sky130_fd_sc_hd__decap_4
XFILLER_0_91_533 VGND VGND VPWR VPWR sky130_fd_sc_hd__decap_3
X_8627_ clknet_leaf_65_clk _0716_ VGND VGND VPWR VPWR u_input_buffer.fifo_mem\[24\]\[9\]
+ sky130_fd_sc_hd__dfxtp_1
X_5839_ _1620_ net1260 _2443_ VGND VGND VPWR VPWR _2453_ sky130_fd_sc_hd__mux2_1
X_8558_ clknet_leaf_55_clk _0647_ VGND VGND VPWR VPWR u_input_buffer.fifo_mem\[28\]\[4\]
+ sky130_fd_sc_hd__dfxtp_1
XFILLER_0_17_663 VGND VGND VPWR VPWR sky130_fd_sc_hd__decap_8
X_7509_ net40 u_register_bank.window_cfg\[6\] _3700_ VGND VGND VPWR VPWR _3707_ sky130_fd_sc_hd__mux2_1
XFILLER_0_17_685 VGND VGND VPWR VPWR sky130_fd_sc_hd__fill_1
XFILLER_0_32_622 VGND VGND VPWR VPWR sky130_fd_sc_hd__fill_1
X_8489_ clknet_leaf_100_clk _0578_ VGND VGND VPWR VPWR u_input_buffer.fifo_mem\[33\]\[15\]
+ sky130_fd_sc_hd__dfxtp_1
Xhold770 u_input_buffer.fifo_mem\[1\]\[11\] VGND VGND VPWR VPWR net982 sky130_fd_sc_hd__dlygate4sd3_1
Xhold781 u_input_buffer.fifo_mem\[25\]\[9\] VGND VGND VPWR VPWR net993 sky130_fd_sc_hd__dlygate4sd3_1
Xhold792 u_input_buffer.fifo_mem\[57\]\[13\] VGND VGND VPWR VPWR net1004 sky130_fd_sc_hd__dlygate4sd3_1
XFILLER_0_86_338 VGND VGND VPWR VPWR sky130_fd_sc_hd__fill_1
XFILLER_0_67_541 VGND VGND VPWR VPWR sky130_fd_sc_hd__decap_3
XFILLER_0_27_405 VGND VGND VPWR VPWR sky130_fd_sc_hd__fill_1
XFILLER_0_27_449 VGND VGND VPWR VPWR sky130_fd_sc_hd__fill_2
XFILLER_0_109_186 VGND VGND VPWR VPWR sky130_fd_sc_hd__fill_2
XFILLER_0_77_26 VPWR VGND VPWR VGND sky130_ef_sc_hd__decap_12
XFILLER_0_50_485 VGND VGND VPWR VPWR sky130_fd_sc_hd__decap_4
X_4170_ net247 _1477_ VGND VGND VPWR VPWR _1479_ sky130_fd_sc_hd__nand2_1
XFILLER_0_93_69 VGND VGND VPWR VPWR sky130_fd_sc_hd__decap_8
X_7860_ net26 u_register_bank.sensor_enable\[22\] _3927_ VGND VGND VPWR VPWR _3930_
+ sky130_fd_sc_hd__mux2_1
X_6811_ u_input_buffer.fifo_mem\[15\]\[0\] _3060_ _3062_ u_input_buffer.fifo_mem\[43\]\[0\]
+ VGND VGND VPWR VPWR _3063_ sky130_fd_sc_hd__a22o_1
X_7791_ u_analytics_engine.data_valid VGND VGND VPWR VPWR _3893_ sky130_fd_sc_hd__buf_6
XFILLER_0_9_104 VGND VGND VPWR VPWR sky130_fd_sc_hd__fill_1
XFILLER_0_92_319 VGND VGND VPWR VPWR sky130_fd_sc_hd__decap_4
X_3954_ u_sensor_interface.sensor_array\[2\]\[3\] net74 _1323_ VGND VGND VPWR VPWR
+ _1327_ sky130_fd_sc_hd__mux2_1
XFILLER_0_58_585 VGND VGND VPWR VPWR sky130_fd_sc_hd__decap_3
XFILLER_0_9_137 VGND VGND VPWR VPWR sky130_fd_sc_hd__fill_2
X_6742_ _2900_ _2964_ VGND VGND VPWR VPWR _2994_ sky130_fd_sc_hd__nor2_4
XFILLER_0_85_393 VGND VGND VPWR VPWR sky130_fd_sc_hd__fill_2
X_6673_ _2911_ _2924_ VGND VGND VPWR VPWR _2925_ sky130_fd_sc_hd__and2_4
X_5624_ net303 _2252_ _2334_ VGND VGND VPWR VPWR _2339_ sky130_fd_sc_hd__mux2_1
X_8412_ clknet_leaf_21_clk _0501_ VGND VGND VPWR VPWR u_input_buffer.fifo_mem\[37\]\[2\]
+ sky130_fd_sc_hd__dfxtp_1
XFILLER_0_115_156 VGND VGND VPWR VPWR sky130_fd_sc_hd__decap_8
X_8343_ clknet_leaf_7_clk _0432_ VGND VGND VPWR VPWR u_input_buffer.fifo_mem\[42\]\[13\]
+ sky130_fd_sc_hd__dfxtp_1
X_5555_ _1403_ net1207 _2297_ VGND VGND VPWR VPWR _2302_ sky130_fd_sc_hd__mux2_1
XFILLER_0_41_430 VGND VGND VPWR VPWR sky130_fd_sc_hd__fill_1
X_4506_ _1715_ VGND VGND VPWR VPWR _0168_ sky130_fd_sc_hd__clkbuf_1
XFILLER_0_77_3 VGND VGND VPWR VPWR sky130_fd_sc_hd__decap_6
X_8274_ clknet_leaf_41_clk _0363_ VGND VGND VPWR VPWR u_input_buffer.fifo_mem\[46\]\[8\]
+ sky130_fd_sc_hd__dfxtp_1
X_5486_ net656 _2260_ _2244_ VGND VGND VPWR VPWR _2261_ sky130_fd_sc_hd__mux2_1
XFILLER_0_111_340 VGND VGND VPWR VPWR sky130_fd_sc_hd__fill_2
X_4437_ net802 _1624_ _1660_ VGND VGND VPWR VPWR _1673_ sky130_fd_sc_hd__mux2_1
X_7225_ _3460_ _3462_ _3464_ _3466_ VGND VGND VPWR VPWR _3467_ sky130_fd_sc_hd__or4_1
XFILLER_0_6_73 VGND VGND VPWR VPWR sky130_fd_sc_hd__fill_2
X_7156_ u_input_buffer.fifo_mem\[17\]\[9\] _2943_ _2945_ u_input_buffer.fifo_mem\[5\]\[9\]
+ VGND VGND VPWR VPWR _3399_ sky130_fd_sc_hd__a22o_1
XTAP_360 VGND VPWR sky130_fd_sc_hd__tapvpwrvgnd_1
X_4368_ u_input_buffer.data_in\[15\] VGND VGND VPWR VPWR _1632_ sky130_fd_sc_hd__clkbuf_4
X_6107_ net565 _2528_ _2586_ VGND VGND VPWR VPWR _2603_ sky130_fd_sc_hd__mux2_1
X_4299_ u_analytics_engine.threshold\[1\] _1576_ _1578_ VGND VGND VPWR VPWR _1579_
+ sky130_fd_sc_hd__a21bo_1
X_7087_ u_input_buffer.fifo_mem\[50\]\[7\] _2995_ _2997_ u_input_buffer.fifo_mem\[4\]\[7\]
+ VGND VGND VPWR VPWR _3332_ sky130_fd_sc_hd__a22o_1
XTAP_393 VGND VPWR sky130_fd_sc_hd__tapvpwrvgnd_1
XTAP_382 VGND VPWR sky130_fd_sc_hd__tapvpwrvgnd_1
XTAP_371 VGND VPWR sky130_fd_sc_hd__tapvpwrvgnd_1
X_6038_ _2565_ VGND VGND VPWR VPWR _0850_ sky130_fd_sc_hd__clkbuf_1
XFILLER_0_96_614 VGND VGND VPWR VPWR sky130_fd_sc_hd__decap_6
XFILLER_0_96_603 VGND VGND VPWR VPWR sky130_fd_sc_hd__decap_8
XTAP_1515 VGND VPWR sky130_fd_sc_hd__tapvpwrvgnd_1
XTAP_1504 VGND VPWR sky130_fd_sc_hd__tapvpwrvgnd_1
XFILLER_0_95_113 VGND VGND VPWR VPWR sky130_fd_sc_hd__fill_1
XPHY_22 VGND VGND VPWR VPWR sky130_fd_sc_hd__decap_3
XPHY_11 VGND VGND VPWR VPWR sky130_fd_sc_hd__decap_3
XTAP_1548 VGND VPWR sky130_fd_sc_hd__tapvpwrvgnd_1
XTAP_1537 VGND VPWR sky130_fd_sc_hd__tapvpwrvgnd_1
XTAP_1526 VGND VPWR sky130_fd_sc_hd__tapvpwrvgnd_1
XPHY_33 VGND VGND VPWR VPWR sky130_fd_sc_hd__decap_3
XPHY_44 VGND VGND VPWR VPWR sky130_fd_sc_hd__decap_3
XPHY_55 VGND VGND VPWR VPWR sky130_fd_sc_hd__decap_3
X_7989_ clknet_leaf_80_clk _0078_ net191 VGND VGND VPWR VPWR u_sample_counter.sample_count\[12\]
+ sky130_fd_sc_hd__dfrtp_1
XTAP_1559 VGND VPWR sky130_fd_sc_hd__tapvpwrvgnd_1
XFILLER_0_83_319 VGND VGND VPWR VPWR sky130_fd_sc_hd__fill_1
XPHY_66 VGND VGND VPWR VPWR sky130_fd_sc_hd__decap_3
XPHY_77 VGND VGND VPWR VPWR sky130_fd_sc_hd__decap_3
XPHY_88 VGND VGND VPWR VPWR sky130_fd_sc_hd__decap_3
XFILLER_0_9_671 VGND VGND VPWR VPWR sky130_fd_sc_hd__fill_1
XPHY_99 VGND VGND VPWR VPWR sky130_fd_sc_hd__decap_3
XFILLER_0_91_363 VGND VGND VPWR VPWR sky130_fd_sc_hd__fill_1
XFILLER_0_24_419 VGND VGND VPWR VPWR sky130_fd_sc_hd__fill_1
XFILLER_0_20_625 VGND VGND VPWR VPWR sky130_fd_sc_hd__fill_1
XFILLER_0_67_393 VGND VGND VPWR VPWR sky130_fd_sc_hd__fill_2
XFILLER_0_82_363 VGND VGND VPWR VPWR sky130_fd_sc_hd__fill_1
XFILLER_0_70_558 VPWR VGND VPWR VGND sky130_ef_sc_hd__decap_12
X_5340_ _2178_ VGND VGND VPWR VPWR _0539_ sky130_fd_sc_hd__clkbuf_1
Xoutput116 net116 VGND VGND VPWR VPWR cfg_rdata[11] sky130_fd_sc_hd__buf_2
Xoutput127 net127 VGND VGND VPWR VPWR cfg_rdata[21] sky130_fd_sc_hd__clkbuf_4
Xoutput149 net149 VGND VGND VPWR VPWR processed_data_out[10] sky130_fd_sc_hd__buf_2
X_5271_ _1427_ net1049 _2133_ VGND VGND VPWR VPWR _2142_ sky130_fd_sc_hd__mux2_1
Xoutput138 net138 VGND VGND VPWR VPWR cfg_rdata[31] sky130_fd_sc_hd__clkbuf_4
X_7010_ u_input_buffer.fifo_mem\[51\]\[5\] _2990_ _2993_ u_input_buffer.fifo_mem\[11\]\[5\]
+ _3256_ VGND VGND VPWR VPWR _3257_ sky130_fd_sc_hd__a221o_1
X_4222_ u_sample_counter.sample_count\[19\] _1507_ _1512_ VGND VGND VPWR VPWR _1513_
+ sky130_fd_sc_hd__and3_1
X_4153_ _1463_ _1466_ _1320_ VGND VGND VPWR VPWR _1467_ sky130_fd_sc_hd__mux2_1
X_8961_ clknet_leaf_40_clk _1050_ VGND VGND VPWR VPWR u_input_buffer.fifo_mem\[3\]\[7\]
+ sky130_fd_sc_hd__dfxtp_1
X_4084_ _1407_ VGND VGND VPWR VPWR _0054_ sky130_fd_sc_hd__clkbuf_1
X_7912_ clknet_leaf_31_clk _0002_ VGND VGND VPWR VPWR u_sensor_interface.sensor_array\[2\]\[0\]
+ sky130_fd_sc_hd__dfxtp_1
X_8892_ clknet_leaf_54_clk _0981_ VGND VGND VPWR VPWR u_input_buffer.fifo_mem\[7\]\[2\]
+ sky130_fd_sc_hd__dfxtp_1
XFILLER_0_77_113 VGND VGND VPWR VPWR sky130_fd_sc_hd__decap_3
XFILLER_0_77_157 VGND VGND VPWR VPWR sky130_fd_sc_hd__decap_3
X_7843_ net17 u_register_bank.sensor_enable\[14\] _3916_ VGND VGND VPWR VPWR _3921_
+ sky130_fd_sc_hd__mux2_1
XFILLER_0_93_617 VGND VGND VPWR VPWR sky130_fd_sc_hd__decap_6
X_4986_ _1982_ VGND VGND VPWR VPWR _0381_ sky130_fd_sc_hd__clkbuf_1
X_7774_ _3883_ VGND VGND VPWR VPWR _1268_ sky130_fd_sc_hd__clkbuf_1
X_6725_ u_input_buffer.fifo_mem\[34\]\[0\] _2966_ _2969_ u_input_buffer.fifo_mem\[48\]\[0\]
+ _2976_ VGND VGND VPWR VPWR _2977_ sky130_fd_sc_hd__a221o_1
XFILLER_0_85_190 VGND VGND VPWR VPWR sky130_fd_sc_hd__decap_4
XFILLER_0_61_525 VGND VGND VPWR VPWR sky130_fd_sc_hd__decap_6
X_6656_ _2906_ _2907_ VGND VGND VPWR VPWR _2908_ sky130_fd_sc_hd__nor2_4
XFILLER_0_61_547 VGND VGND VPWR VPWR sky130_fd_sc_hd__fill_1
X_6587_ net280 _1468_ _2842_ VGND VGND VPWR VPWR _2859_ sky130_fd_sc_hd__mux2_1
X_5607_ net329 _2270_ _2314_ VGND VGND VPWR VPWR _2329_ sky130_fd_sc_hd__mux2_1
X_5538_ _2291_ VGND VGND VPWR VPWR _0624_ sky130_fd_sc_hd__clkbuf_1
X_8326_ clknet_leaf_96_clk _0415_ VGND VGND VPWR VPWR u_input_buffer.fifo_mem\[43\]\[12\]
+ sky130_fd_sc_hd__dfxtp_1
X_8257_ clknet_leaf_66_clk _0346_ VGND VGND VPWR VPWR u_input_buffer.fifo_mem\[47\]\[7\]
+ sky130_fd_sc_hd__dfxtp_1
X_5469_ _2249_ VGND VGND VPWR VPWR _0597_ sky130_fd_sc_hd__clkbuf_1
X_7208_ u_input_buffer.fifo_mem\[47\]\[10\] _2879_ _2917_ _3008_ u_input_buffer.fifo_mem\[24\]\[10\]
+ VGND VGND VPWR VPWR _3450_ sky130_fd_sc_hd__a32o_1
X_8188_ clknet_leaf_31_clk _0277_ VGND VGND VPWR VPWR u_input_buffer.fifo_mem\[51\]\[2\]
+ sky130_fd_sc_hd__dfxtp_1
X_7139_ u_input_buffer.fifo_mem\[39\]\[8\] _3050_ _3052_ u_input_buffer.fifo_mem\[40\]\[8\]
+ VGND VGND VPWR VPWR _3383_ sky130_fd_sc_hd__a22o_1
XFILLER_0_69_614 VGND VGND VPWR VPWR sky130_fd_sc_hd__fill_2
XTAP_1323 VGND VPWR sky130_fd_sc_hd__tapvpwrvgnd_1
XTAP_1312 VGND VPWR sky130_fd_sc_hd__tapvpwrvgnd_1
XTAP_1301 VGND VPWR sky130_fd_sc_hd__tapvpwrvgnd_1
XTAP_1356 VGND VPWR sky130_fd_sc_hd__tapvpwrvgnd_1
XTAP_1345 VGND VPWR sky130_fd_sc_hd__tapvpwrvgnd_1
XTAP_1334 VGND VPWR sky130_fd_sc_hd__tapvpwrvgnd_1
XTAP_1389 VGND VPWR sky130_fd_sc_hd__tapvpwrvgnd_1
XTAP_1378 VGND VPWR sky130_fd_sc_hd__tapvpwrvgnd_1
XTAP_1367 VGND VPWR sky130_fd_sc_hd__tapvpwrvgnd_1
XFILLER_0_64_341 VGND VGND VPWR VPWR sky130_fd_sc_hd__fill_1
XFILLER_0_92_672 VGND VGND VPWR VPWR sky130_fd_sc_hd__decap_8
XFILLER_0_64_396 VPWR VGND VPWR VGND sky130_ef_sc_hd__decap_12
XFILLER_0_64_385 VGND VGND VPWR VPWR sky130_fd_sc_hd__decap_8
XFILLER_0_64_363 VGND VGND VPWR VPWR sky130_fd_sc_hd__fill_1
Xinput18 cfg_wdata[15] VGND VGND VPWR VPWR net18 sky130_fd_sc_hd__buf_2
XFILLER_0_24_205 VGND VGND VPWR VPWR sky130_fd_sc_hd__fill_1
Xinput29 cfg_wdata[25] VGND VGND VPWR VPWR net29 sky130_fd_sc_hd__buf_2
XFILLER_0_74_16 VGND VGND VPWR VPWR sky130_fd_sc_hd__decap_4
XFILLER_0_99_271 VGND VGND VPWR VPWR sky130_fd_sc_hd__fill_1
XFILLER_0_90_15 VPWR VGND VPWR VGND sky130_ef_sc_hd__decap_12
XFILLER_0_75_617 VGND VGND VPWR VPWR sky130_fd_sc_hd__decap_8
X_4840_ _1902_ VGND VGND VPWR VPWR _0315_ sky130_fd_sc_hd__clkbuf_1
XFILLER_0_47_319 VGND VGND VPWR VPWR sky130_fd_sc_hd__decap_4
XFILLER_0_28_533 VGND VGND VPWR VPWR sky130_fd_sc_hd__decap_3
XFILLER_0_83_661 VGND VGND VPWR VPWR sky130_fd_sc_hd__decap_8
X_4771_ net537 _1722_ _1855_ VGND VGND VPWR VPWR _1865_ sky130_fd_sc_hd__mux2_1
X_6510_ _2818_ VGND VGND VPWR VPWR _1069_ sky130_fd_sc_hd__clkbuf_1
X_7490_ _3694_ VGND VGND VPWR VPWR _1173_ sky130_fd_sc_hd__clkbuf_1
XFILLER_0_99_57 VPWR VGND VPWR VGND sky130_ef_sc_hd__decap_12
XFILLER_0_70_333 VGND VGND VPWR VPWR sky130_fd_sc_hd__fill_1
X_6441_ net317 _1438_ _2770_ VGND VGND VPWR VPWR _2782_ sky130_fd_sc_hd__mux2_1
X_6372_ _2745_ VGND VGND VPWR VPWR _1004_ sky130_fd_sc_hd__clkbuf_1
X_9160_ net171 _1248_ VGND VGND VPWR VPWR net115 sky130_fd_sc_hd__dfxtp_1
X_8111_ clknet_leaf_51_clk _0200_ VGND VGND VPWR VPWR u_input_buffer.fifo_mem\[56\]\[5\]
+ sky130_fd_sc_hd__dfxtp_1
X_5323_ net771 _1988_ _2169_ VGND VGND VPWR VPWR _2170_ sky130_fd_sc_hd__mux2_1
X_9091_ net179 _1179_ net210 VGND VGND VPWR VPWR u_register_bank.window_cfg\[5\] sky130_fd_sc_hd__dfrtp_1
X_8042_ clknet_leaf_40_clk _0131_ VGND VGND VPWR VPWR u_input_buffer.fifo_mem\[60\]\[0\]
+ sky130_fd_sc_hd__dfxtp_1
XFILLER_0_11_499 VGND VGND VPWR VPWR sky130_fd_sc_hd__decap_4
X_5254_ _2132_ VGND VGND VPWR VPWR _2133_ sky130_fd_sc_hd__buf_4
X_4205_ u_sample_counter.sample_count\[12\] u_sample_counter.sample_count\[13\] u_sample_counter.sample_count\[14\]
+ _1494_ u_sample_counter.sample_count\[15\] VGND VGND VPWR VPWR _1502_ sky130_fd_sc_hd__a41o_1
X_5185_ _2095_ VGND VGND VPWR VPWR _2096_ sky130_fd_sc_hd__clkbuf_4
X_4136_ u_sensor_interface.sensor_array\[0\]\[12\] u_sensor_interface.sensor_array\[1\]\[12\]
+ net111 VGND VGND VPWR VPWR _1452_ sky130_fd_sc_hd__mux2_1
X_4067_ _1392_ u_sensor_interface.sensor_array\[2\]\[2\] _1379_ VGND VGND VPWR VPWR
+ _1393_ sky130_fd_sc_hd__mux2_1
X_8944_ clknet_leaf_38_clk _1033_ VGND VGND VPWR VPWR u_input_buffer.fifo_mem\[4\]\[6\]
+ sky130_fd_sc_hd__dfxtp_1
X_8875_ clknet_leaf_66_clk _0964_ VGND VGND VPWR VPWR u_input_buffer.fifo_mem\[8\]\[1\]
+ sky130_fd_sc_hd__dfxtp_1
X_7826_ net40 u_register_bank.sensor_enable\[6\] _3905_ VGND VGND VPWR VPWR _3912_
+ sky130_fd_sc_hd__mux2_1
XFILLER_0_80_70 VGND VGND VPWR VPWR sky130_fd_sc_hd__fill_2
X_4969_ _1391_ net785 _1971_ VGND VGND VPWR VPWR _1974_ sky130_fd_sc_hd__mux2_1
X_7757_ _3870_ net132 _3852_ VGND VGND VPWR VPWR _3871_ sky130_fd_sc_hd__mux2_1
XFILLER_0_80_108 VGND VGND VPWR VPWR sky130_fd_sc_hd__fill_1
X_7688_ _3816_ net115 _3817_ VGND VGND VPWR VPWR _3818_ sky130_fd_sc_hd__mux2_1
X_6708_ _2895_ _2959_ VGND VGND VPWR VPWR _2960_ sky130_fd_sc_hd__nor2_4
XFILLER_0_73_182 VGND VGND VPWR VPWR sky130_fd_sc_hd__decap_6
X_6639_ net248 _2891_ VGND VGND VPWR VPWR _1125_ sky130_fd_sc_hd__xnor2_1
XFILLER_0_104_457 VGND VGND VPWR VPWR sky130_fd_sc_hd__fill_2
X_8309_ clknet_leaf_95_clk _0398_ VGND VGND VPWR VPWR u_input_buffer.fifo_mem\[44\]\[11\]
+ sky130_fd_sc_hd__dfxtp_1
XFILLER_0_100_641 VGND VGND VPWR VPWR sky130_fd_sc_hd__decap_3
XFILLER_0_100_685 VGND VGND VPWR VPWR sky130_fd_sc_hd__fill_1
Xfanout173 net183 VGND VGND VPWR VPWR net173 sky130_fd_sc_hd__buf_2
Xfanout195 net196 VGND VGND VPWR VPWR net195 sky130_fd_sc_hd__clkbuf_4
Xfanout184 net186 VGND VGND VPWR VPWR net184 sky130_fd_sc_hd__buf_4
XFILLER_0_69_433 VGND VGND VPWR VPWR sky130_fd_sc_hd__fill_1
XTAP_1131 VGND VPWR sky130_fd_sc_hd__tapvpwrvgnd_1
XTAP_1120 VGND VPWR sky130_fd_sc_hd__tapvpwrvgnd_1
XFILLER_0_29_319 VGND VGND VPWR VPWR sky130_fd_sc_hd__fill_1
XTAP_1164 VGND VPWR sky130_fd_sc_hd__tapvpwrvgnd_1
XTAP_1153 VGND VPWR sky130_fd_sc_hd__tapvpwrvgnd_1
XTAP_1142 VGND VPWR sky130_fd_sc_hd__tapvpwrvgnd_1
XTAP_1197 VGND VPWR sky130_fd_sc_hd__tapvpwrvgnd_1
XTAP_1186 VGND VPWR sky130_fd_sc_hd__tapvpwrvgnd_1
XTAP_1175 VGND VPWR sky130_fd_sc_hd__tapvpwrvgnd_1
XFILLER_0_65_661 VGND VGND VPWR VPWR sky130_fd_sc_hd__fill_1
XFILLER_0_60_29 VGND VGND VPWR VPWR sky130_fd_sc_hd__fill_1
XFILLER_0_25_503 VGND VGND VPWR VPWR sky130_fd_sc_hd__fill_1
XFILLER_0_107_251 VGND VGND VPWR VPWR sky130_fd_sc_hd__fill_1
XFILLER_0_69_27 VGND VGND VPWR VPWR sky130_fd_sc_hd__decap_6
XFILLER_0_110_438 VGND VGND VPWR VPWR sky130_fd_sc_hd__decap_3
XFILLER_0_0_625 VGND VGND VPWR VPWR sky130_fd_sc_hd__fill_1
XTAP_926 VGND VPWR sky130_fd_sc_hd__tapvpwrvgnd_1
XTAP_915 VGND VPWR sky130_fd_sc_hd__tapvpwrvgnd_1
XTAP_904 VGND VPWR sky130_fd_sc_hd__tapvpwrvgnd_1
XTAP_959 VGND VPWR sky130_fd_sc_hd__tapvpwrvgnd_1
XTAP_948 VGND VPWR sky130_fd_sc_hd__tapvpwrvgnd_1
XTAP_937 VGND VPWR sky130_fd_sc_hd__tapvpwrvgnd_1
XFILLER_0_109_55 VGND VGND VPWR VPWR sky130_fd_sc_hd__fill_1
X_6990_ u_input_buffer.fifo_mem\[63\]\[4\] _2887_ _3076_ u_input_buffer.fifo_mem\[55\]\[4\]
+ _3237_ VGND VGND VPWR VPWR _3238_ sky130_fd_sc_hd__a221o_1
X_5941_ _1414_ VGND VGND VPWR VPWR _2510_ sky130_fd_sc_hd__buf_4
XFILLER_0_75_403 VGND VGND VPWR VPWR sky130_fd_sc_hd__fill_1
XFILLER_0_34_63 VGND VGND VPWR VPWR sky130_fd_sc_hd__fill_1
X_5872_ _2470_ VGND VGND VPWR VPWR _0779_ sky130_fd_sc_hd__clkbuf_1
X_8660_ clknet_leaf_85_clk _0749_ VGND VGND VPWR VPWR u_input_buffer.fifo_mem\[22\]\[10\]
+ sky130_fd_sc_hd__dfxtp_1
XFILLER_0_47_138 VGND VGND VPWR VPWR sky130_fd_sc_hd__decap_4
X_4823_ _1377_ net1266 _1893_ VGND VGND VPWR VPWR _1894_ sky130_fd_sc_hd__mux2_1
X_8591_ clknet_leaf_45_clk _0680_ VGND VGND VPWR VPWR u_input_buffer.fifo_mem\[26\]\[5\]
+ sky130_fd_sc_hd__dfxtp_1
X_7611_ _3761_ VGND VGND VPWR VPWR _1227_ sky130_fd_sc_hd__clkbuf_1
XFILLER_0_63_609 VGND VGND VPWR VPWR sky130_fd_sc_hd__fill_1
X_4754_ _1856_ VGND VGND VPWR VPWR _0275_ sky130_fd_sc_hd__clkbuf_1
X_7542_ _3724_ VGND VGND VPWR VPWR _1195_ sky130_fd_sc_hd__clkbuf_1
XFILLER_0_28_363 VGND VGND VPWR VPWR sky130_fd_sc_hd__fill_1
X_7473_ net725 _1420_ _3678_ VGND VGND VPWR VPWR _3686_ sky130_fd_sc_hd__mux2_1
XFILLER_0_70_141 VGND VGND VPWR VPWR sky130_fd_sc_hd__fill_1
X_9212_ net171 _1299_ net204 VGND VGND VPWR VPWR u_register_bank.sensor_enable\[13\]
+ sky130_fd_sc_hd__dfrtp_1
X_4685_ _1385_ net1100 _1817_ VGND VGND VPWR VPWR _1819_ sky130_fd_sc_hd__mux2_1
X_6424_ _2773_ VGND VGND VPWR VPWR _1028_ sky130_fd_sc_hd__clkbuf_1
XFILLER_0_24_580 VGND VGND VPWR VPWR sky130_fd_sc_hd__fill_1
XFILLER_0_43_399 VGND VGND VPWR VPWR sky130_fd_sc_hd__fill_1
X_6355_ net461 _2500_ _2735_ VGND VGND VPWR VPWR _2737_ sky130_fd_sc_hd__mux2_1
XFILLER_0_101_427 VGND VGND VPWR VPWR sky130_fd_sc_hd__decap_4
X_9143_ net178 _1231_ net212 VGND VGND VPWR VPWR u_register_bank.threshold_cfg\[25\]
+ sky130_fd_sc_hd__dfrtp_1
XFILLER_0_11_241 VGND VGND VPWR VPWR sky130_fd_sc_hd__decap_3
X_5306_ _2160_ VGND VGND VPWR VPWR _0523_ sky130_fd_sc_hd__clkbuf_1
X_9074_ clknet_leaf_44_clk _1162_ VGND VGND VPWR VPWR u_input_buffer.fifo_mem\[63\]\[4\]
+ sky130_fd_sc_hd__dfxtp_1
X_6286_ net574 _2500_ _2698_ VGND VGND VPWR VPWR _2700_ sky130_fd_sc_hd__mux2_1
XFILLER_0_11_274 VGND VGND VPWR VPWR sky130_fd_sc_hd__decap_3
X_5237_ net1269 _2006_ _2115_ VGND VGND VPWR VPWR _2124_ sky130_fd_sc_hd__mux2_1
X_8025_ clknet_leaf_87_clk _0114_ VGND VGND VPWR VPWR u_input_buffer.fifo_mem\[62\]\[15\]
+ sky130_fd_sc_hd__dfxtp_1
X_5168_ net610 _2006_ _2078_ VGND VGND VPWR VPWR _2087_ sky130_fd_sc_hd__mux2_1
X_5099_ _2050_ VGND VGND VPWR VPWR _0426_ sky130_fd_sc_hd__clkbuf_1
X_4119_ _1437_ VGND VGND VPWR VPWR _0059_ sky130_fd_sc_hd__clkbuf_1
XFILLER_0_78_230 VGND VGND VPWR VPWR sky130_fd_sc_hd__fill_1
X_8927_ clknet_leaf_111_clk _1016_ VGND VGND VPWR VPWR u_input_buffer.fifo_mem\[5\]\[5\]
+ sky130_fd_sc_hd__dfxtp_1
XPHY_225 VGND VGND VPWR VPWR sky130_fd_sc_hd__decap_3
XFILLER_0_109_505 VGND VGND VPWR VPWR sky130_fd_sc_hd__fill_1
XPHY_214 VGND VGND VPWR VPWR sky130_fd_sc_hd__decap_3
XPHY_203 VGND VGND VPWR VPWR sky130_fd_sc_hd__decap_3
XFILLER_0_93_222 VGND VGND VPWR VPWR sky130_fd_sc_hd__fill_2
X_8858_ clknet_leaf_22_clk _0947_ VGND VGND VPWR VPWR u_input_buffer.fifo_mem\[9\]\[0\]
+ sky130_fd_sc_hd__dfxtp_1
XFILLER_0_39_639 VGND VGND VPWR VPWR sky130_fd_sc_hd__decap_4
XFILLER_0_19_330 VGND VGND VPWR VPWR sky130_fd_sc_hd__decap_3
X_7809_ _3902_ VGND VGND VPWR VPWR _1284_ sky130_fd_sc_hd__clkbuf_1
X_8789_ clknet_leaf_10_clk _0878_ VGND VGND VPWR VPWR u_input_buffer.fifo_mem\[14\]\[11\]
+ sky130_fd_sc_hd__dfxtp_1
XFILLER_0_62_642 VGND VGND VPWR VPWR sky130_fd_sc_hd__fill_2
XFILLER_0_104_221 VGND VGND VPWR VPWR sky130_fd_sc_hd__fill_2
XFILLER_0_22_517 VGND VGND VPWR VPWR sky130_fd_sc_hd__decap_4
XFILLER_0_34_388 VGND VGND VPWR VPWR sky130_fd_sc_hd__fill_1
Xhold7 u_sample_counter.sample_count\[30\] VGND VGND VPWR VPWR net219 sky130_fd_sc_hd__dlygate4sd3_1
XFILLER_0_29_116 VGND VGND VPWR VPWR sky130_fd_sc_hd__fill_2
XFILLER_0_57_447 VGND VGND VPWR VPWR sky130_fd_sc_hd__fill_1
XFILLER_0_84_288 VGND VGND VPWR VPWR sky130_fd_sc_hd__fill_1
XFILLER_0_72_417 VGND VGND VPWR VPWR sky130_fd_sc_hd__decap_3
XFILLER_0_44_108 VGND VGND VPWR VPWR sky130_fd_sc_hd__fill_2
XFILLER_0_20_32 VGND VGND VPWR VPWR sky130_fd_sc_hd__decap_3
Xhold418 u_input_buffer.fifo_mem\[10\]\[7\] VGND VGND VPWR VPWR net630 sky130_fd_sc_hd__dlygate4sd3_1
Xhold407 u_input_buffer.fifo_mem\[58\]\[7\] VGND VGND VPWR VPWR net619 sky130_fd_sc_hd__dlygate4sd3_1
X_4470_ _1692_ VGND VGND VPWR VPWR _0155_ sky130_fd_sc_hd__clkbuf_1
XFILLER_0_20_54 VGND VGND VPWR VPWR sky130_fd_sc_hd__decap_3
Xhold429 u_input_buffer.fifo_mem\[16\]\[8\] VGND VGND VPWR VPWR net641 sky130_fd_sc_hd__dlygate4sd3_1
XFILLER_0_110_235 VGND VGND VPWR VPWR sky130_fd_sc_hd__fill_1
X_6140_ _2621_ VGND VGND VPWR VPWR _0896_ sky130_fd_sc_hd__clkbuf_1
XFILLER_0_0_433 VGND VGND VPWR VPWR sky130_fd_sc_hd__fill_2
XTAP_701 VGND VPWR sky130_fd_sc_hd__tapvpwrvgnd_1
XFILLER_0_0_477 VGND VGND VPWR VPWR sky130_fd_sc_hd__fill_2
XFILLER_0_21_594 VGND VGND VPWR VPWR sky130_fd_sc_hd__fill_2
XTAP_712 VGND VPWR sky130_fd_sc_hd__tapvpwrvgnd_1
XTAP_734 VGND VPWR sky130_fd_sc_hd__tapvpwrvgnd_1
XTAP_723 VGND VPWR sky130_fd_sc_hd__tapvpwrvgnd_1
XTAP_745 VGND VPWR sky130_fd_sc_hd__tapvpwrvgnd_1
XTAP_756 VGND VPWR sky130_fd_sc_hd__tapvpwrvgnd_1
XTAP_767 VGND VPWR sky130_fd_sc_hd__tapvpwrvgnd_1
X_6071_ net675 _2526_ _2568_ VGND VGND VPWR VPWR _2584_ sky130_fd_sc_hd__mux2_1
X_5022_ _2005_ VGND VGND VPWR VPWR _0394_ sky130_fd_sc_hd__clkbuf_1
Xhold1107 u_sensor_interface.sensor_array\[2\]\[13\] VGND VGND VPWR VPWR net1319 sky130_fd_sc_hd__dlygate4sd3_1
XTAP_778 VGND VPWR sky130_fd_sc_hd__tapvpwrvgnd_1
XTAP_789 VGND VPWR sky130_fd_sc_hd__tapvpwrvgnd_1
X_6973_ _3205_ _3207_ _3211_ _3220_ VGND VGND VPWR VPWR _3221_ sky130_fd_sc_hd__or4_4
X_5924_ net524 _2496_ _2498_ VGND VGND VPWR VPWR _2499_ sky130_fd_sc_hd__mux2_1
XFILLER_0_75_200 VGND VGND VPWR VPWR sky130_fd_sc_hd__fill_2
XFILLER_0_0_42 VGND VGND VPWR VPWR sky130_fd_sc_hd__decap_8
XFILLER_0_0_20 VGND VGND VPWR VPWR sky130_fd_sc_hd__decap_8
X_8712_ clknet_leaf_80_clk _0801_ VGND VGND VPWR VPWR u_input_buffer.fifo_mem\[19\]\[14\]
+ sky130_fd_sc_hd__dfxtp_1
X_5855_ net960 _2240_ _2461_ VGND VGND VPWR VPWR _2462_ sky130_fd_sc_hd__mux2_1
X_8643_ clknet_leaf_53_clk _0732_ VGND VGND VPWR VPWR u_input_buffer.fifo_mem\[23\]\[9\]
+ sky130_fd_sc_hd__dfxtp_1
XFILLER_0_48_447 VGND VGND VPWR VPWR sky130_fd_sc_hd__fill_2
XFILLER_0_48_458 VGND VGND VPWR VPWR sky130_fd_sc_hd__fill_2
XFILLER_0_75_277 VGND VGND VPWR VPWR sky130_fd_sc_hd__decap_3
X_4806_ net691 _1722_ _1874_ VGND VGND VPWR VPWR _1884_ sky130_fd_sc_hd__mux2_1
XFILLER_0_8_533 VGND VGND VPWR VPWR sky130_fd_sc_hd__decap_4
X_8574_ clknet_leaf_68_clk _0663_ VGND VGND VPWR VPWR u_input_buffer.fifo_mem\[27\]\[4\]
+ sky130_fd_sc_hd__dfxtp_1
XFILLER_0_56_491 VGND VGND VPWR VPWR sky130_fd_sc_hd__fill_2
X_5786_ _2424_ VGND VGND VPWR VPWR _2425_ sky130_fd_sc_hd__buf_4
XFILLER_0_44_620 VPWR VGND VPWR VGND sky130_ef_sc_hd__decap_12
XFILLER_0_90_269 VGND VGND VPWR VPWR sky130_fd_sc_hd__fill_2
X_4737_ _1846_ VGND VGND VPWR VPWR _0268_ sky130_fd_sc_hd__clkbuf_1
XFILLER_0_9_51 VGND VGND VPWR VPWR sky130_fd_sc_hd__fill_2
X_7525_ _3715_ VGND VGND VPWR VPWR _1187_ sky130_fd_sc_hd__clkbuf_1
X_7456_ _3676_ VGND VGND VPWR VPWR _1157_ sky130_fd_sc_hd__clkbuf_1
X_4668_ net338 _1724_ _1797_ VGND VGND VPWR VPWR _1809_ sky130_fd_sc_hd__mux2_1
XFILLER_0_16_399 VGND VGND VPWR VPWR sky130_fd_sc_hd__decap_6
X_6407_ _1622_ net962 _2752_ VGND VGND VPWR VPWR _2764_ sky130_fd_sc_hd__mux2_1
Xhold930 u_input_buffer.fifo_mem\[13\]\[2\] VGND VGND VPWR VPWR net1142 sky130_fd_sc_hd__dlygate4sd3_1
XFILLER_0_43_196 VGND VGND VPWR VPWR sky130_fd_sc_hd__decap_4
X_9126_ net179 _1214_ net210 VGND VGND VPWR VPWR u_analytics_engine.threshold\[8\]
+ sky130_fd_sc_hd__dfrtp_1
Xhold941 u_input_buffer.fifo_mem\[62\]\[5\] VGND VGND VPWR VPWR net1153 sky130_fd_sc_hd__dlygate4sd3_1
Xhold952 u_input_buffer.fifo_mem\[5\]\[13\] VGND VGND VPWR VPWR net1164 sky130_fd_sc_hd__dlygate4sd3_1
X_7387_ u_input_buffer.fifo_mem\[37\]\[15\] _2922_ _2925_ u_input_buffer.fifo_mem\[9\]\[15\]
+ VGND VGND VPWR VPWR _3624_ sky130_fd_sc_hd__a22o_1
X_4599_ net689 _1728_ _1756_ VGND VGND VPWR VPWR _1770_ sky130_fd_sc_hd__mux2_1
Xhold963 u_input_buffer.fifo_mem\[61\]\[6\] VGND VGND VPWR VPWR net1175 sky130_fd_sc_hd__dlygate4sd3_1
Xhold996 u_input_buffer.fifo_mem\[7\]\[1\] VGND VGND VPWR VPWR net1208 sky130_fd_sc_hd__dlygate4sd3_1
Xhold985 u_input_buffer.fifo_mem\[59\]\[2\] VGND VGND VPWR VPWR net1197 sky130_fd_sc_hd__dlygate4sd3_1
X_6338_ _2727_ VGND VGND VPWR VPWR _0988_ sky130_fd_sc_hd__clkbuf_1
Xhold974 u_input_buffer.fifo_mem\[61\]\[5\] VGND VGND VPWR VPWR net1186 sky130_fd_sc_hd__dlygate4sd3_1
XFILLER_0_86_80 VGND VGND VPWR VPWR sky130_fd_sc_hd__decap_4
X_6269_ _2690_ VGND VGND VPWR VPWR _0956_ sky130_fd_sc_hd__clkbuf_1
X_9057_ clknet_leaf_110_clk _1146_ VGND VGND VPWR VPWR u_sensor_interface.sensor_array\[3\]\[4\]
+ sky130_fd_sc_hd__dfxtp_1
X_8008_ clknet_leaf_78_clk _0097_ net192 VGND VGND VPWR VPWR u_sample_counter.sample_count\[31\]
+ sky130_fd_sc_hd__dfrtp_1
XFILLER_0_98_347 VGND VGND VPWR VPWR sky130_fd_sc_hd__fill_1
XFILLER_0_79_594 VGND VGND VPWR VPWR sky130_fd_sc_hd__decap_8
XFILLER_0_66_211 VGND VGND VPWR VPWR sky130_fd_sc_hd__fill_1
XFILLER_0_81_225 VGND VGND VPWR VPWR sky130_fd_sc_hd__decap_6
XFILLER_0_34_141 VGND VGND VPWR VPWR sky130_fd_sc_hd__fill_2
XFILLER_0_105_541 VGND VGND VPWR VPWR sky130_fd_sc_hd__fill_2
XFILLER_0_10_509 VPWR VGND VPWR VGND sky130_ef_sc_hd__decap_12
XFILLER_0_50_645 VGND VGND VPWR VPWR sky130_fd_sc_hd__decap_3
XFILLER_0_82_27 VGND VGND VPWR VPWR sky130_fd_sc_hd__fill_1
X_3970_ _1335_ VGND VGND VPWR VPWR _0012_ sky130_fd_sc_hd__clkbuf_1
XFILLER_0_85_520 VGND VGND VPWR VPWR sky130_fd_sc_hd__fill_1
XFILLER_0_85_597 VGND VGND VPWR VPWR sky130_fd_sc_hd__fill_2
XFILLER_0_17_108 VGND VGND VPWR VPWR sky130_fd_sc_hd__decap_4
X_5640_ net1255 _2268_ _2333_ VGND VGND VPWR VPWR _2347_ sky130_fd_sc_hd__mux2_1
XFILLER_0_26_642 VGND VGND VPWR VPWR sky130_fd_sc_hd__fill_2
XFILLER_0_72_269 VGND VGND VPWR VPWR sky130_fd_sc_hd__fill_2
X_5571_ _1451_ net1143 _2296_ VGND VGND VPWR VPWR _2310_ sky130_fd_sc_hd__mux2_1
X_8290_ clknet_leaf_19_clk _0379_ VGND VGND VPWR VPWR u_input_buffer.fifo_mem\[45\]\[8\]
+ sky130_fd_sc_hd__dfxtp_1
X_7310_ u_input_buffer.fifo_mem\[41\]\[13\] _2918_ _2920_ u_input_buffer.fifo_mem\[45\]\[13\]
+ _3548_ VGND VGND VPWR VPWR _3549_ sky130_fd_sc_hd__a221o_1
XFILLER_0_25_185 VGND VGND VPWR VPWR sky130_fd_sc_hd__decap_3
X_4522_ _1444_ VGND VGND VPWR VPWR _1726_ sky130_fd_sc_hd__clkbuf_4
Xhold226 u_input_buffer.fifo_mem\[42\]\[8\] VGND VGND VPWR VPWR net438 sky130_fd_sc_hd__dlygate4sd3_1
Xhold215 u_input_buffer.fifo_mem\[54\]\[0\] VGND VGND VPWR VPWR net427 sky130_fd_sc_hd__dlygate4sd3_1
X_4453_ net1302 _1588_ _1683_ VGND VGND VPWR VPWR _1684_ sky130_fd_sc_hd__mux2_1
XFILLER_0_80_291 VGND VGND VPWR VPWR sky130_fd_sc_hd__fill_1
Xhold204 u_input_buffer.fifo_mem\[6\]\[8\] VGND VGND VPWR VPWR net416 sky130_fd_sc_hd__dlygate4sd3_1
X_7241_ u_input_buffer.fifo_mem\[2\]\[11\] _2983_ _2985_ u_input_buffer.fifo_mem\[32\]\[11\]
+ VGND VGND VPWR VPWR _3482_ sky130_fd_sc_hd__a22o_1
Xhold259 u_input_buffer.fifo_mem\[23\]\[0\] VGND VGND VPWR VPWR net471 sky130_fd_sc_hd__dlygate4sd3_1
Xhold248 u_input_buffer.fifo_mem\[23\]\[14\] VGND VGND VPWR VPWR net460 sky130_fd_sc_hd__dlygate4sd3_1
Xhold237 u_input_buffer.fifo_mem\[48\]\[11\] VGND VGND VPWR VPWR net449 sky130_fd_sc_hd__dlygate4sd3_1
X_7172_ u_input_buffer.fifo_mem\[27\]\[9\] _3013_ _3015_ u_input_buffer.fifo_mem\[59\]\[9\]
+ _3414_ VGND VGND VPWR VPWR _3415_ sky130_fd_sc_hd__a221o_1
XFILLER_0_21_391 VGND VGND VPWR VPWR sky130_fd_sc_hd__fill_1
X_4384_ _1644_ VGND VGND VPWR VPWR _0117_ sky130_fd_sc_hd__clkbuf_1
XFILLER_0_0_274 VGND VGND VPWR VPWR sky130_fd_sc_hd__fill_2
XFILLER_0_0_285 VGND VGND VPWR VPWR sky130_fd_sc_hd__fill_2
XTAP_520 VGND VPWR sky130_fd_sc_hd__tapvpwrvgnd_1
XTAP_531 VGND VPWR sky130_fd_sc_hd__tapvpwrvgnd_1
XTAP_542 VGND VPWR sky130_fd_sc_hd__tapvpwrvgnd_1
X_6123_ _1612_ net1173 _2607_ VGND VGND VPWR VPWR _2613_ sky130_fd_sc_hd__mux2_1
X_6054_ _2575_ VGND VGND VPWR VPWR _0856_ sky130_fd_sc_hd__clkbuf_1
XTAP_553 VGND VPWR sky130_fd_sc_hd__tapvpwrvgnd_1
XTAP_575 VGND VPWR sky130_fd_sc_hd__tapvpwrvgnd_1
XTAP_564 VGND VPWR sky130_fd_sc_hd__tapvpwrvgnd_1
X_5005_ _1390_ VGND VGND VPWR VPWR _1994_ sky130_fd_sc_hd__buf_4
XFILLER_0_56_61 VGND VGND VPWR VPWR sky130_fd_sc_hd__fill_1
XTAP_586 VGND VPWR sky130_fd_sc_hd__tapvpwrvgnd_1
XTAP_597 VGND VPWR sky130_fd_sc_hd__tapvpwrvgnd_1
XFILLER_0_56_94 VGND VGND VPWR VPWR sky130_fd_sc_hd__decap_3
XFILLER_0_22_3 VGND VGND VPWR VPWR sky130_fd_sc_hd__decap_8
XFILLER_0_76_520 VGND VGND VPWR VPWR sky130_fd_sc_hd__fill_1
X_6956_ u_input_buffer.fifo_mem\[21\]\[4\] _2909_ _2913_ u_input_buffer.fifo_mem\[25\]\[4\]
+ VGND VGND VPWR VPWR _3204_ sky130_fd_sc_hd__a22o_1
XFILLER_0_76_553 VGND VGND VPWR VPWR sky130_fd_sc_hd__decap_3
X_5907_ net440 _2262_ _2479_ VGND VGND VPWR VPWR _2489_ sky130_fd_sc_hd__mux2_1
X_6887_ u_input_buffer.fifo_mem\[36\]\[2\] _2951_ _2955_ u_input_buffer.fifo_mem\[35\]\[2\]
+ _3136_ VGND VGND VPWR VPWR _3137_ sky130_fd_sc_hd__a221o_1
XFILLER_0_63_236 VGND VGND VPWR VPWR sky130_fd_sc_hd__fill_1
XFILLER_0_63_225 VGND VGND VPWR VPWR sky130_fd_sc_hd__fill_2
XFILLER_0_36_439 VGND VGND VPWR VPWR sky130_fd_sc_hd__fill_2
X_8626_ clknet_leaf_77_clk _0715_ VGND VGND VPWR VPWR u_input_buffer.fifo_mem\[24\]\[8\]
+ sky130_fd_sc_hd__dfxtp_1
X_5838_ _2452_ VGND VGND VPWR VPWR _0763_ sky130_fd_sc_hd__clkbuf_1
X_5769_ net821 _2260_ _2407_ VGND VGND VPWR VPWR _2416_ sky130_fd_sc_hd__mux2_1
X_8557_ clknet_leaf_67_clk _0646_ VGND VGND VPWR VPWR u_input_buffer.fifo_mem\[28\]\[3\]
+ sky130_fd_sc_hd__dfxtp_1
X_7508_ _3706_ VGND VGND VPWR VPWR _1179_ sky130_fd_sc_hd__clkbuf_1
XFILLER_0_31_100 VGND VGND VPWR VPWR sky130_fd_sc_hd__decap_3
XFILLER_0_32_601 VGND VGND VPWR VPWR sky130_fd_sc_hd__fill_1
X_8488_ clknet_leaf_101_clk _0577_ VGND VGND VPWR VPWR u_input_buffer.fifo_mem\[33\]\[14\]
+ sky130_fd_sc_hd__dfxtp_1
XFILLER_0_31_111 VGND VGND VPWR VPWR sky130_fd_sc_hd__fill_1
X_7439_ u_sensor_interface.sensor_array\[3\]\[7\] net96 _3662_ VGND VGND VPWR VPWR
+ _3668_ sky130_fd_sc_hd__mux2_1
Xhold760 u_input_buffer.fifo_mem\[40\]\[1\] VGND VGND VPWR VPWR net972 sky130_fd_sc_hd__dlygate4sd3_1
Xhold771 u_input_buffer.fifo_mem\[24\]\[6\] VGND VGND VPWR VPWR net983 sky130_fd_sc_hd__dlygate4sd3_1
Xhold782 u_input_buffer.fifo_mem\[57\]\[8\] VGND VGND VPWR VPWR net994 sky130_fd_sc_hd__dlygate4sd3_1
Xhold793 u_input_buffer.fifo_mem\[43\]\[2\] VGND VGND VPWR VPWR net1005 sky130_fd_sc_hd__dlygate4sd3_1
X_9109_ net176 _1197_ net208 VGND VGND VPWR VPWR u_register_bank.window_cfg\[23\]
+ sky130_fd_sc_hd__dfrtp_1
XFILLER_0_94_361 VGND VGND VPWR VPWR sky130_fd_sc_hd__decap_3
XFILLER_0_67_597 VGND VGND VPWR VPWR sky130_fd_sc_hd__fill_1
XFILLER_0_105_393 VGND VGND VPWR VPWR sky130_fd_sc_hd__decap_4
XFILLER_0_22_177 VGND VGND VPWR VPWR sky130_fd_sc_hd__decap_8
XFILLER_0_50_475 VGND VGND VPWR VPWR sky130_fd_sc_hd__fill_1
XFILLER_0_77_38 VGND VGND VPWR VPWR sky130_fd_sc_hd__decap_6
XFILLER_0_93_15 VPWR VGND VPWR VGND sky130_ef_sc_hd__decap_12
XFILLER_0_89_111 VGND VGND VPWR VPWR sky130_fd_sc_hd__fill_1
X_6810_ _3061_ VGND VGND VPWR VPWR _3062_ sky130_fd_sc_hd__clkbuf_4
X_7790_ _3892_ VGND VGND VPWR VPWR _1275_ sky130_fd_sc_hd__clkbuf_1
X_3953_ _1326_ VGND VGND VPWR VPWR _0004_ sky130_fd_sc_hd__clkbuf_1
XFILLER_0_92_309 VGND VGND VPWR VPWR sky130_fd_sc_hd__fill_1
XFILLER_0_73_501 VGND VGND VPWR VPWR sky130_fd_sc_hd__decap_3
X_6741_ _2992_ VGND VGND VPWR VPWR _2993_ sky130_fd_sc_hd__clkbuf_4
XFILLER_0_42_41 VGND VGND VPWR VPWR sky130_fd_sc_hd__fill_2
X_6672_ _2885_ _2882_ VGND VGND VPWR VPWR _2924_ sky130_fd_sc_hd__nor2_1
XFILLER_0_42_85 VGND VGND VPWR VPWR sky130_fd_sc_hd__decap_3
XFILLER_0_115_113 VGND VGND VPWR VPWR sky130_fd_sc_hd__fill_2
XFILLER_0_91_6 VPWR VGND VPWR VGND sky130_ef_sc_hd__decap_12
X_5623_ _2338_ VGND VGND VPWR VPWR _0662_ sky130_fd_sc_hd__clkbuf_1
X_8411_ clknet_leaf_21_clk _0500_ VGND VGND VPWR VPWR u_input_buffer.fifo_mem\[37\]\[1\]
+ sky130_fd_sc_hd__dfxtp_1
X_8342_ clknet_leaf_10_clk _0431_ VGND VGND VPWR VPWR u_input_buffer.fifo_mem\[42\]\[12\]
+ sky130_fd_sc_hd__dfxtp_1
XFILLER_0_14_645 VPWR VGND VPWR VGND sky130_ef_sc_hd__decap_12
X_5554_ _2301_ VGND VGND VPWR VPWR _0630_ sky130_fd_sc_hd__clkbuf_1
X_8273_ clknet_leaf_35_clk _0362_ VGND VGND VPWR VPWR u_input_buffer.fifo_mem\[46\]\[7\]
+ sky130_fd_sc_hd__dfxtp_1
X_4505_ net696 _1714_ _1704_ VGND VGND VPWR VPWR _1715_ sky130_fd_sc_hd__mux2_1
X_5485_ _1426_ VGND VGND VPWR VPWR _2260_ sky130_fd_sc_hd__clkbuf_4
XFILLER_0_13_177 VGND VGND VPWR VPWR sky130_fd_sc_hd__fill_1
X_4436_ _1672_ VGND VGND VPWR VPWR _0141_ sky130_fd_sc_hd__clkbuf_1
XFILLER_0_1_550 VGND VGND VPWR VPWR sky130_fd_sc_hd__decap_6
XFILLER_0_1_561 VPWR VGND VPWR VGND sky130_ef_sc_hd__decap_12
X_7224_ u_input_buffer.fifo_mem\[63\]\[10\] _2886_ _3075_ u_input_buffer.fifo_mem\[55\]\[10\]
+ _3465_ VGND VGND VPWR VPWR _3466_ sky130_fd_sc_hd__a221o_1
XFILLER_0_111_374 VGND VGND VPWR VPWR sky130_fd_sc_hd__fill_1
X_4367_ _1631_ VGND VGND VPWR VPWR _0113_ sky130_fd_sc_hd__clkbuf_1
X_7155_ u_input_buffer.fifo_mem\[53\]\[9\] _2934_ _2936_ u_input_buffer.fifo_mem\[57\]\[9\]
+ VGND VGND VPWR VPWR _3398_ sky130_fd_sc_hd__a22o_1
XTAP_350 VGND VPWR sky130_fd_sc_hd__tapvpwrvgnd_1
XFILLER_0_6_85 VGND VGND VPWR VPWR sky130_fd_sc_hd__fill_2
X_6106_ _2602_ VGND VGND VPWR VPWR _0881_ sky130_fd_sc_hd__clkbuf_1
X_7086_ u_input_buffer.fifo_mem\[12\]\[7\] _2980_ _2982_ u_input_buffer.fifo_mem\[18\]\[7\]
+ _3330_ VGND VGND VPWR VPWR _3331_ sky130_fd_sc_hd__a221o_1
X_4298_ u_analytics_engine.threshold\[1\] _1576_ u_analytics_engine.data_in\[0\] _1577_
+ VGND VGND VPWR VPWR _1578_ sky130_fd_sc_hd__o22a_1
XTAP_394 VGND VPWR sky130_fd_sc_hd__tapvpwrvgnd_1
XTAP_383 VGND VPWR sky130_fd_sc_hd__tapvpwrvgnd_1
XTAP_372 VGND VPWR sky130_fd_sc_hd__tapvpwrvgnd_1
XTAP_361 VGND VPWR sky130_fd_sc_hd__tapvpwrvgnd_1
X_6037_ net344 _2528_ _2548_ VGND VGND VPWR VPWR _2565_ sky130_fd_sc_hd__mux2_1
XTAP_1505 VGND VPWR sky130_fd_sc_hd__tapvpwrvgnd_1
XFILLER_0_95_103 VGND VGND VPWR VPWR sky130_fd_sc_hd__fill_2
XPHY_12 VGND VGND VPWR VPWR sky130_fd_sc_hd__decap_3
XTAP_1538 VGND VPWR sky130_fd_sc_hd__tapvpwrvgnd_1
XTAP_1527 VGND VPWR sky130_fd_sc_hd__tapvpwrvgnd_1
XTAP_1516 VGND VPWR sky130_fd_sc_hd__tapvpwrvgnd_1
XPHY_23 VGND VGND VPWR VPWR sky130_fd_sc_hd__decap_3
XPHY_34 VGND VGND VPWR VPWR sky130_fd_sc_hd__decap_3
XPHY_45 VGND VGND VPWR VPWR sky130_fd_sc_hd__decap_3
XPHY_56 VGND VGND VPWR VPWR sky130_fd_sc_hd__decap_3
X_7988_ clknet_leaf_80_clk _0077_ net187 VGND VGND VPWR VPWR u_sample_counter.sample_count\[11\]
+ sky130_fd_sc_hd__dfrtp_1
XTAP_1549 VGND VPWR sky130_fd_sc_hd__tapvpwrvgnd_1
X_6939_ u_input_buffer.fifo_mem\[30\]\[3\] _3029_ _3031_ u_input_buffer.fifo_mem\[58\]\[3\]
+ VGND VGND VPWR VPWR _3188_ sky130_fd_sc_hd__a22o_1
XPHY_67 VGND VGND VPWR VPWR sky130_fd_sc_hd__decap_3
XPHY_78 VGND VGND VPWR VPWR sky130_fd_sc_hd__decap_3
XPHY_89 VGND VGND VPWR VPWR sky130_fd_sc_hd__decap_3
XFILLER_0_49_597 VPWR VGND VPWR VGND sky130_ef_sc_hd__decap_12
XFILLER_0_106_102 VPWR VGND VPWR VGND sky130_ef_sc_hd__decap_12
X_8609_ clknet_leaf_6_clk _0698_ VGND VGND VPWR VPWR u_input_buffer.fifo_mem\[25\]\[7\]
+ sky130_fd_sc_hd__dfxtp_1
XFILLER_0_64_589 VGND VGND VPWR VPWR sky130_fd_sc_hd__decap_4
XFILLER_0_17_461 VGND VGND VPWR VPWR sky130_fd_sc_hd__decap_4
XFILLER_0_51_228 VGND VGND VPWR VPWR sky130_fd_sc_hd__decap_3
XFILLER_0_32_442 VGND VGND VPWR VPWR sky130_fd_sc_hd__decap_3
XFILLER_0_20_604 VGND VGND VPWR VPWR sky130_fd_sc_hd__fill_1
XFILLER_0_102_352 VGND VGND VPWR VPWR sky130_fd_sc_hd__fill_1
Xhold590 u_input_buffer.fifo_mem\[60\]\[11\] VGND VGND VPWR VPWR net802 sky130_fd_sc_hd__dlygate4sd3_1
XFILLER_0_27_225 VGND VGND VPWR VPWR sky130_fd_sc_hd__fill_1
XFILLER_0_103_57 VPWR VGND VPWR VGND sky130_ef_sc_hd__decap_12
XFILLER_0_82_386 VGND VGND VPWR VPWR sky130_fd_sc_hd__decap_3
XFILLER_0_113_617 VPWR VGND VPWR VGND sky130_ef_sc_hd__decap_12
XFILLER_0_88_15 VPWR VGND VPWR VGND sky130_ef_sc_hd__decap_12
XFILLER_0_112_127 VGND VGND VPWR VPWR sky130_fd_sc_hd__decap_8
Xoutput117 net117 VGND VGND VPWR VPWR cfg_rdata[12] sky130_fd_sc_hd__clkbuf_4
X_5270_ _2141_ VGND VGND VPWR VPWR _0506_ sky130_fd_sc_hd__clkbuf_1
XFILLER_0_2_358 VGND VGND VPWR VPWR sky130_fd_sc_hd__decap_6
Xoutput128 net128 VGND VGND VPWR VPWR cfg_rdata[22] sky130_fd_sc_hd__buf_2
Xoutput139 net139 VGND VGND VPWR VPWR cfg_rdata[3] sky130_fd_sc_hd__clkbuf_4
X_4221_ u_sample_counter.sample_count\[20\] u_sample_counter.sample_count\[21\] VGND
+ VGND VPWR VPWR _1512_ sky130_fd_sc_hd__and2_1
XFILLER_0_56_9 VGND VGND VPWR VPWR sky130_fd_sc_hd__decap_3
X_4152_ _1465_ u_sensor_interface.sensor_array\[3\]\[14\] net113 VGND VGND VPWR VPWR
+ _1466_ sky130_fd_sc_hd__mux2_1
X_8960_ clknet_leaf_43_clk _1049_ VGND VGND VPWR VPWR u_input_buffer.fifo_mem\[3\]\[6\]
+ sky130_fd_sc_hd__dfxtp_1
X_4083_ _1403_ _1406_ _0000_ VGND VGND VPWR VPWR _1407_ sky130_fd_sc_hd__mux2_1
XFILLER_0_37_74 VGND VGND VPWR VPWR sky130_fd_sc_hd__decap_4
X_7911_ clknet_leaf_79_clk net216 net190 VGND VGND VPWR VPWR u_register_bank.status_flags\[31\]
+ sky130_fd_sc_hd__dfrtp_1
X_8891_ clknet_leaf_54_clk _0980_ VGND VGND VPWR VPWR u_input_buffer.fifo_mem\[7\]\[1\]
+ sky130_fd_sc_hd__dfxtp_1
XFILLER_0_77_103 VGND VGND VPWR VPWR sky130_fd_sc_hd__fill_1
XFILLER_0_78_648 VGND VGND VPWR VPWR sky130_fd_sc_hd__decap_8
XFILLER_0_77_125 VGND VGND VPWR VPWR sky130_fd_sc_hd__decap_4
X_7842_ _3920_ VGND VGND VPWR VPWR _1299_ sky130_fd_sc_hd__clkbuf_1
X_4985_ _1439_ net1162 _1970_ VGND VGND VPWR VPWR _1982_ sky130_fd_sc_hd__mux2_1
X_7773_ _3882_ net137 _3781_ VGND VGND VPWR VPWR _3883_ sky130_fd_sc_hd__mux2_1
XFILLER_0_92_128 VGND VGND VPWR VPWR sky130_fd_sc_hd__fill_1
X_6724_ u_input_buffer.fifo_mem\[16\]\[0\] _2971_ _2973_ u_input_buffer.fifo_mem\[49\]\[0\]
+ _2975_ VGND VGND VPWR VPWR _2976_ sky130_fd_sc_hd__a221o_1
XFILLER_0_18_236 VGND VGND VPWR VPWR sky130_fd_sc_hd__decap_3
X_6655_ _2873_ _2877_ _2876_ u_input_buffer.rd_ptr\[0\] VGND VGND VPWR VPWR _2907_
+ sky130_fd_sc_hd__or4bb_4
XFILLER_0_103_105 VGND VGND VPWR VPWR sky130_fd_sc_hd__decap_6
X_5606_ _2328_ VGND VGND VPWR VPWR _0655_ sky130_fd_sc_hd__clkbuf_1
X_6586_ _2858_ VGND VGND VPWR VPWR _1105_ sky130_fd_sc_hd__clkbuf_1
XFILLER_0_104_639 VGND VGND VPWR VPWR sky130_fd_sc_hd__decap_4
XFILLER_0_103_138 VGND VGND VPWR VPWR sky130_fd_sc_hd__decap_4
XFILLER_0_14_475 VGND VGND VPWR VPWR sky130_fd_sc_hd__fill_1
X_5537_ net858 _2270_ _2276_ VGND VGND VPWR VPWR _2291_ sky130_fd_sc_hd__mux2_1
X_8325_ clknet_leaf_95_clk _0414_ VGND VGND VPWR VPWR u_input_buffer.fifo_mem\[43\]\[11\]
+ sky130_fd_sc_hd__dfxtp_1
X_8256_ clknet_leaf_59_clk _0345_ VGND VGND VPWR VPWR u_input_buffer.fifo_mem\[47\]\[6\]
+ sky130_fd_sc_hd__dfxtp_1
XFILLER_0_14_486 VGND VGND VPWR VPWR sky130_fd_sc_hd__fill_1
X_5468_ net467 _2248_ _2244_ VGND VGND VPWR VPWR _2249_ sky130_fd_sc_hd__mux2_1
XFILLER_0_78_70 VGND VGND VPWR VPWR sky130_fd_sc_hd__fill_2
X_7207_ _3433_ _3435_ _3439_ _3448_ VGND VGND VPWR VPWR _3449_ sky130_fd_sc_hd__or4_2
X_8187_ clknet_leaf_38_clk _0276_ VGND VGND VPWR VPWR u_input_buffer.fifo_mem\[51\]\[1\]
+ sky130_fd_sc_hd__dfxtp_1
X_4419_ net1093 _1606_ _1661_ VGND VGND VPWR VPWR _1664_ sky130_fd_sc_hd__mux2_1
XFILLER_0_10_681 VGND VGND VPWR VPWR sky130_fd_sc_hd__fill_1
X_5399_ _1403_ net1191 _2205_ VGND VGND VPWR VPWR _2210_ sky130_fd_sc_hd__mux2_1
X_7138_ _3375_ _3377_ _3379_ _3381_ VGND VGND VPWR VPWR _3382_ sky130_fd_sc_hd__or4_1
X_7069_ _3308_ _3310_ _3312_ _3314_ VGND VGND VPWR VPWR _3315_ sky130_fd_sc_hd__or4_1
XFILLER_0_69_626 VGND VGND VPWR VPWR sky130_fd_sc_hd__decap_4
XTAP_1313 VGND VPWR sky130_fd_sc_hd__tapvpwrvgnd_1
XTAP_1302 VGND VPWR sky130_fd_sc_hd__tapvpwrvgnd_1
XTAP_1357 VGND VPWR sky130_fd_sc_hd__tapvpwrvgnd_1
XTAP_1346 VGND VPWR sky130_fd_sc_hd__tapvpwrvgnd_1
XTAP_1335 VGND VPWR sky130_fd_sc_hd__tapvpwrvgnd_1
XTAP_1324 VGND VPWR sky130_fd_sc_hd__tapvpwrvgnd_1
XFILLER_0_77_670 VGND VGND VPWR VPWR sky130_fd_sc_hd__fill_2
XFILLER_0_56_309 VGND VGND VPWR VPWR sky130_fd_sc_hd__fill_1
XFILLER_0_49_361 VGND VGND VPWR VPWR sky130_fd_sc_hd__fill_2
XTAP_1379 VGND VPWR sky130_fd_sc_hd__tapvpwrvgnd_1
XTAP_1368 VGND VPWR sky130_fd_sc_hd__tapvpwrvgnd_1
XFILLER_0_37_556 VGND VGND VPWR VPWR sky130_fd_sc_hd__decap_4
XFILLER_0_107_444 VGND VGND VPWR VPWR sky130_fd_sc_hd__decap_4
XFILLER_0_91_150 VGND VGND VPWR VPWR sky130_fd_sc_hd__fill_2
Xinput19 cfg_wdata[16] VGND VGND VPWR VPWR net19 sky130_fd_sc_hd__clkbuf_4
XFILLER_0_24_239 VGND VGND VPWR VPWR sky130_fd_sc_hd__fill_1
XFILLER_0_90_27 VGND VGND VPWR VPWR sky130_fd_sc_hd__fill_1
XFILLER_0_75_629 VPWR VGND VPWR VGND sky130_ef_sc_hd__decap_12
XFILLER_0_75_607 VGND VGND VPWR VPWR sky130_fd_sc_hd__decap_8
X_4770_ _1864_ VGND VGND VPWR VPWR _0283_ sky130_fd_sc_hd__clkbuf_1
XFILLER_0_70_312 VGND VGND VPWR VPWR sky130_fd_sc_hd__decap_4
XFILLER_0_28_589 VGND VGND VPWR VPWR sky130_fd_sc_hd__decap_4
XFILLER_0_99_69 VGND VGND VPWR VPWR sky130_fd_sc_hd__fill_1
X_6440_ _2781_ VGND VGND VPWR VPWR _1036_ sky130_fd_sc_hd__clkbuf_1
XFILLER_0_15_239 VGND VGND VPWR VPWR sky130_fd_sc_hd__decap_4
XFILLER_0_113_447 VGND VGND VPWR VPWR sky130_fd_sc_hd__fill_1
X_6371_ net715 _2516_ _2735_ VGND VGND VPWR VPWR _2745_ sky130_fd_sc_hd__mux2_1
XFILLER_0_2_122 VGND VGND VPWR VPWR sky130_fd_sc_hd__fill_1
X_8110_ clknet_leaf_55_clk _0199_ VGND VGND VPWR VPWR u_input_buffer.fifo_mem\[56\]\[4\]
+ sky130_fd_sc_hd__dfxtp_1
X_5322_ _2168_ VGND VGND VPWR VPWR _2169_ sky130_fd_sc_hd__buf_4
X_9090_ net182 _1178_ net211 VGND VGND VPWR VPWR u_register_bank.window_cfg\[4\] sky130_fd_sc_hd__dfrtp_1
X_8041_ clknet_leaf_100_clk _0130_ VGND VGND VPWR VPWR u_input_buffer.fifo_mem\[61\]\[15\]
+ sky130_fd_sc_hd__dfxtp_1
X_5253_ _1815_ _1969_ VGND VGND VPWR VPWR _2132_ sky130_fd_sc_hd__nand2_4
X_4204_ _1494_ _1500_ VGND VGND VPWR VPWR _1501_ sky130_fd_sc_hd__nand2_1
X_5184_ _1775_ _1969_ VGND VGND VPWR VPWR _2095_ sky130_fd_sc_hd__and2_1
XFILLER_0_48_73 VGND VGND VPWR VPWR sky130_fd_sc_hd__fill_2
X_4135_ _1450_ VGND VGND VPWR VPWR _1451_ sky130_fd_sc_hd__clkbuf_2
X_4066_ u_sensor_interface.sensor_array\[0\]\[2\] u_sensor_interface.sensor_array\[1\]\[2\]
+ _1318_ VGND VGND VPWR VPWR _1392_ sky130_fd_sc_hd__mux2_1
X_8943_ clknet_leaf_37_clk _1032_ VGND VGND VPWR VPWR u_input_buffer.fifo_mem\[4\]\[5\]
+ sky130_fd_sc_hd__dfxtp_1
X_8874_ clknet_leaf_54_clk _0963_ VGND VGND VPWR VPWR u_input_buffer.fifo_mem\[8\]\[0\]
+ sky130_fd_sc_hd__dfxtp_1
XFILLER_0_64_94 VGND VGND VPWR VPWR sky130_fd_sc_hd__decap_4
X_7825_ _3911_ VGND VGND VPWR VPWR _1291_ sky130_fd_sc_hd__clkbuf_1
XFILLER_0_93_415 VGND VGND VPWR VPWR sky130_fd_sc_hd__fill_1
X_4968_ _1973_ VGND VGND VPWR VPWR _0372_ sky130_fd_sc_hd__clkbuf_1
X_7756_ u_register_bank.window_cfg\[26\] _3847_ _3848_ u_register_bank.threshold_cfg\[26\]
+ _3869_ VGND VGND VPWR VPWR _3870_ sky130_fd_sc_hd__a221o_1
X_4899_ _1936_ VGND VGND VPWR VPWR _0340_ sky130_fd_sc_hd__clkbuf_1
X_7687_ _3781_ VGND VGND VPWR VPWR _3817_ sky130_fd_sc_hd__buf_4
X_6707_ u_input_buffer.rd_ptr\[0\] u_input_buffer.rd_ptr\[2\] u_input_buffer.rd_ptr\[3\]
+ u_input_buffer.rd_ptr\[1\] VGND VGND VPWR VPWR _2959_ sky130_fd_sc_hd__or4bb_4
XFILLER_0_61_334 VGND VGND VPWR VPWR sky130_fd_sc_hd__fill_2
X_6638_ _1589_ _1932_ VGND VGND VPWR VPWR _2891_ sky130_fd_sc_hd__or2_1
XFILLER_0_104_447 VGND VGND VPWR VPWR sky130_fd_sc_hd__fill_1
X_6569_ net263 _1414_ _2843_ VGND VGND VPWR VPWR _2850_ sky130_fd_sc_hd__mux2_1
XFILLER_0_61_389 VGND VGND VPWR VPWR sky130_fd_sc_hd__decap_3
X_8308_ clknet_leaf_71_clk _0397_ VGND VGND VPWR VPWR u_input_buffer.fifo_mem\[44\]\[10\]
+ sky130_fd_sc_hd__dfxtp_1
XFILLER_0_42_581 VGND VGND VPWR VPWR sky130_fd_sc_hd__decap_6
X_8239_ clknet_leaf_38_clk _0328_ VGND VGND VPWR VPWR u_input_buffer.fifo_mem\[48\]\[5\]
+ sky130_fd_sc_hd__dfxtp_1
Xfanout174 net175 VGND VGND VPWR VPWR net174 sky130_fd_sc_hd__buf_2
Xfanout196 net197 VGND VGND VPWR VPWR net196 sky130_fd_sc_hd__buf_2
Xfanout185 net186 VGND VGND VPWR VPWR net185 sky130_fd_sc_hd__clkbuf_4
XFILLER_0_84_404 VGND VGND VPWR VPWR sky130_fd_sc_hd__fill_1
XTAP_1132 VGND VPWR sky130_fd_sc_hd__tapvpwrvgnd_1
XTAP_1110 VGND VPWR sky130_fd_sc_hd__tapvpwrvgnd_1
XTAP_1121 VGND VPWR sky130_fd_sc_hd__tapvpwrvgnd_1
XTAP_1165 VGND VPWR sky130_fd_sc_hd__tapvpwrvgnd_1
XTAP_1154 VGND VPWR sky130_fd_sc_hd__tapvpwrvgnd_1
XTAP_1143 VGND VPWR sky130_fd_sc_hd__tapvpwrvgnd_1
XTAP_1198 VGND VPWR sky130_fd_sc_hd__tapvpwrvgnd_1
XTAP_1187 VGND VPWR sky130_fd_sc_hd__tapvpwrvgnd_1
XTAP_1176 VGND VPWR sky130_fd_sc_hd__tapvpwrvgnd_1
XTAP_916 VGND VPWR sky130_fd_sc_hd__tapvpwrvgnd_1
XTAP_905 VGND VPWR sky130_fd_sc_hd__tapvpwrvgnd_1
XTAP_949 VGND VPWR sky130_fd_sc_hd__tapvpwrvgnd_1
XTAP_938 VGND VPWR sky130_fd_sc_hd__tapvpwrvgnd_1
XTAP_927 VGND VPWR sky130_fd_sc_hd__tapvpwrvgnd_1
XFILLER_0_18_76 VGND VGND VPWR VPWR sky130_fd_sc_hd__decap_8
X_5940_ _2509_ VGND VGND VPWR VPWR _0808_ sky130_fd_sc_hd__clkbuf_1
XFILLER_0_87_220 VGND VGND VPWR VPWR sky130_fd_sc_hd__decap_4
X_5871_ net728 _2260_ _2461_ VGND VGND VPWR VPWR _2470_ sky130_fd_sc_hd__mux2_1
X_7610_ net25 u_register_bank.threshold_cfg\[21\] _3759_ VGND VGND VPWR VPWR _3761_
+ sky130_fd_sc_hd__mux2_1
X_8590_ clknet_leaf_43_clk _0679_ VGND VGND VPWR VPWR u_input_buffer.fifo_mem\[26\]\[4\]
+ sky130_fd_sc_hd__dfxtp_1
X_4822_ _1892_ VGND VGND VPWR VPWR _1893_ sky130_fd_sc_hd__buf_4
X_4753_ net932 _1700_ _1855_ VGND VGND VPWR VPWR _1856_ sky130_fd_sc_hd__mux2_1
X_7541_ net25 u_register_bank.window_cfg\[21\] _3722_ VGND VGND VPWR VPWR _3724_ sky130_fd_sc_hd__mux2_1
X_7472_ _3685_ VGND VGND VPWR VPWR _1164_ sky130_fd_sc_hd__clkbuf_1
XFILLER_0_71_643 VGND VGND VPWR VPWR sky130_fd_sc_hd__decap_6
XFILLER_0_50_85 VGND VGND VPWR VPWR sky130_fd_sc_hd__decap_3
XFILLER_0_113_200 VPWR VGND VPWR VGND sky130_ef_sc_hd__decap_12
X_6423_ net561 _1384_ _2771_ VGND VGND VPWR VPWR _2773_ sky130_fd_sc_hd__mux2_1
X_4684_ _1818_ VGND VGND VPWR VPWR _0243_ sky130_fd_sc_hd__clkbuf_1
X_9211_ net170 _1298_ net202 VGND VGND VPWR VPWR u_register_bank.sensor_enable\[12\]
+ sky130_fd_sc_hd__dfrtp_1
XFILLER_0_24_570 VGND VGND VPWR VPWR sky130_fd_sc_hd__fill_1
X_6354_ _2736_ VGND VGND VPWR VPWR _0995_ sky130_fd_sc_hd__clkbuf_1
XFILLER_0_59_61 VGND VGND VPWR VPWR sky130_fd_sc_hd__fill_1
X_9142_ net175 _1230_ net207 VGND VGND VPWR VPWR u_register_bank.threshold_cfg\[24\]
+ sky130_fd_sc_hd__dfrtp_1
XFILLER_0_11_220 VGND VGND VPWR VPWR sky130_fd_sc_hd__fill_1
X_5305_ net834 _2006_ _2151_ VGND VGND VPWR VPWR _2160_ sky130_fd_sc_hd__mux2_1
X_6285_ _2699_ VGND VGND VPWR VPWR _0963_ sky130_fd_sc_hd__clkbuf_1
X_9073_ clknet_leaf_42_clk _1161_ VGND VGND VPWR VPWR u_input_buffer.fifo_mem\[63\]\[3\]
+ sky130_fd_sc_hd__dfxtp_1
X_5236_ _2123_ VGND VGND VPWR VPWR _0490_ sky130_fd_sc_hd__clkbuf_1
XFILLER_0_11_297 VGND VGND VPWR VPWR sky130_fd_sc_hd__fill_1
X_8024_ clknet_leaf_88_clk _0113_ VGND VGND VPWR VPWR u_input_buffer.fifo_mem\[62\]\[14\]
+ sky130_fd_sc_hd__dfxtp_1
XFILLER_0_52_3 VGND VGND VPWR VPWR sky130_fd_sc_hd__decap_3
X_5167_ _2086_ VGND VGND VPWR VPWR _0458_ sky130_fd_sc_hd__clkbuf_1
X_5098_ net936 _2004_ _2042_ VGND VGND VPWR VPWR _2050_ sky130_fd_sc_hd__mux2_1
X_4118_ _1433_ _1436_ _1320_ VGND VGND VPWR VPWR _1437_ sky130_fd_sc_hd__mux2_1
X_4049_ _1376_ VGND VGND VPWR VPWR _1377_ sky130_fd_sc_hd__buf_2
X_8926_ clknet_leaf_111_clk _1015_ VGND VGND VPWR VPWR u_input_buffer.fifo_mem\[5\]\[4\]
+ sky130_fd_sc_hd__dfxtp_1
XFILLER_0_78_253 VGND VGND VPWR VPWR sky130_fd_sc_hd__decap_8
XPHY_215 VGND VGND VPWR VPWR sky130_fd_sc_hd__decap_3
XPHY_204 VGND VGND VPWR VPWR sky130_fd_sc_hd__decap_3
XFILLER_0_66_437 VGND VGND VPWR VPWR sky130_fd_sc_hd__decap_8
XFILLER_0_66_415 VGND VGND VPWR VPWR sky130_fd_sc_hd__fill_2
XFILLER_0_38_128 VGND VGND VPWR VPWR sky130_fd_sc_hd__fill_1
X_8857_ clknet_leaf_95_clk _0946_ VGND VGND VPWR VPWR u_input_buffer.fifo_mem\[10\]\[15\]
+ sky130_fd_sc_hd__dfxtp_1
XPHY_226 VGND VGND VPWR VPWR sky130_fd_sc_hd__decap_3
X_8788_ clknet_leaf_13_clk _0877_ VGND VGND VPWR VPWR u_input_buffer.fifo_mem\[14\]\[10\]
+ sky130_fd_sc_hd__dfxtp_1
X_7808_ net1303 u_analytics_engine.data_in\[14\] _3893_ VGND VGND VPWR VPWR _3902_
+ sky130_fd_sc_hd__mux2_1
X_7739_ u_register_bank.status_flags\[22\] _3849_ _3843_ u_register_bank.sensor_enable\[22\]
+ VGND VGND VPWR VPWR _3857_ sky130_fd_sc_hd__a22o_1
XFILLER_0_19_375 VGND VGND VPWR VPWR sky130_fd_sc_hd__fill_1
XFILLER_0_47_673 VGND VGND VPWR VPWR sky130_fd_sc_hd__fill_2
XFILLER_0_47_684 VGND VGND VPWR VPWR sky130_fd_sc_hd__fill_2
XFILLER_0_74_492 VGND VGND VPWR VPWR sky130_fd_sc_hd__fill_1
XFILLER_0_15_570 VPWR VGND VPWR VGND sky130_ef_sc_hd__decap_12
XFILLER_0_30_584 VGND VGND VPWR VPWR sky130_fd_sc_hd__decap_4
Xhold8 u_sample_counter.sample_count\[2\] VGND VGND VPWR VPWR net220 sky130_fd_sc_hd__dlygate4sd3_1
XFILLER_0_55_19 VGND VGND VPWR VPWR sky130_fd_sc_hd__fill_2
XFILLER_0_71_29 VGND VGND VPWR VPWR sky130_fd_sc_hd__fill_1
XFILLER_0_37_150 VGND VGND VPWR VPWR sky130_fd_sc_hd__fill_2
XFILLER_0_25_312 VGND VGND VPWR VPWR sky130_fd_sc_hd__decap_4
XFILLER_0_52_131 VGND VGND VPWR VPWR sky130_fd_sc_hd__fill_1
XFILLER_0_111_57 VPWR VGND VPWR VGND sky130_ef_sc_hd__decap_12
Xhold408 u_input_buffer.fifo_mem\[55\]\[15\] VGND VGND VPWR VPWR net620 sky130_fd_sc_hd__dlygate4sd3_1
XFILLER_0_96_15 VPWR VGND VPWR VGND sky130_ef_sc_hd__decap_12
Xhold419 u_input_buffer.fifo_mem\[18\]\[2\] VGND VGND VPWR VPWR net631 sky130_fd_sc_hd__dlygate4sd3_1
XFILLER_0_0_401 VGND VGND VPWR VPWR sky130_fd_sc_hd__fill_1
XFILLER_0_0_489 VPWR VGND VPWR VGND sky130_ef_sc_hd__decap_12
XTAP_702 VGND VPWR sky130_fd_sc_hd__tapvpwrvgnd_1
XTAP_724 VGND VPWR sky130_fd_sc_hd__tapvpwrvgnd_1
XTAP_713 VGND VPWR sky130_fd_sc_hd__tapvpwrvgnd_1
X_6070_ _2583_ VGND VGND VPWR VPWR _0864_ sky130_fd_sc_hd__clkbuf_1
XTAP_735 VGND VPWR sky130_fd_sc_hd__tapvpwrvgnd_1
XTAP_746 VGND VPWR sky130_fd_sc_hd__tapvpwrvgnd_1
XTAP_757 VGND VPWR sky130_fd_sc_hd__tapvpwrvgnd_1
XTAP_768 VGND VPWR sky130_fd_sc_hd__tapvpwrvgnd_1
X_5021_ net432 _2004_ _1990_ VGND VGND VPWR VPWR _2005_ sky130_fd_sc_hd__mux2_1
Xhold1108 u_analytics_engine.data_in\[1\] VGND VGND VPWR VPWR net1320 sky130_fd_sc_hd__dlygate4sd3_1
XTAP_779 VGND VPWR sky130_fd_sc_hd__tapvpwrvgnd_1
XFILLER_0_45_30 VGND VGND VPWR VPWR sky130_fd_sc_hd__fill_1
X_6972_ _3213_ _3215_ _3217_ _3219_ VGND VGND VPWR VPWR _3220_ sky130_fd_sc_hd__or4_1
XFILLER_0_17_6 VPWR VGND VPWR VGND sky130_ef_sc_hd__decap_12
X_8711_ clknet_leaf_76_clk _0800_ VGND VGND VPWR VPWR u_input_buffer.fifo_mem\[19\]\[13\]
+ sky130_fd_sc_hd__dfxtp_1
X_5923_ _2497_ VGND VGND VPWR VPWR _2498_ sky130_fd_sc_hd__buf_4
X_8642_ clknet_leaf_47_clk _0731_ VGND VGND VPWR VPWR u_input_buffer.fifo_mem\[23\]\[8\]
+ sky130_fd_sc_hd__dfxtp_1
X_5854_ _2460_ VGND VGND VPWR VPWR _2461_ sky130_fd_sc_hd__buf_4
XFILLER_0_75_234 VGND VGND VPWR VPWR sky130_fd_sc_hd__decap_3
X_8573_ clknet_leaf_68_clk _0662_ VGND VGND VPWR VPWR u_input_buffer.fifo_mem\[27\]\[3\]
+ sky130_fd_sc_hd__dfxtp_1
X_4805_ _1883_ VGND VGND VPWR VPWR _0299_ sky130_fd_sc_hd__clkbuf_1
XFILLER_0_61_84 VGND VGND VPWR VPWR sky130_fd_sc_hd__fill_2
XFILLER_0_29_673 VGND VGND VPWR VPWR sky130_fd_sc_hd__decap_6
XFILLER_0_56_481 VGND VGND VPWR VPWR sky130_fd_sc_hd__fill_1
XFILLER_0_8_589 VPWR VGND VPWR VGND sky130_ef_sc_hd__decap_12
X_7524_ net16 u_register_bank.window_cfg\[13\] _3711_ VGND VGND VPWR VPWR _3715_ sky130_fd_sc_hd__mux2_1
X_5785_ _1796_ _2242_ VGND VGND VPWR VPWR _2424_ sky130_fd_sc_hd__nor2_4
XFILLER_0_44_632 VPWR VGND VPWR VGND sky130_ef_sc_hd__decap_12
X_4736_ net703 _1722_ _1836_ VGND VGND VPWR VPWR _1846_ sky130_fd_sc_hd__mux2_1
XFILLER_0_43_120 VGND VGND VPWR VPWR sky130_fd_sc_hd__decap_4
X_4667_ _1808_ VGND VGND VPWR VPWR _0236_ sky130_fd_sc_hd__clkbuf_1
X_7455_ net448 net105 _1322_ VGND VGND VPWR VPWR _3676_ sky130_fd_sc_hd__mux2_1
XFILLER_0_43_186 VGND VGND VPWR VPWR sky130_fd_sc_hd__fill_2
X_7386_ u_input_buffer.fifo_mem\[33\]\[15\] _2897_ _2903_ u_input_buffer.fifo_mem\[61\]\[15\]
+ _3622_ VGND VGND VPWR VPWR _3623_ sky130_fd_sc_hd__a221o_1
Xhold931 u_input_buffer.fifo_mem\[29\]\[12\] VGND VGND VPWR VPWR net1143 sky130_fd_sc_hd__dlygate4sd3_1
X_6406_ _2763_ VGND VGND VPWR VPWR _1020_ sky130_fd_sc_hd__clkbuf_1
XFILLER_0_31_337 VGND VGND VPWR VPWR sky130_fd_sc_hd__decap_4
Xhold920 u_analytics_engine.data_in\[13\] VGND VGND VPWR VPWR net1132 sky130_fd_sc_hd__dlygate4sd3_1
Xhold964 u_input_buffer.fifo_mem\[6\]\[0\] VGND VGND VPWR VPWR net1176 sky130_fd_sc_hd__dlygate4sd3_1
X_9125_ net180 _1213_ net210 VGND VGND VPWR VPWR u_analytics_engine.threshold\[7\]
+ sky130_fd_sc_hd__dfrtp_1
X_6337_ net361 _2516_ _2717_ VGND VGND VPWR VPWR _2727_ sky130_fd_sc_hd__mux2_1
Xhold942 u_input_buffer.fifo_mem\[5\]\[1\] VGND VGND VPWR VPWR net1154 sky130_fd_sc_hd__dlygate4sd3_1
X_4598_ _1769_ VGND VGND VPWR VPWR _0206_ sky130_fd_sc_hd__clkbuf_1
Xhold953 u_input_buffer.fifo_mem\[61\]\[4\] VGND VGND VPWR VPWR net1165 sky130_fd_sc_hd__dlygate4sd3_1
XFILLER_0_101_269 VGND VGND VPWR VPWR sky130_fd_sc_hd__fill_1
Xhold997 u_input_buffer.fifo_mem\[37\]\[6\] VGND VGND VPWR VPWR net1209 sky130_fd_sc_hd__dlygate4sd3_1
Xhold975 u_input_buffer.fifo_mem\[5\]\[11\] VGND VGND VPWR VPWR net1187 sky130_fd_sc_hd__dlygate4sd3_1
Xhold986 u_input_buffer.fifo_mem\[49\]\[13\] VGND VGND VPWR VPWR net1198 sky130_fd_sc_hd__dlygate4sd3_1
X_9056_ clknet_leaf_22_clk _1145_ VGND VGND VPWR VPWR u_sensor_interface.sensor_array\[3\]\[3\]
+ sky130_fd_sc_hd__dfxtp_1
X_6268_ _1620_ net992 _2680_ VGND VGND VPWR VPWR _2690_ sky130_fd_sc_hd__mux2_1
X_6199_ _2653_ VGND VGND VPWR VPWR _0923_ sky130_fd_sc_hd__clkbuf_1
X_5219_ _1796_ _1930_ VGND VGND VPWR VPWR _2114_ sky130_fd_sc_hd__nor2_4
X_8007_ clknet_leaf_78_clk _0096_ net190 VGND VGND VPWR VPWR u_sample_counter.sample_count\[30\]
+ sky130_fd_sc_hd__dfrtp_1
X_8909_ clknet_leaf_67_clk _0998_ VGND VGND VPWR VPWR u_input_buffer.fifo_mem\[6\]\[3\]
+ sky130_fd_sc_hd__dfxtp_1
XFILLER_0_109_347 VGND VGND VPWR VPWR sky130_fd_sc_hd__decap_4
XFILLER_0_54_429 VGND VGND VPWR VPWR sky130_fd_sc_hd__fill_1
XFILLER_0_35_621 VGND VGND VPWR VPWR sky130_fd_sc_hd__fill_2
XFILLER_0_34_197 VGND VGND VPWR VPWR sky130_fd_sc_hd__fill_2
XFILLER_0_89_337 VGND VGND VPWR VPWR sky130_fd_sc_hd__fill_2
XFILLER_0_89_315 VGND VGND VPWR VPWR sky130_fd_sc_hd__decap_4
XFILLER_0_106_13 VPWR VGND VPWR VGND sky130_ef_sc_hd__decap_12
XFILLER_0_97_370 VGND VGND VPWR VPWR sky130_fd_sc_hd__fill_1
XFILLER_0_15_55 VGND VGND VPWR VPWR sky130_fd_sc_hd__fill_1
X_5570_ _2309_ VGND VGND VPWR VPWR _0638_ sky130_fd_sc_hd__clkbuf_1
XFILLER_0_26_665 VGND VGND VPWR VPWR sky130_fd_sc_hd__fill_1
XFILLER_0_5_559 VGND VGND VPWR VPWR sky130_fd_sc_hd__fill_1
X_4521_ _1725_ VGND VGND VPWR VPWR _0173_ sky130_fd_sc_hd__clkbuf_1
Xhold216 u_input_buffer.fifo_mem\[60\]\[9\] VGND VGND VPWR VPWR net428 sky130_fd_sc_hd__dlygate4sd3_1
X_4452_ _1682_ VGND VGND VPWR VPWR _1683_ sky130_fd_sc_hd__clkbuf_4
XFILLER_0_13_337 VGND VGND VPWR VPWR sky130_fd_sc_hd__fill_1
Xhold205 u_input_buffer.fifo_mem\[31\]\[11\] VGND VGND VPWR VPWR net417 sky130_fd_sc_hd__dlygate4sd3_1
X_7240_ u_input_buffer.fifo_mem\[34\]\[11\] _2965_ _2968_ u_input_buffer.fifo_mem\[48\]\[11\]
+ _3480_ VGND VGND VPWR VPWR _3481_ sky130_fd_sc_hd__a221o_1
Xhold249 u_input_buffer.fifo_mem\[6\]\[1\] VGND VGND VPWR VPWR net461 sky130_fd_sc_hd__dlygate4sd3_1
Xhold227 u_input_buffer.fifo_mem\[50\]\[8\] VGND VGND VPWR VPWR net439 sky130_fd_sc_hd__dlygate4sd3_1
Xhold238 u_input_buffer.fifo_mem\[34\]\[9\] VGND VGND VPWR VPWR net450 sky130_fd_sc_hd__dlygate4sd3_1
X_7171_ u_input_buffer.fifo_mem\[31\]\[9\] _3017_ _3020_ u_input_buffer.fifo_mem\[38\]\[9\]
+ VGND VGND VPWR VPWR _3414_ sky130_fd_sc_hd__a22o_1
X_4383_ _1391_ net1252 _1641_ VGND VGND VPWR VPWR _1644_ sky130_fd_sc_hd__mux2_1
XFILLER_0_0_253 VGND VGND VPWR VPWR sky130_fd_sc_hd__fill_1
XTAP_510 VGND VPWR sky130_fd_sc_hd__tapvpwrvgnd_1
XTAP_521 VGND VPWR sky130_fd_sc_hd__tapvpwrvgnd_1
XTAP_532 VGND VPWR sky130_fd_sc_hd__tapvpwrvgnd_1
XTAP_543 VGND VPWR sky130_fd_sc_hd__tapvpwrvgnd_1
X_6122_ _2612_ VGND VGND VPWR VPWR _0887_ sky130_fd_sc_hd__clkbuf_1
X_6053_ net434 _2508_ _2569_ VGND VGND VPWR VPWR _2575_ sky130_fd_sc_hd__mux2_1
XTAP_554 VGND VPWR sky130_fd_sc_hd__tapvpwrvgnd_1
XTAP_576 VGND VPWR sky130_fd_sc_hd__tapvpwrvgnd_1
XTAP_565 VGND VPWR sky130_fd_sc_hd__tapvpwrvgnd_1
X_5004_ _1993_ VGND VGND VPWR VPWR _0388_ sky130_fd_sc_hd__clkbuf_1
XTAP_587 VGND VPWR sky130_fd_sc_hd__tapvpwrvgnd_1
XTAP_598 VGND VPWR sky130_fd_sc_hd__tapvpwrvgnd_1
XFILLER_0_15_3 VPWR VGND VPWR VGND sky130_ef_sc_hd__decap_12
X_6955_ u_analytics_engine.data_in\[3\] _2893_ _3202_ _3203_ VGND VGND VPWR VPWR _1129_
+ sky130_fd_sc_hd__a22o_1
XFILLER_0_88_381 VGND VGND VPWR VPWR sky130_fd_sc_hd__fill_2
XFILLER_0_72_72 VGND VGND VPWR VPWR sky130_fd_sc_hd__decap_3
X_5906_ _2488_ VGND VGND VPWR VPWR _0795_ sky130_fd_sc_hd__clkbuf_1
X_6886_ u_input_buffer.fifo_mem\[14\]\[2\] _2958_ _2961_ u_input_buffer.fifo_mem\[42\]\[2\]
+ VGND VGND VPWR VPWR _3136_ sky130_fd_sc_hd__a22o_1
XFILLER_0_76_587 VGND VGND VPWR VPWR sky130_fd_sc_hd__fill_1
X_8625_ clknet_leaf_66_clk _0714_ VGND VGND VPWR VPWR u_input_buffer.fifo_mem\[24\]\[7\]
+ sky130_fd_sc_hd__dfxtp_1
XFILLER_0_76_598 VGND VGND VPWR VPWR sky130_fd_sc_hd__decap_4
X_5837_ _1618_ net930 _2443_ VGND VGND VPWR VPWR _2452_ sky130_fd_sc_hd__mux2_1
X_5768_ _2415_ VGND VGND VPWR VPWR _0730_ sky130_fd_sc_hd__clkbuf_1
X_8556_ clknet_leaf_55_clk _0645_ VGND VGND VPWR VPWR u_input_buffer.fifo_mem\[28\]\[2\]
+ sky130_fd_sc_hd__dfxtp_1
X_4719_ _1837_ VGND VGND VPWR VPWR _0259_ sky130_fd_sc_hd__clkbuf_1
X_7507_ net39 u_register_bank.window_cfg\[5\] _3700_ VGND VGND VPWR VPWR _3706_ sky130_fd_sc_hd__mux2_1
X_8487_ clknet_leaf_107_clk _0576_ VGND VGND VPWR VPWR u_input_buffer.fifo_mem\[33\]\[13\]
+ sky130_fd_sc_hd__dfxtp_1
X_7438_ _3667_ VGND VGND VPWR VPWR _1148_ sky130_fd_sc_hd__clkbuf_1
X_5699_ _2378_ VGND VGND VPWR VPWR _0698_ sky130_fd_sc_hd__clkbuf_1
XFILLER_0_4_581 VGND VGND VPWR VPWR sky130_fd_sc_hd__decap_6
XFILLER_0_97_80 VGND VGND VPWR VPWR sky130_fd_sc_hd__decap_3
Xhold772 u_input_buffer.fifo_mem\[8\]\[4\] VGND VGND VPWR VPWR net984 sky130_fd_sc_hd__dlygate4sd3_1
Xhold761 u_input_buffer.fifo_mem\[21\]\[14\] VGND VGND VPWR VPWR net973 sky130_fd_sc_hd__dlygate4sd3_1
Xhold750 u_input_buffer.fifo_mem\[5\]\[10\] VGND VGND VPWR VPWR net962 sky130_fd_sc_hd__dlygate4sd3_1
X_7369_ u_input_buffer.fifo_mem\[7\]\[14\] _3024_ _3026_ u_input_buffer.fifo_mem\[22\]\[14\]
+ _3606_ VGND VGND VPWR VPWR _3607_ sky130_fd_sc_hd__a221o_1
Xhold783 u_input_buffer.fifo_mem\[6\]\[2\] VGND VGND VPWR VPWR net995 sky130_fd_sc_hd__dlygate4sd3_1
Xhold794 u_input_buffer.fifo_mem\[28\]\[0\] VGND VGND VPWR VPWR net1006 sky130_fd_sc_hd__dlygate4sd3_1
XFILLER_0_102_589 VGND VGND VPWR VPWR sky130_fd_sc_hd__fill_2
X_9108_ net174 _1196_ net206 VGND VGND VPWR VPWR u_register_bank.window_cfg\[22\]
+ sky130_fd_sc_hd__dfrtp_1
X_9039_ clknet_leaf_46_clk _1128_ VGND VGND VPWR VPWR u_analytics_engine.data_in\[2\]
+ sky130_fd_sc_hd__dfxtp_2
XFILLER_0_99_613 VGND VGND VPWR VPWR sky130_fd_sc_hd__decap_3
XFILLER_0_86_307 VGND VGND VPWR VPWR sky130_fd_sc_hd__fill_1
XFILLER_0_109_111 VGND VGND VPWR VPWR sky130_fd_sc_hd__fill_1
XFILLER_0_54_226 VGND VGND VPWR VPWR sky130_fd_sc_hd__decap_3
XFILLER_0_112_309 VGND VGND VPWR VPWR sky130_fd_sc_hd__decap_4
XFILLER_0_50_421 VGND VGND VPWR VPWR sky130_fd_sc_hd__decap_4
XFILLER_0_50_498 VGND VGND VPWR VPWR sky130_fd_sc_hd__fill_2
XFILLER_0_93_27 VPWR VGND VPWR VGND sky130_ef_sc_hd__decap_12
Xclkbuf_leaf_109_clk clknet_3_0__leaf_clk VGND VGND VPWR VPWR clknet_leaf_109_clk
+ sky130_fd_sc_hd__clkbuf_16
X_6740_ _2930_ _2991_ VGND VGND VPWR VPWR _2992_ sky130_fd_sc_hd__nor2_4
X_3952_ u_sensor_interface.sensor_array\[2\]\[2\] net73 _1323_ VGND VGND VPWR VPWR
+ _1326_ sky130_fd_sc_hd__mux2_1
XFILLER_0_18_418 VGND VGND VPWR VPWR sky130_fd_sc_hd__fill_2
X_6671_ _2922_ VGND VGND VPWR VPWR _2923_ sky130_fd_sc_hd__clkbuf_4
X_5622_ net676 _2250_ _2334_ VGND VGND VPWR VPWR _2338_ sky130_fd_sc_hd__mux2_1
X_8410_ clknet_leaf_20_clk _0499_ VGND VGND VPWR VPWR u_input_buffer.fifo_mem\[37\]\[0\]
+ sky130_fd_sc_hd__dfxtp_1
XFILLER_0_60_218 VGND VGND VPWR VPWR sky130_fd_sc_hd__fill_1
X_5553_ _1397_ net1214 _2297_ VGND VGND VPWR VPWR _2301_ sky130_fd_sc_hd__mux2_1
X_8341_ clknet_leaf_7_clk _0430_ VGND VGND VPWR VPWR u_input_buffer.fifo_mem\[42\]\[11\]
+ sky130_fd_sc_hd__dfxtp_1
XFILLER_0_115_169 VPWR VGND VPWR VGND sky130_ef_sc_hd__decap_12
X_4504_ _1408_ VGND VGND VPWR VPWR _1714_ sky130_fd_sc_hd__buf_4
XFILLER_0_14_657 VPWR VGND VPWR VGND sky130_ef_sc_hd__decap_12
X_8272_ clknet_leaf_36_clk _0361_ VGND VGND VPWR VPWR u_input_buffer.fifo_mem\[46\]\[6\]
+ sky130_fd_sc_hd__dfxtp_1
X_5484_ _2259_ VGND VGND VPWR VPWR _0602_ sky130_fd_sc_hd__clkbuf_1
X_7223_ u_input_buffer.fifo_mem\[54\]\[10\] _3077_ _3079_ u_input_buffer.fifo_mem\[46\]\[10\]
+ VGND VGND VPWR VPWR _3465_ sky130_fd_sc_hd__a22o_1
X_4435_ net1020 _1622_ _1660_ VGND VGND VPWR VPWR _1672_ sky130_fd_sc_hd__mux2_1
XFILLER_0_1_540 VGND VGND VPWR VPWR sky130_fd_sc_hd__fill_1
X_7154_ u_input_buffer.fifo_mem\[41\]\[9\] _2919_ _2921_ u_input_buffer.fifo_mem\[45\]\[9\]
+ _3396_ VGND VGND VPWR VPWR _3397_ sky130_fd_sc_hd__a221o_1
XFILLER_0_1_573 VPWR VGND VPWR VGND sky130_ef_sc_hd__decap_12
X_4366_ net1298 _1630_ _1601_ VGND VGND VPWR VPWR _1631_ sky130_fd_sc_hd__mux2_1
XTAP_351 VGND VPWR sky130_fd_sc_hd__tapvpwrvgnd_1
XTAP_340 VGND VPWR sky130_fd_sc_hd__tapvpwrvgnd_1
X_6105_ net655 _2526_ _2586_ VGND VGND VPWR VPWR _2602_ sky130_fd_sc_hd__mux2_1
X_7085_ u_input_buffer.fifo_mem\[2\]\[7\] _2984_ _2986_ u_input_buffer.fifo_mem\[32\]\[7\]
+ VGND VGND VPWR VPWR _3330_ sky130_fd_sc_hd__a22o_1
X_4297_ u_analytics_engine.threshold\[0\] VGND VGND VPWR VPWR _1577_ sky130_fd_sc_hd__inv_2
XTAP_384 VGND VPWR sky130_fd_sc_hd__tapvpwrvgnd_1
XTAP_373 VGND VPWR sky130_fd_sc_hd__tapvpwrvgnd_1
XTAP_362 VGND VPWR sky130_fd_sc_hd__tapvpwrvgnd_1
XTAP_395 VGND VPWR sky130_fd_sc_hd__tapvpwrvgnd_1
X_6036_ _2564_ VGND VGND VPWR VPWR _0849_ sky130_fd_sc_hd__clkbuf_1
XTAP_1506 VGND VPWR sky130_fd_sc_hd__tapvpwrvgnd_1
XPHY_13 VGND VGND VPWR VPWR sky130_fd_sc_hd__decap_3
XTAP_1539 VGND VPWR sky130_fd_sc_hd__tapvpwrvgnd_1
XTAP_1528 VGND VPWR sky130_fd_sc_hd__tapvpwrvgnd_1
XTAP_1517 VGND VPWR sky130_fd_sc_hd__tapvpwrvgnd_1
XPHY_24 VGND VGND VPWR VPWR sky130_fd_sc_hd__decap_3
XPHY_35 VGND VGND VPWR VPWR sky130_fd_sc_hd__decap_3
XPHY_46 VGND VGND VPWR VPWR sky130_fd_sc_hd__decap_3
X_7987_ clknet_leaf_80_clk _0076_ net191 VGND VGND VPWR VPWR u_sample_counter.sample_count\[10\]
+ sky130_fd_sc_hd__dfrtp_1
X_6938_ u_input_buffer.fifo_mem\[27\]\[3\] _3013_ _3015_ u_input_buffer.fifo_mem\[59\]\[3\]
+ _3186_ VGND VGND VPWR VPWR _3187_ sky130_fd_sc_hd__a221o_1
XPHY_57 VGND VGND VPWR VPWR sky130_fd_sc_hd__decap_3
XPHY_68 VGND VGND VPWR VPWR sky130_fd_sc_hd__decap_3
XPHY_79 VGND VGND VPWR VPWR sky130_fd_sc_hd__decap_3
XFILLER_0_49_576 VPWR VGND VPWR VGND sky130_ef_sc_hd__decap_12
X_6869_ u_input_buffer.fifo_mem\[10\]\[1\] _3056_ _3058_ u_input_buffer.fifo_mem\[44\]\[1\]
+ _3119_ VGND VGND VPWR VPWR _3120_ sky130_fd_sc_hd__a221o_1
XFILLER_0_76_395 VGND VGND VPWR VPWR sky130_fd_sc_hd__fill_1
XFILLER_0_106_114 VGND VGND VPWR VPWR sky130_fd_sc_hd__fill_1
XFILLER_0_9_673 VPWR VGND VPWR VGND sky130_ef_sc_hd__decap_12
X_8608_ clknet_leaf_6_clk _0697_ VGND VGND VPWR VPWR u_input_buffer.fifo_mem\[25\]\[6\]
+ sky130_fd_sc_hd__dfxtp_1
X_8539_ clknet_leaf_3_clk _0628_ VGND VGND VPWR VPWR u_input_buffer.fifo_mem\[29\]\[1\]
+ sky130_fd_sc_hd__dfxtp_1
XFILLER_0_20_638 VGND VGND VPWR VPWR sky130_fd_sc_hd__decap_6
Xhold580 u_input_buffer.fifo_mem\[15\]\[3\] VGND VGND VPWR VPWR net792 sky130_fd_sc_hd__dlygate4sd3_1
XFILLER_0_4_3 VPWR VGND VPWR VGND sky130_ef_sc_hd__decap_12
XFILLER_0_102_397 VGND VGND VPWR VPWR sky130_fd_sc_hd__fill_1
Xhold591 u_input_buffer.fifo_mem\[16\]\[1\] VGND VGND VPWR VPWR net803 sky130_fd_sc_hd__dlygate4sd3_1
XFILLER_0_99_443 VGND VGND VPWR VPWR sky130_fd_sc_hd__fill_2
XFILLER_0_95_682 VGND VGND VPWR VPWR sky130_fd_sc_hd__decap_4
XFILLER_0_103_69 VPWR VGND VPWR VGND sky130_ef_sc_hd__decap_12
XFILLER_0_113_629 VPWR VGND VPWR VGND sky130_ef_sc_hd__decap_12
XFILLER_0_88_27 VGND VGND VPWR VPWR sky130_fd_sc_hd__fill_1
XFILLER_0_70_549 VGND VGND VPWR VPWR sky130_fd_sc_hd__fill_1
XFILLER_0_35_281 VGND VGND VPWR VPWR sky130_fd_sc_hd__fill_1
Xoutput129 net129 VGND VGND VPWR VPWR cfg_rdata[23] sky130_fd_sc_hd__clkbuf_4
Xoutput118 net118 VGND VGND VPWR VPWR cfg_rdata[13] sky130_fd_sc_hd__clkbuf_4
XFILLER_0_50_262 VGND VGND VPWR VPWR sky130_fd_sc_hd__fill_1
X_4220_ net226 _1509_ VGND VGND VPWR VPWR _0086_ sky130_fd_sc_hd__xnor2_1
X_4151_ _1464_ u_sensor_interface.sensor_array\[2\]\[14\] net112 VGND VGND VPWR VPWR
+ _1465_ sky130_fd_sc_hd__mux2_1
X_4082_ _1405_ u_sensor_interface.sensor_array\[3\]\[4\] _1381_ VGND VGND VPWR VPWR
+ _1406_ sky130_fd_sc_hd__mux2_1
XFILLER_0_37_53 VGND VGND VPWR VPWR sky130_fd_sc_hd__decap_3
X_8890_ clknet_leaf_54_clk _0979_ VGND VGND VPWR VPWR u_input_buffer.fifo_mem\[7\]\[0\]
+ sky130_fd_sc_hd__dfxtp_1
X_7910_ clknet_leaf_79_clk net219 net191 VGND VGND VPWR VPWR u_register_bank.status_flags\[30\]
+ sky130_fd_sc_hd__dfrtp_1
X_7841_ net16 u_register_bank.sensor_enable\[13\] _3916_ VGND VGND VPWR VPWR _3920_
+ sky130_fd_sc_hd__mux2_1
X_4984_ _1981_ VGND VGND VPWR VPWR _0380_ sky130_fd_sc_hd__clkbuf_1
X_7772_ u_register_bank.window_cfg\[30\] _3698_ net167 u_register_bank.threshold_cfg\[30\]
+ _3881_ VGND VGND VPWR VPWR _3882_ sky130_fd_sc_hd__a221o_1
XFILLER_0_53_96 VGND VGND VPWR VPWR sky130_fd_sc_hd__decap_6
X_6723_ _2974_ VGND VGND VPWR VPWR _2975_ sky130_fd_sc_hd__clkbuf_4
X_6654_ _2905_ VGND VGND VPWR VPWR _2906_ sky130_fd_sc_hd__buf_8
XFILLER_0_61_505 VGND VGND VPWR VPWR sky130_fd_sc_hd__decap_4
XFILLER_0_6_643 VGND VGND VPWR VPWR sky130_fd_sc_hd__fill_1
X_5605_ net843 _2268_ _2314_ VGND VGND VPWR VPWR _2328_ sky130_fd_sc_hd__mux2_1
XFILLER_0_82_3 VPWR VGND VPWR VGND sky130_ef_sc_hd__decap_12
X_6585_ net648 _1462_ _2842_ VGND VGND VPWR VPWR _2858_ sky130_fd_sc_hd__mux2_1
X_8324_ clknet_leaf_42_clk _0413_ VGND VGND VPWR VPWR u_input_buffer.fifo_mem\[43\]\[10\]
+ sky130_fd_sc_hd__dfxtp_1
X_5536_ _2290_ VGND VGND VPWR VPWR _0623_ sky130_fd_sc_hd__clkbuf_1
X_5467_ _1390_ VGND VGND VPWR VPWR _2248_ sky130_fd_sc_hd__clkbuf_4
X_8255_ clknet_leaf_61_clk _0344_ VGND VGND VPWR VPWR u_input_buffer.fifo_mem\[47\]\[5\]
+ sky130_fd_sc_hd__dfxtp_1
X_4418_ _1663_ VGND VGND VPWR VPWR _0132_ sky130_fd_sc_hd__clkbuf_1
X_7206_ _3441_ _3443_ _3445_ _3447_ VGND VGND VPWR VPWR _3448_ sky130_fd_sc_hd__or4_2
XFILLER_0_1_370 VGND VGND VPWR VPWR sky130_fd_sc_hd__decap_6
X_8186_ clknet_leaf_37_clk _0275_ VGND VGND VPWR VPWR u_input_buffer.fifo_mem\[51\]\[0\]
+ sky130_fd_sc_hd__dfxtp_1
X_5398_ _2209_ VGND VGND VPWR VPWR _0566_ sky130_fd_sc_hd__clkbuf_1
X_4349_ _1619_ VGND VGND VPWR VPWR _0107_ sky130_fd_sc_hd__clkbuf_1
X_7137_ u_input_buffer.fifo_mem\[6\]\[8\] _3035_ _3037_ u_input_buffer.fifo_mem\[28\]\[8\]
+ _3380_ VGND VGND VPWR VPWR _3381_ sky130_fd_sc_hd__a221o_1
X_7068_ u_input_buffer.fifo_mem\[63\]\[6\] _2887_ _3076_ u_input_buffer.fifo_mem\[55\]\[6\]
+ _3313_ VGND VGND VPWR VPWR _3314_ sky130_fd_sc_hd__a221o_1
X_6019_ net566 _2510_ _2549_ VGND VGND VPWR VPWR _2556_ sky130_fd_sc_hd__mux2_1
XFILLER_0_96_402 VGND VGND VPWR VPWR sky130_fd_sc_hd__decap_6
XTAP_1314 VGND VPWR sky130_fd_sc_hd__tapvpwrvgnd_1
XTAP_1303 VGND VPWR sky130_fd_sc_hd__tapvpwrvgnd_1
XTAP_1347 VGND VPWR sky130_fd_sc_hd__tapvpwrvgnd_1
XTAP_1336 VGND VPWR sky130_fd_sc_hd__tapvpwrvgnd_1
XTAP_1325 VGND VPWR sky130_fd_sc_hd__tapvpwrvgnd_1
XTAP_1358 VGND VPWR sky130_fd_sc_hd__tapvpwrvgnd_1
XTAP_1369 VGND VPWR sky130_fd_sc_hd__tapvpwrvgnd_1
XFILLER_0_77_682 VGND VGND VPWR VPWR sky130_fd_sc_hd__fill_1
XFILLER_0_37_513 VGND VGND VPWR VPWR sky130_fd_sc_hd__decap_3
XFILLER_0_92_630 VPWR VGND VPWR VGND sky130_ef_sc_hd__decap_12
XFILLER_0_64_365 VGND VGND VPWR VPWR sky130_fd_sc_hd__decap_3
XFILLER_0_107_456 VPWR VGND VPWR VGND sky130_ef_sc_hd__decap_12
XFILLER_0_17_281 VGND VGND VPWR VPWR sky130_fd_sc_hd__decap_4
XFILLER_0_45_590 VGND VGND VPWR VPWR sky130_fd_sc_hd__decap_6
XFILLER_0_32_262 VGND VGND VPWR VPWR sky130_fd_sc_hd__fill_1
XFILLER_0_103_673 VPWR VGND VPWR VGND sky130_ef_sc_hd__decap_12
XFILLER_0_74_29 VGND VGND VPWR VPWR sky130_fd_sc_hd__decap_6
XFILLER_0_99_284 VGND VGND VPWR VPWR sky130_fd_sc_hd__fill_1
XFILLER_0_87_424 VGND VGND VPWR VPWR sky130_fd_sc_hd__decap_4
XFILLER_0_59_126 VGND VGND VPWR VPWR sky130_fd_sc_hd__fill_1
XFILLER_0_83_652 VGND VGND VPWR VPWR sky130_fd_sc_hd__fill_1
XFILLER_0_99_15 VPWR VGND VPWR VGND sky130_ef_sc_hd__decap_12
Xclkbuf_leaf_40_clk clknet_3_4__leaf_clk VGND VGND VPWR VPWR clknet_leaf_40_clk sky130_fd_sc_hd__clkbuf_16
X_6370_ _2744_ VGND VGND VPWR VPWR _1003_ sky130_fd_sc_hd__clkbuf_1
X_5321_ _1853_ _1930_ VGND VGND VPWR VPWR _2168_ sky130_fd_sc_hd__nor2_4
XFILLER_0_11_446 VGND VGND VPWR VPWR sky130_fd_sc_hd__fill_2
X_8040_ clknet_leaf_102_clk _0129_ VGND VGND VPWR VPWR u_input_buffer.fifo_mem\[61\]\[14\]
+ sky130_fd_sc_hd__dfxtp_1
X_5252_ _2131_ VGND VGND VPWR VPWR _0498_ sky130_fd_sc_hd__clkbuf_1
X_4203_ u_sample_counter.sample_count\[12\] u_sample_counter.sample_count\[13\] u_sample_counter.sample_count\[14\]
+ u_sample_counter.sample_count\[15\] VGND VGND VPWR VPWR _1500_ sky130_fd_sc_hd__and4_1
X_5183_ _2094_ VGND VGND VPWR VPWR _0466_ sky130_fd_sc_hd__clkbuf_1
X_4134_ u_input_buffer.data_in\[12\] VGND VGND VPWR VPWR _1450_ sky130_fd_sc_hd__buf_4
X_4065_ _1390_ VGND VGND VPWR VPWR _1391_ sky130_fd_sc_hd__clkbuf_4
XFILLER_0_78_402 VGND VGND VPWR VPWR sky130_fd_sc_hd__decap_3
X_8942_ clknet_leaf_39_clk _1031_ VGND VGND VPWR VPWR u_input_buffer.fifo_mem\[4\]\[4\]
+ sky130_fd_sc_hd__dfxtp_1
X_8873_ clknet_leaf_99_clk _0962_ VGND VGND VPWR VPWR u_input_buffer.fifo_mem\[9\]\[15\]
+ sky130_fd_sc_hd__dfxtp_1
X_7824_ net39 u_register_bank.sensor_enable\[5\] _3905_ VGND VGND VPWR VPWR _3911_
+ sky130_fd_sc_hd__mux2_1
XFILLER_0_59_682 VGND VGND VPWR VPWR sky130_fd_sc_hd__fill_1
XFILLER_0_59_671 VGND VGND VPWR VPWR sky130_fd_sc_hd__fill_1
XFILLER_0_93_449 VGND VGND VPWR VPWR sky130_fd_sc_hd__fill_1
XFILLER_0_74_641 VGND VGND VPWR VPWR sky130_fd_sc_hd__decap_3
X_4967_ _1385_ net1236 _1971_ VGND VGND VPWR VPWR _1973_ sky130_fd_sc_hd__mux2_1
XFILLER_0_46_321 VGND VGND VPWR VPWR sky130_fd_sc_hd__fill_1
X_7755_ u_register_bank.status_flags\[26\] _3849_ _3843_ u_register_bank.sensor_enable\[26\]
+ VGND VGND VPWR VPWR _3869_ sky130_fd_sc_hd__a22o_1
Xclkbuf_leaf_31_clk clknet_3_5__leaf_clk VGND VGND VPWR VPWR clknet_leaf_31_clk sky130_fd_sc_hd__clkbuf_16
X_6706_ _2957_ VGND VGND VPWR VPWR _2958_ sky130_fd_sc_hd__clkbuf_4
X_4898_ net572 _1706_ _1934_ VGND VGND VPWR VPWR _1936_ sky130_fd_sc_hd__mux2_1
XFILLER_0_19_568 VGND VGND VPWR VPWR sky130_fd_sc_hd__fill_2
X_7686_ u_register_bank.window_cfg\[10\] _3812_ _3813_ u_analytics_engine.threshold\[10\]
+ _3815_ VGND VGND VPWR VPWR _3816_ sky130_fd_sc_hd__a221o_1
XFILLER_0_61_313 VGND VGND VPWR VPWR sky130_fd_sc_hd__decap_3
X_6637_ net1317 _1932_ VGND VGND VPWR VPWR _1124_ sky130_fd_sc_hd__xnor2_1
X_6568_ _2849_ VGND VGND VPWR VPWR _1096_ sky130_fd_sc_hd__clkbuf_1
XFILLER_0_61_346 VGND VGND VPWR VPWR sky130_fd_sc_hd__fill_2
X_5519_ net798 _2252_ _2277_ VGND VGND VPWR VPWR _2282_ sky130_fd_sc_hd__mux2_1
X_8307_ clknet_leaf_39_clk _0396_ VGND VGND VPWR VPWR u_input_buffer.fifo_mem\[44\]\[9\]
+ sky130_fd_sc_hd__dfxtp_1
X_6499_ net606 _1408_ _2807_ VGND VGND VPWR VPWR _2813_ sky130_fd_sc_hd__mux2_1
XFILLER_0_14_295 VGND VGND VPWR VPWR sky130_fd_sc_hd__fill_2
X_8238_ clknet_leaf_17_clk _0327_ VGND VGND VPWR VPWR u_input_buffer.fifo_mem\[48\]\[4\]
+ sky130_fd_sc_hd__dfxtp_1
X_8169_ clknet_leaf_104_clk _0258_ VGND VGND VPWR VPWR u_input_buffer.fifo_mem\[53\]\[15\]
+ sky130_fd_sc_hd__dfxtp_1
Xclkbuf_leaf_98_clk clknet_3_1__leaf_clk VGND VGND VPWR VPWR clknet_leaf_98_clk sky130_fd_sc_hd__clkbuf_16
Xfanout197 net200 VGND VGND VPWR VPWR net197 sky130_fd_sc_hd__buf_2
Xfanout175 net183 VGND VGND VPWR VPWR net175 sky130_fd_sc_hd__buf_2
Xfanout186 net200 VGND VGND VPWR VPWR net186 sky130_fd_sc_hd__buf_2
XFILLER_0_69_402 VGND VGND VPWR VPWR sky130_fd_sc_hd__fill_1
XFILLER_0_96_210 VGND VGND VPWR VPWR sky130_fd_sc_hd__decap_4
XTAP_1111 VGND VPWR sky130_fd_sc_hd__tapvpwrvgnd_1
XTAP_1122 VGND VPWR sky130_fd_sc_hd__tapvpwrvgnd_1
XTAP_1100 VGND VPWR sky130_fd_sc_hd__tapvpwrvgnd_1
XFILLER_0_84_416 VGND VGND VPWR VPWR sky130_fd_sc_hd__decap_4
XTAP_1155 VGND VPWR sky130_fd_sc_hd__tapvpwrvgnd_1
XTAP_1144 VGND VPWR sky130_fd_sc_hd__tapvpwrvgnd_1
XTAP_1133 VGND VPWR sky130_fd_sc_hd__tapvpwrvgnd_1
XFILLER_0_56_118 VGND VGND VPWR VPWR sky130_fd_sc_hd__fill_1
XTAP_1199 VGND VPWR sky130_fd_sc_hd__tapvpwrvgnd_1
XTAP_1188 VGND VPWR sky130_fd_sc_hd__tapvpwrvgnd_1
XTAP_1177 VGND VPWR sky130_fd_sc_hd__tapvpwrvgnd_1
XTAP_1166 VGND VPWR sky130_fd_sc_hd__tapvpwrvgnd_1
XFILLER_0_107_220 VGND VGND VPWR VPWR sky130_fd_sc_hd__decap_4
Xclkbuf_leaf_22_clk clknet_3_4__leaf_clk VGND VGND VPWR VPWR clknet_leaf_22_clk sky130_fd_sc_hd__clkbuf_16
XFILLER_0_37_376 VGND VGND VPWR VPWR sky130_fd_sc_hd__decap_8
XFILLER_0_80_666 VGND VGND VPWR VPWR sky130_fd_sc_hd__fill_1
XFILLER_0_52_368 VGND VGND VPWR VPWR sky130_fd_sc_hd__fill_1
XFILLER_0_100_26 VGND VGND VPWR VPWR sky130_fd_sc_hd__fill_2
XTAP_917 VGND VPWR sky130_fd_sc_hd__tapvpwrvgnd_1
XTAP_906 VGND VPWR sky130_fd_sc_hd__tapvpwrvgnd_1
XTAP_939 VGND VPWR sky130_fd_sc_hd__tapvpwrvgnd_1
XTAP_928 VGND VPWR sky130_fd_sc_hd__tapvpwrvgnd_1
XFILLER_0_20_298 VGND VGND VPWR VPWR sky130_fd_sc_hd__decap_4
XFILLER_0_109_57 VPWR VGND VPWR VGND sky130_ef_sc_hd__decap_12
Xclkbuf_leaf_89_clk clknet_3_2__leaf_clk VGND VGND VPWR VPWR clknet_leaf_89_clk sky130_fd_sc_hd__clkbuf_16
XFILLER_0_18_66 VGND VGND VPWR VPWR sky130_fd_sc_hd__fill_1
XFILLER_0_18_99 VGND VGND VPWR VPWR sky130_fd_sc_hd__fill_1
X_5870_ _2469_ VGND VGND VPWR VPWR _0778_ sky130_fd_sc_hd__clkbuf_1
X_4821_ _1634_ net166 VGND VGND VPWR VPWR _1892_ sky130_fd_sc_hd__nand2_4
XFILLER_0_34_98 VGND VGND VPWR VPWR sky130_fd_sc_hd__fill_2
XFILLER_0_71_611 VGND VGND VPWR VPWR sky130_fd_sc_hd__decap_4
X_7540_ _3723_ VGND VGND VPWR VPWR _1194_ sky130_fd_sc_hd__clkbuf_1
X_4752_ _1854_ VGND VGND VPWR VPWR _1855_ sky130_fd_sc_hd__clkbuf_4
Xclkbuf_leaf_13_clk clknet_3_1__leaf_clk VGND VGND VPWR VPWR clknet_leaf_13_clk sky130_fd_sc_hd__clkbuf_16
XFILLER_0_16_505 VGND VGND VPWR VPWR sky130_fd_sc_hd__decap_4
X_7471_ net366 _1414_ _3678_ VGND VGND VPWR VPWR _3685_ sky130_fd_sc_hd__mux2_1
X_4683_ _1377_ net816 _1817_ VGND VGND VPWR VPWR _1818_ sky130_fd_sc_hd__mux2_1
XFILLER_0_113_212 VPWR VGND VPWR VGND sky130_ef_sc_hd__decap_12
X_6422_ _2772_ VGND VGND VPWR VPWR _1027_ sky130_fd_sc_hd__clkbuf_1
XFILLER_0_71_655 VGND VGND VPWR VPWR sky130_fd_sc_hd__decap_4
XFILLER_0_3_421 VPWR VGND VPWR VGND sky130_ef_sc_hd__decap_12
X_9210_ net171 _1297_ net204 VGND VGND VPWR VPWR u_register_bank.sensor_enable\[11\]
+ sky130_fd_sc_hd__dfrtp_1
X_9141_ net176 _1229_ net208 VGND VGND VPWR VPWR u_register_bank.threshold_cfg\[23\]
+ sky130_fd_sc_hd__dfrtp_1
X_6353_ net1176 _2496_ _2735_ VGND VGND VPWR VPWR _2736_ sky130_fd_sc_hd__mux2_1
XFILLER_0_101_418 VGND VGND VPWR VPWR sky130_fd_sc_hd__fill_1
XFILLER_0_59_51 VGND VGND VPWR VPWR sky130_fd_sc_hd__decap_4
X_5304_ _2159_ VGND VGND VPWR VPWR _0522_ sky130_fd_sc_hd__clkbuf_1
X_9072_ clknet_leaf_49_clk _1160_ VGND VGND VPWR VPWR u_input_buffer.fifo_mem\[63\]\[2\]
+ sky130_fd_sc_hd__dfxtp_1
X_6284_ net643 _2496_ _2698_ VGND VGND VPWR VPWR _2699_ sky130_fd_sc_hd__mux2_1
X_5235_ net1227 _2004_ _2115_ VGND VGND VPWR VPWR _2123_ sky130_fd_sc_hd__mux2_1
X_8023_ clknet_leaf_87_clk _0112_ VGND VGND VPWR VPWR u_input_buffer.fifo_mem\[62\]\[13\]
+ sky130_fd_sc_hd__dfxtp_1
X_5166_ net714 _2004_ _2078_ VGND VGND VPWR VPWR _2086_ sky130_fd_sc_hd__mux2_1
X_5097_ _2049_ VGND VGND VPWR VPWR _0425_ sky130_fd_sc_hd__clkbuf_1
X_4117_ _1435_ u_sensor_interface.sensor_array\[3\]\[9\] _1381_ VGND VGND VPWR VPWR
+ _1436_ sky130_fd_sc_hd__mux2_1
X_4048_ u_input_buffer.data_in\[0\] VGND VGND VPWR VPWR _1376_ sky130_fd_sc_hd__clkbuf_4
X_8925_ clknet_leaf_111_clk _1014_ VGND VGND VPWR VPWR u_input_buffer.fifo_mem\[5\]\[3\]
+ sky130_fd_sc_hd__dfxtp_1
XPHY_216 VGND VGND VPWR VPWR sky130_fd_sc_hd__decap_3
XPHY_205 VGND VGND VPWR VPWR sky130_fd_sc_hd__decap_3
X_8856_ clknet_leaf_71_clk _0945_ VGND VGND VPWR VPWR u_input_buffer.fifo_mem\[10\]\[14\]
+ sky130_fd_sc_hd__dfxtp_1
X_7807_ _3901_ VGND VGND VPWR VPWR _1283_ sky130_fd_sc_hd__clkbuf_1
XPHY_227 VGND VGND VPWR VPWR sky130_fd_sc_hd__decap_3
X_8787_ clknet_leaf_29_clk _0876_ VGND VGND VPWR VPWR u_input_buffer.fifo_mem\[14\]\[9\]
+ sky130_fd_sc_hd__dfxtp_1
X_5999_ _1628_ net1044 _2530_ VGND VGND VPWR VPWR _2545_ sky130_fd_sc_hd__mux2_1
X_7738_ _3856_ VGND VGND VPWR VPWR _1259_ sky130_fd_sc_hd__clkbuf_1
X_7669_ u_register_bank.status_flags\[7\] _3775_ _3778_ u_register_bank.sensor_enable\[7\]
+ VGND VGND VPWR VPWR _3802_ sky130_fd_sc_hd__a22o_1
XFILLER_0_15_582 VPWR VGND VPWR VGND sky130_ef_sc_hd__decap_12
XFILLER_0_104_256 VGND VGND VPWR VPWR sky130_fd_sc_hd__decap_4
Xhold9 u_sample_counter.sample_count\[21\] VGND VGND VPWR VPWR net221 sky130_fd_sc_hd__dlygate4sd3_1
XFILLER_0_69_210 VGND VGND VPWR VPWR sky130_fd_sc_hd__decap_4
XFILLER_0_84_213 VGND VGND VPWR VPWR sky130_fd_sc_hd__decap_4
XFILLER_0_53_611 VGND VGND VPWR VPWR sky130_fd_sc_hd__fill_1
XFILLER_0_111_69 VPWR VGND VPWR VGND sky130_ef_sc_hd__decap_12
Xhold409 u_sensor_interface.sensor_array\[2\]\[15\] VGND VGND VPWR VPWR net621 sky130_fd_sc_hd__dlygate4sd3_1
XFILLER_0_33_390 VGND VGND VPWR VPWR sky130_fd_sc_hd__fill_2
XFILLER_0_96_27 VGND VGND VPWR VPWR sky130_fd_sc_hd__fill_1
XTAP_703 VGND VPWR sky130_fd_sc_hd__tapvpwrvgnd_1
XTAP_725 VGND VPWR sky130_fd_sc_hd__tapvpwrvgnd_1
XTAP_714 VGND VPWR sky130_fd_sc_hd__tapvpwrvgnd_1
X_5020_ _1420_ VGND VGND VPWR VPWR _2004_ sky130_fd_sc_hd__buf_4
XFILLER_0_29_54 VGND VGND VPWR VPWR sky130_fd_sc_hd__fill_2
XTAP_736 VGND VPWR sky130_fd_sc_hd__tapvpwrvgnd_1
XTAP_747 VGND VPWR sky130_fd_sc_hd__tapvpwrvgnd_1
XTAP_758 VGND VPWR sky130_fd_sc_hd__tapvpwrvgnd_1
Xhold1109 net160 VGND VGND VPWR VPWR net1321 sky130_fd_sc_hd__dlygate4sd3_1
Xclkbuf_leaf_2_clk clknet_3_1__leaf_clk VGND VGND VPWR VPWR clknet_leaf_2_clk sky130_fd_sc_hd__clkbuf_16
XTAP_769 VGND VPWR sky130_fd_sc_hd__tapvpwrvgnd_1
X_6971_ u_input_buffer.fifo_mem\[51\]\[4\] _2990_ _2993_ u_input_buffer.fifo_mem\[11\]\[4\]
+ _3218_ VGND VGND VPWR VPWR _3219_ sky130_fd_sc_hd__a221o_1
X_8710_ clknet_leaf_80_clk _0799_ VGND VGND VPWR VPWR u_input_buffer.fifo_mem\[19\]\[12\]
+ sky130_fd_sc_hd__dfxtp_1
X_5922_ _1872_ _2242_ VGND VGND VPWR VPWR _2497_ sky130_fd_sc_hd__nor2_4
XFILLER_0_48_416 VGND VGND VPWR VPWR sky130_fd_sc_hd__decap_4
X_8641_ clknet_leaf_51_clk _0730_ VGND VGND VPWR VPWR u_input_buffer.fifo_mem\[23\]\[7\]
+ sky130_fd_sc_hd__dfxtp_1
XFILLER_0_61_52 VGND VGND VPWR VPWR sky130_fd_sc_hd__decap_4
XFILLER_0_0_55 VGND VGND VPWR VPWR sky130_fd_sc_hd__fill_1
X_5853_ _1834_ _2242_ VGND VGND VPWR VPWR _2460_ sky130_fd_sc_hd__nor2_4
X_8572_ clknet_leaf_45_clk _0661_ VGND VGND VPWR VPWR u_input_buffer.fifo_mem\[27\]\[2\]
+ sky130_fd_sc_hd__dfxtp_1
X_4804_ net439 _1720_ _1874_ VGND VGND VPWR VPWR _1883_ sky130_fd_sc_hd__mux2_1
XFILLER_0_61_74 VGND VGND VPWR VPWR sky130_fd_sc_hd__fill_1
X_5784_ _2423_ VGND VGND VPWR VPWR _0738_ sky130_fd_sc_hd__clkbuf_1
XFILLER_0_56_471 VGND VGND VPWR VPWR sky130_fd_sc_hd__decap_4
XFILLER_0_16_313 VGND VGND VPWR VPWR sky130_fd_sc_hd__fill_1
X_7523_ _3714_ VGND VGND VPWR VPWR _1186_ sky130_fd_sc_hd__clkbuf_1
X_4735_ _1845_ VGND VGND VPWR VPWR _0267_ sky130_fd_sc_hd__clkbuf_1
XFILLER_0_28_195 VGND VGND VPWR VPWR sky130_fd_sc_hd__fill_1
X_4666_ net757 _1722_ _1798_ VGND VGND VPWR VPWR _1808_ sky130_fd_sc_hd__mux2_1
X_7454_ _3675_ VGND VGND VPWR VPWR _1156_ sky130_fd_sc_hd__clkbuf_1
XFILLER_0_114_587 VGND VGND VPWR VPWR sky130_fd_sc_hd__fill_1
Xhold910 u_input_buffer.fifo_mem\[61\]\[12\] VGND VGND VPWR VPWR net1122 sky130_fd_sc_hd__dlygate4sd3_1
X_7385_ u_input_buffer.fifo_mem\[21\]\[15\] _2908_ _2912_ u_input_buffer.fifo_mem\[25\]\[15\]
+ VGND VGND VPWR VPWR _3622_ sky130_fd_sc_hd__a22o_1
X_6405_ _1620_ net1161 _2753_ VGND VGND VPWR VPWR _2763_ sky130_fd_sc_hd__mux2_1
X_4597_ net291 _1726_ _1756_ VGND VGND VPWR VPWR _1769_ sky130_fd_sc_hd__mux2_1
Xhold921 u_input_buffer.fifo_mem\[32\]\[12\] VGND VGND VPWR VPWR net1133 sky130_fd_sc_hd__dlygate4sd3_1
X_9124_ net180 _1212_ net210 VGND VGND VPWR VPWR u_analytics_engine.threshold\[6\]
+ sky130_fd_sc_hd__dfrtp_1
X_6336_ _2726_ VGND VGND VPWR VPWR _0987_ sky130_fd_sc_hd__clkbuf_1
Xhold932 u_input_buffer.fifo_mem\[3\]\[10\] VGND VGND VPWR VPWR net1144 sky130_fd_sc_hd__dlygate4sd3_1
Xhold954 u_input_buffer.fifo_mem\[26\]\[12\] VGND VGND VPWR VPWR net1166 sky130_fd_sc_hd__dlygate4sd3_1
Xhold943 u_input_buffer.fifo_mem\[25\]\[4\] VGND VGND VPWR VPWR net1155 sky130_fd_sc_hd__dlygate4sd3_1
Xhold998 u_input_buffer.fifo_mem\[22\]\[2\] VGND VGND VPWR VPWR net1210 sky130_fd_sc_hd__dlygate4sd3_1
X_9055_ clknet_leaf_23_clk _1144_ VGND VGND VPWR VPWR u_sensor_interface.sensor_array\[3\]\[2\]
+ sky130_fd_sc_hd__dfxtp_1
Xhold965 u_input_buffer.fifo_mem\[63\]\[8\] VGND VGND VPWR VPWR net1177 sky130_fd_sc_hd__dlygate4sd3_1
Xhold976 u_input_buffer.fifo_mem\[41\]\[3\] VGND VGND VPWR VPWR net1188 sky130_fd_sc_hd__dlygate4sd3_1
Xhold987 u_input_buffer.fifo_mem\[9\]\[10\] VGND VGND VPWR VPWR net1199 sky130_fd_sc_hd__dlygate4sd3_1
X_6267_ _2689_ VGND VGND VPWR VPWR _0955_ sky130_fd_sc_hd__clkbuf_1
X_8006_ clknet_leaf_62_clk _0095_ net196 VGND VGND VPWR VPWR u_sample_counter.sample_count\[29\]
+ sky130_fd_sc_hd__dfrtp_1
X_6198_ net406 _2514_ _2644_ VGND VGND VPWR VPWR _2653_ sky130_fd_sc_hd__mux2_1
X_5218_ _2113_ VGND VGND VPWR VPWR _0482_ sky130_fd_sc_hd__clkbuf_1
X_5149_ _2076_ VGND VGND VPWR VPWR _0450_ sky130_fd_sc_hd__clkbuf_1
X_8908_ clknet_leaf_55_clk _0997_ VGND VGND VPWR VPWR u_input_buffer.fifo_mem\[6\]\[2\]
+ sky130_fd_sc_hd__dfxtp_1
XFILLER_0_94_533 VGND VGND VPWR VPWR sky130_fd_sc_hd__fill_1
X_8839_ clknet_leaf_10_clk _0928_ VGND VGND VPWR VPWR u_input_buffer.fifo_mem\[11\]\[13\]
+ sky130_fd_sc_hd__dfxtp_1
XFILLER_0_109_337 VGND VGND VPWR VPWR sky130_fd_sc_hd__fill_1
XFILLER_0_66_279 VGND VGND VPWR VPWR sky130_fd_sc_hd__fill_2
XFILLER_0_54_419 VGND VGND VPWR VPWR sky130_fd_sc_hd__fill_1
XFILLER_0_35_633 VGND VGND VPWR VPWR sky130_fd_sc_hd__decap_8
XFILLER_0_62_474 VGND VGND VPWR VPWR sky130_fd_sc_hd__fill_2
XFILLER_0_30_382 VGND VGND VPWR VPWR sky130_fd_sc_hd__fill_2
XFILLER_0_82_29 VGND VGND VPWR VPWR sky130_fd_sc_hd__decap_4
XFILLER_0_106_25 VGND VGND VPWR VPWR sky130_fd_sc_hd__decap_3
XFILLER_0_57_279 VGND VGND VPWR VPWR sky130_fd_sc_hd__fill_1
XFILLER_0_5_505 VPWR VGND VPWR VGND sky130_ef_sc_hd__decap_12
XFILLER_0_26_600 VGND VGND VPWR VPWR sky130_fd_sc_hd__decap_8
XFILLER_0_108_381 VGND VGND VPWR VPWR sky130_fd_sc_hd__fill_2
X_4520_ net462 _1724_ _1703_ VGND VGND VPWR VPWR _1725_ sky130_fd_sc_hd__mux2_1
XFILLER_0_25_165 VGND VGND VPWR VPWR sky130_fd_sc_hd__decap_3
XFILLER_0_103_3 VPWR VGND VPWR VGND sky130_ef_sc_hd__decap_12
Xhold206 u_input_buffer.fifo_mem\[16\]\[11\] VGND VGND VPWR VPWR net418 sky130_fd_sc_hd__dlygate4sd3_1
X_4451_ _1681_ VGND VGND VPWR VPWR _1682_ sky130_fd_sc_hd__clkbuf_4
Xhold217 u_input_buffer.fifo_mem\[24\]\[14\] VGND VGND VPWR VPWR net429 sky130_fd_sc_hd__dlygate4sd3_1
Xhold239 u_input_buffer.fifo_mem\[7\]\[0\] VGND VGND VPWR VPWR net451 sky130_fd_sc_hd__dlygate4sd3_1
X_7170_ u_input_buffer.fifo_mem\[8\]\[9\] _3004_ _3006_ u_input_buffer.fifo_mem\[19\]\[9\]
+ _3412_ VGND VGND VPWR VPWR _3413_ sky130_fd_sc_hd__a221o_1
Xhold228 u_input_buffer.fifo_mem\[19\]\[9\] VGND VGND VPWR VPWR net440 sky130_fd_sc_hd__dlygate4sd3_1
XFILLER_0_111_557 VGND VGND VPWR VPWR sky130_fd_sc_hd__decap_3
XTAP_500 VGND VPWR sky130_fd_sc_hd__tapvpwrvgnd_1
X_6121_ _1610_ net968 _2607_ VGND VGND VPWR VPWR _2612_ sky130_fd_sc_hd__mux2_1
X_4382_ _1643_ VGND VGND VPWR VPWR _0116_ sky130_fd_sc_hd__clkbuf_1
XTAP_511 VGND VPWR sky130_fd_sc_hd__tapvpwrvgnd_1
XTAP_522 VGND VPWR sky130_fd_sc_hd__tapvpwrvgnd_1
XTAP_533 VGND VPWR sky130_fd_sc_hd__tapvpwrvgnd_1
X_6052_ _2574_ VGND VGND VPWR VPWR _0855_ sky130_fd_sc_hd__clkbuf_1
XTAP_544 VGND VPWR sky130_fd_sc_hd__tapvpwrvgnd_1
XTAP_555 VGND VPWR sky130_fd_sc_hd__tapvpwrvgnd_1
XTAP_566 VGND VPWR sky130_fd_sc_hd__tapvpwrvgnd_1
X_5003_ net720 _1992_ _1990_ VGND VGND VPWR VPWR _1993_ sky130_fd_sc_hd__mux2_1
XTAP_577 VGND VPWR sky130_fd_sc_hd__tapvpwrvgnd_1
XTAP_588 VGND VPWR sky130_fd_sc_hd__tapvpwrvgnd_1
XTAP_599 VGND VPWR sky130_fd_sc_hd__tapvpwrvgnd_1
X_6954_ net452 _3086_ _3088_ VGND VGND VPWR VPWR _3203_ sky130_fd_sc_hd__o21a_1
X_5905_ net385 _2260_ _2479_ VGND VGND VPWR VPWR _2488_ sky130_fd_sc_hd__mux2_1
X_8624_ clknet_leaf_60_clk _0713_ VGND VGND VPWR VPWR u_input_buffer.fifo_mem\[24\]\[6\]
+ sky130_fd_sc_hd__dfxtp_1
X_6885_ u_input_buffer.fifo_mem\[1\]\[2\] _2932_ _3132_ _3134_ VGND VGND VPWR VPWR
+ _3135_ sky130_fd_sc_hd__a211o_1
XFILLER_0_91_514 VGND VGND VPWR VPWR sky130_fd_sc_hd__decap_3
X_5836_ _2451_ VGND VGND VPWR VPWR _0762_ sky130_fd_sc_hd__clkbuf_1
XFILLER_0_106_318 VGND VGND VPWR VPWR sky130_fd_sc_hd__decap_4
X_8555_ clknet_leaf_52_clk _0644_ VGND VGND VPWR VPWR u_input_buffer.fifo_mem\[28\]\[1\]
+ sky130_fd_sc_hd__dfxtp_1
X_5767_ net569 _2258_ _2407_ VGND VGND VPWR VPWR _2415_ sky130_fd_sc_hd__mux2_1
X_4718_ net558 _1700_ _1836_ VGND VGND VPWR VPWR _1837_ sky130_fd_sc_hd__mux2_1
X_7506_ _3705_ VGND VGND VPWR VPWR _1178_ sky130_fd_sc_hd__clkbuf_1
X_8486_ clknet_leaf_106_clk _0575_ VGND VGND VPWR VPWR u_input_buffer.fifo_mem\[33\]\[12\]
+ sky130_fd_sc_hd__dfxtp_1
XFILLER_0_44_474 VGND VGND VPWR VPWR sky130_fd_sc_hd__fill_2
X_5698_ _1616_ net1211 _2370_ VGND VGND VPWR VPWR _2378_ sky130_fd_sc_hd__mux2_1
X_7437_ u_sensor_interface.sensor_array\[3\]\[6\] net95 _3662_ VGND VGND VPWR VPWR
+ _3667_ sky130_fd_sc_hd__mux2_1
X_4649_ _1799_ VGND VGND VPWR VPWR _0227_ sky130_fd_sc_hd__clkbuf_1
Xhold740 u_input_buffer.fifo_mem\[42\]\[5\] VGND VGND VPWR VPWR net952 sky130_fd_sc_hd__dlygate4sd3_1
Xhold762 u_input_buffer.fifo_mem\[10\]\[5\] VGND VGND VPWR VPWR net974 sky130_fd_sc_hd__dlygate4sd3_1
Xhold751 u_input_buffer.fifo_mem\[44\]\[8\] VGND VGND VPWR VPWR net963 sky130_fd_sc_hd__dlygate4sd3_1
X_7368_ u_input_buffer.fifo_mem\[30\]\[14\] _3028_ _3030_ u_input_buffer.fifo_mem\[58\]\[14\]
+ VGND VGND VPWR VPWR _3606_ sky130_fd_sc_hd__a22o_1
Xhold773 u_input_buffer.fifo_mem\[37\]\[13\] VGND VGND VPWR VPWR net985 sky130_fd_sc_hd__dlygate4sd3_1
XFILLER_0_31_179 VGND VGND VPWR VPWR sky130_fd_sc_hd__fill_2
X_6319_ net451 _2496_ _2717_ VGND VGND VPWR VPWR _2718_ sky130_fd_sc_hd__mux2_1
X_9107_ net177 _1195_ net209 VGND VGND VPWR VPWR u_register_bank.window_cfg\[21\]
+ sky130_fd_sc_hd__dfrtp_1
X_7299_ u_input_buffer.fifo_mem\[3\]\[12\] _3069_ _3071_ u_input_buffer.fifo_mem\[60\]\[12\]
+ VGND VGND VPWR VPWR _3539_ sky130_fd_sc_hd__a22o_1
Xhold784 u_input_buffer.fifo_mem\[33\]\[15\] VGND VGND VPWR VPWR net996 sky130_fd_sc_hd__dlygate4sd3_1
Xhold795 u_input_buffer.fifo_mem\[17\]\[1\] VGND VGND VPWR VPWR net1007 sky130_fd_sc_hd__dlygate4sd3_1
X_9038_ clknet_leaf_48_clk net254 VGND VGND VPWR VPWR u_analytics_engine.data_in\[1\]
+ sky130_fd_sc_hd__dfxtp_1
XFILLER_0_99_636 VPWR VGND VPWR VGND sky130_ef_sc_hd__decap_12
XFILLER_0_109_101 VGND VGND VPWR VPWR sky130_fd_sc_hd__decap_3
XFILLER_0_35_485 VGND VGND VPWR VPWR sky130_fd_sc_hd__decap_3
XFILLER_0_93_39 VPWR VGND VPWR VGND sky130_ef_sc_hd__decap_12
XFILLER_0_89_113 VGND VGND VPWR VPWR sky130_fd_sc_hd__fill_2
X_3951_ _1325_ VGND VGND VPWR VPWR _0003_ sky130_fd_sc_hd__clkbuf_1
XFILLER_0_58_533 VGND VGND VPWR VPWR sky130_fd_sc_hd__fill_2
XFILLER_0_73_514 VGND VGND VPWR VPWR sky130_fd_sc_hd__fill_1
X_6670_ _2896_ _2907_ VGND VGND VPWR VPWR _2922_ sky130_fd_sc_hd__nor2_4
X_5621_ _2337_ VGND VGND VPWR VPWR _0661_ sky130_fd_sc_hd__clkbuf_1
XFILLER_0_115_126 VGND VGND VPWR VPWR sky130_fd_sc_hd__decap_3
X_8340_ clknet_leaf_14_clk _0429_ VGND VGND VPWR VPWR u_input_buffer.fifo_mem\[42\]\[10\]
+ sky130_fd_sc_hd__dfxtp_1
XFILLER_0_5_335 VGND VGND VPWR VPWR sky130_fd_sc_hd__fill_1
X_5552_ _2300_ VGND VGND VPWR VPWR _0629_ sky130_fd_sc_hd__clkbuf_1
X_8271_ clknet_leaf_35_clk _0360_ VGND VGND VPWR VPWR u_input_buffer.fifo_mem\[46\]\[5\]
+ sky130_fd_sc_hd__dfxtp_1
X_4503_ _1713_ VGND VGND VPWR VPWR _0167_ sky130_fd_sc_hd__clkbuf_1
XFILLER_0_26_485 VGND VGND VPWR VPWR sky130_fd_sc_hd__decap_4
X_5483_ net870 _2258_ _2244_ VGND VGND VPWR VPWR _2259_ sky130_fd_sc_hd__mux2_1
XFILLER_0_14_669 VGND VGND VPWR VPWR sky130_fd_sc_hd__decap_4
X_4434_ _1671_ VGND VGND VPWR VPWR _0140_ sky130_fd_sc_hd__clkbuf_1
X_7222_ u_input_buffer.fifo_mem\[26\]\[10\] _3065_ _3067_ u_input_buffer.fifo_mem\[62\]\[10\]
+ _3463_ VGND VGND VPWR VPWR _3464_ sky130_fd_sc_hd__a221o_1
XFILLER_0_111_387 VGND VGND VPWR VPWR sky130_fd_sc_hd__fill_2
X_7153_ u_input_buffer.fifo_mem\[37\]\[9\] _2923_ _2926_ u_input_buffer.fifo_mem\[9\]\[9\]
+ VGND VGND VPWR VPWR _3396_ sky130_fd_sc_hd__a22o_1
X_4365_ u_input_buffer.data_in\[14\] VGND VGND VPWR VPWR _1630_ sky130_fd_sc_hd__clkbuf_4
XFILLER_0_1_585 VPWR VGND VPWR VGND sky130_ef_sc_hd__decap_12
X_7084_ u_input_buffer.fifo_mem\[34\]\[7\] _2966_ _2969_ u_input_buffer.fifo_mem\[48\]\[7\]
+ _3328_ VGND VGND VPWR VPWR _3329_ sky130_fd_sc_hd__a221o_1
XTAP_341 VGND VPWR sky130_fd_sc_hd__tapvpwrvgnd_1
XTAP_330 VGND VPWR sky130_fd_sc_hd__tapvpwrvgnd_1
X_6104_ _2601_ VGND VGND VPWR VPWR _0880_ sky130_fd_sc_hd__clkbuf_1
X_4296_ u_analytics_engine.data_in\[1\] VGND VGND VPWR VPWR _1576_ sky130_fd_sc_hd__inv_2
XTAP_385 VGND VPWR sky130_fd_sc_hd__tapvpwrvgnd_1
XTAP_374 VGND VPWR sky130_fd_sc_hd__tapvpwrvgnd_1
XTAP_363 VGND VPWR sky130_fd_sc_hd__tapvpwrvgnd_1
XTAP_352 VGND VPWR sky130_fd_sc_hd__tapvpwrvgnd_1
X_6035_ net403 _2526_ _2548_ VGND VGND VPWR VPWR _2564_ sky130_fd_sc_hd__mux2_1
XTAP_396 VGND VPWR sky130_fd_sc_hd__tapvpwrvgnd_1
XTAP_1529 VGND VPWR sky130_fd_sc_hd__tapvpwrvgnd_1
XTAP_1507 VGND VPWR sky130_fd_sc_hd__tapvpwrvgnd_1
XTAP_1518 VGND VPWR sky130_fd_sc_hd__tapvpwrvgnd_1
XPHY_25 VGND VGND VPWR VPWR sky130_fd_sc_hd__decap_3
XPHY_14 VGND VGND VPWR VPWR sky130_fd_sc_hd__decap_3
XPHY_36 VGND VGND VPWR VPWR sky130_fd_sc_hd__decap_3
XPHY_47 VGND VGND VPWR VPWR sky130_fd_sc_hd__decap_3
X_7986_ clknet_leaf_80_clk _0075_ net191 VGND VGND VPWR VPWR u_sample_counter.sample_count\[9\]
+ sky130_fd_sc_hd__dfrtp_1
X_6937_ u_input_buffer.fifo_mem\[31\]\[3\] _3017_ _3020_ u_input_buffer.fifo_mem\[38\]\[3\]
+ VGND VGND VPWR VPWR _3186_ sky130_fd_sc_hd__a22o_1
XPHY_58 VGND VGND VPWR VPWR sky130_fd_sc_hd__decap_3
XPHY_69 VGND VGND VPWR VPWR sky130_fd_sc_hd__decap_3
X_6868_ u_input_buffer.fifo_mem\[15\]\[1\] _3060_ _3062_ u_input_buffer.fifo_mem\[43\]\[1\]
+ VGND VGND VPWR VPWR _3119_ sky130_fd_sc_hd__a22o_1
XFILLER_0_76_374 VGND VGND VPWR VPWR sky130_fd_sc_hd__decap_4
XFILLER_0_9_641 VPWR VGND VPWR VGND sky130_ef_sc_hd__decap_12
XFILLER_0_49_588 VGND VGND VPWR VPWR sky130_fd_sc_hd__fill_1
XFILLER_0_9_685 VGND VGND VPWR VPWR sky130_fd_sc_hd__fill_1
X_5819_ _1815_ _2295_ VGND VGND VPWR VPWR _2442_ sky130_fd_sc_hd__nand2_4
XFILLER_0_36_238 VGND VGND VPWR VPWR sky130_fd_sc_hd__fill_1
X_8607_ clknet_leaf_5_clk _0696_ VGND VGND VPWR VPWR u_input_buffer.fifo_mem\[25\]\[5\]
+ sky130_fd_sc_hd__dfxtp_1
XFILLER_0_8_195 VGND VGND VPWR VPWR sky130_fd_sc_hd__fill_1
X_8538_ clknet_leaf_2_clk _0627_ VGND VGND VPWR VPWR u_input_buffer.fifo_mem\[29\]\[0\]
+ sky130_fd_sc_hd__dfxtp_1
X_6799_ _2896_ _3002_ VGND VGND VPWR VPWR _3051_ sky130_fd_sc_hd__nor2_4
XFILLER_0_51_219 VGND VGND VPWR VPWR sky130_fd_sc_hd__decap_4
XFILLER_0_17_485 VGND VGND VPWR VPWR sky130_fd_sc_hd__decap_3
X_8469_ clknet_leaf_9_clk _0558_ VGND VGND VPWR VPWR u_input_buffer.fifo_mem\[34\]\[11\]
+ sky130_fd_sc_hd__dfxtp_1
XFILLER_0_102_365 VGND VGND VPWR VPWR sky130_fd_sc_hd__decap_3
Xhold581 u_input_buffer.fifo_mem\[44\]\[4\] VGND VGND VPWR VPWR net793 sky130_fd_sc_hd__dlygate4sd3_1
Xhold570 u_input_buffer.fifo_mem\[38\]\[13\] VGND VGND VPWR VPWR net782 sky130_fd_sc_hd__dlygate4sd3_1
Xhold592 u_input_buffer.fifo_mem\[60\]\[8\] VGND VGND VPWR VPWR net804 sky130_fd_sc_hd__dlygate4sd3_1
XFILLER_0_99_433 VGND VGND VPWR VPWR sky130_fd_sc_hd__fill_1
XFILLER_0_99_488 VGND VGND VPWR VPWR sky130_fd_sc_hd__fill_1
XFILLER_0_87_617 VGND VGND VPWR VPWR sky130_fd_sc_hd__decap_4
XFILLER_0_67_341 VGND VGND VPWR VPWR sky130_fd_sc_hd__fill_2
XFILLER_0_103_15 VPWR VGND VPWR VGND sky130_ef_sc_hd__decap_12
XFILLER_0_27_238 VGND VGND VPWR VPWR sky130_fd_sc_hd__decap_3
Xoutput119 net119 VGND VGND VPWR VPWR cfg_rdata[14] sky130_fd_sc_hd__clkbuf_4
XFILLER_0_11_617 VPWR VGND VPWR VGND sky130_ef_sc_hd__decap_12
X_4150_ u_sensor_interface.sensor_array\[0\]\[14\] u_sensor_interface.sensor_array\[1\]\[14\]
+ net111 VGND VGND VPWR VPWR _1464_ sky130_fd_sc_hd__mux2_1
X_4081_ _1404_ u_sensor_interface.sensor_array\[2\]\[4\] _1379_ VGND VGND VPWR VPWR
+ _1405_ sky130_fd_sc_hd__mux2_1
X_7840_ _3919_ VGND VGND VPWR VPWR _1298_ sky130_fd_sc_hd__clkbuf_1
XFILLER_0_86_661 VGND VGND VPWR VPWR sky130_fd_sc_hd__decap_8
X_4983_ _1433_ net1083 _1971_ VGND VGND VPWR VPWR _1981_ sky130_fd_sc_hd__mux2_1
X_7771_ u_register_bank.status_flags\[30\] _3774_ _3777_ u_register_bank.sensor_enable\[30\]
+ VGND VGND VPWR VPWR _3881_ sky130_fd_sc_hd__a22o_1
XFILLER_0_92_119 VGND VGND VPWR VPWR sky130_fd_sc_hd__fill_1
XFILLER_0_73_300 VGND VGND VPWR VPWR sky130_fd_sc_hd__fill_1
XFILLER_0_58_385 VGND VGND VPWR VPWR sky130_fd_sc_hd__fill_2
XFILLER_0_58_374 VGND VGND VPWR VPWR sky130_fd_sc_hd__fill_2
XFILLER_0_58_363 VGND VGND VPWR VPWR sky130_fd_sc_hd__fill_1
X_6722_ _2929_ _2967_ VGND VGND VPWR VPWR _2974_ sky130_fd_sc_hd__nor2_2
X_6653_ u_input_buffer.rd_ptr\[5\] u_input_buffer.rd_ptr\[4\] VGND VGND VPWR VPWR
+ _2905_ sky130_fd_sc_hd__or2b_1
X_5604_ _2327_ VGND VGND VPWR VPWR _0654_ sky130_fd_sc_hd__clkbuf_1
X_6584_ _2857_ VGND VGND VPWR VPWR _1104_ sky130_fd_sc_hd__clkbuf_1
X_8323_ clknet_leaf_39_clk _0412_ VGND VGND VPWR VPWR u_input_buffer.fifo_mem\[43\]\[9\]
+ sky130_fd_sc_hd__dfxtp_1
X_5535_ net909 _2268_ _2276_ VGND VGND VPWR VPWR _2290_ sky130_fd_sc_hd__mux2_1
XFILLER_0_41_241 VGND VGND VPWR VPWR sky130_fd_sc_hd__fill_1
X_5466_ _2247_ VGND VGND VPWR VPWR _0596_ sky130_fd_sc_hd__clkbuf_1
X_8254_ clknet_leaf_61_clk _0343_ VGND VGND VPWR VPWR u_input_buffer.fifo_mem\[47\]\[4\]
+ sky130_fd_sc_hd__dfxtp_1
XFILLER_0_75_3 VPWR VGND VPWR VGND sky130_ef_sc_hd__decap_12
XFILLER_0_112_685 VGND VGND VPWR VPWR sky130_fd_sc_hd__fill_1
X_4417_ net947 _1604_ _1661_ VGND VGND VPWR VPWR _1663_ sky130_fd_sc_hd__mux2_1
X_7205_ u_input_buffer.fifo_mem\[51\]\[10\] _2989_ _2992_ u_input_buffer.fifo_mem\[11\]\[10\]
+ _3446_ VGND VGND VPWR VPWR _3447_ sky130_fd_sc_hd__a221o_1
X_8185_ clknet_leaf_74_clk _0274_ VGND VGND VPWR VPWR u_input_buffer.fifo_mem\[52\]\[15\]
+ sky130_fd_sc_hd__dfxtp_1
X_5397_ _1397_ net1055 _2205_ VGND VGND VPWR VPWR _2209_ sky130_fd_sc_hd__mux2_1
X_4348_ net551 _1618_ _1602_ VGND VGND VPWR VPWR _1619_ sky130_fd_sc_hd__mux2_1
X_7136_ u_input_buffer.fifo_mem\[52\]\[8\] _3039_ _3041_ u_input_buffer.fifo_mem\[56\]\[8\]
+ VGND VGND VPWR VPWR _3380_ sky130_fd_sc_hd__a22o_1
X_4279_ u_analytics_engine.data_in\[7\] VGND VGND VPWR VPWR _1559_ sky130_fd_sc_hd__inv_2
X_7067_ u_input_buffer.fifo_mem\[54\]\[6\] _3078_ _3080_ u_input_buffer.fifo_mem\[46\]\[6\]
+ VGND VGND VPWR VPWR _3313_ sky130_fd_sc_hd__a22o_1
X_6018_ _2555_ VGND VGND VPWR VPWR _0840_ sky130_fd_sc_hd__clkbuf_1
XFILLER_0_69_617 VGND VGND VPWR VPWR sky130_fd_sc_hd__fill_1
XTAP_1304 VGND VPWR sky130_fd_sc_hd__tapvpwrvgnd_1
XTAP_1348 VGND VPWR sky130_fd_sc_hd__tapvpwrvgnd_1
XTAP_1337 VGND VPWR sky130_fd_sc_hd__tapvpwrvgnd_1
XTAP_1326 VGND VPWR sky130_fd_sc_hd__tapvpwrvgnd_1
XTAP_1315 VGND VPWR sky130_fd_sc_hd__tapvpwrvgnd_1
X_7969_ clknet_leaf_15_clk _0059_ net193 VGND VGND VPWR VPWR u_input_buffer.data_in\[9\]
+ sky130_fd_sc_hd__dfrtp_1
XTAP_1359 VGND VPWR sky130_fd_sc_hd__tapvpwrvgnd_1
XFILLER_0_37_503 VGND VGND VPWR VPWR sky130_fd_sc_hd__fill_1
XFILLER_0_92_642 VGND VGND VPWR VPWR sky130_fd_sc_hd__fill_2
XFILLER_0_64_333 VGND VGND VPWR VPWR sky130_fd_sc_hd__decap_8
XFILLER_0_9_460 VGND VGND VPWR VPWR sky130_fd_sc_hd__decap_3
XFILLER_0_37_569 VGND VGND VPWR VPWR sky130_fd_sc_hd__decap_6
XFILLER_0_107_468 VGND VGND VPWR VPWR sky130_fd_sc_hd__decap_6
XFILLER_0_20_403 VGND VGND VPWR VPWR sky130_fd_sc_hd__fill_1
XFILLER_0_103_685 VGND VGND VPWR VPWR sky130_fd_sc_hd__fill_1
XFILLER_0_20_458 VGND VGND VPWR VPWR sky130_fd_sc_hd__fill_2
XFILLER_0_102_195 VGND VGND VPWR VPWR sky130_fd_sc_hd__fill_1
XFILLER_0_90_29 VPWR VGND VPWR VGND sky130_ef_sc_hd__decap_12
XFILLER_0_87_447 VGND VGND VPWR VPWR sky130_fd_sc_hd__fill_1
XFILLER_0_23_34 VGND VGND VPWR VPWR sky130_fd_sc_hd__fill_2
XFILLER_0_28_514 VGND VGND VPWR VPWR sky130_fd_sc_hd__fill_2
XFILLER_0_83_631 VGND VGND VPWR VPWR sky130_fd_sc_hd__fill_1
XFILLER_0_55_311 VGND VGND VPWR VPWR sky130_fd_sc_hd__fill_1
XFILLER_0_99_27 VPWR VGND VPWR VGND sky130_ef_sc_hd__decap_12
XFILLER_0_82_141 VGND VGND VPWR VPWR sky130_fd_sc_hd__fill_1
XFILLER_0_113_449 VGND VGND VPWR VPWR sky130_fd_sc_hd__fill_2
XFILLER_0_23_263 VGND VGND VPWR VPWR sky130_fd_sc_hd__fill_1
X_5320_ _2167_ VGND VGND VPWR VPWR _0530_ sky130_fd_sc_hd__clkbuf_1
XFILLER_0_51_561 VGND VGND VPWR VPWR sky130_fd_sc_hd__fill_2
X_5251_ net1171 _2020_ _2114_ VGND VGND VPWR VPWR _2131_ sky130_fd_sc_hd__mux2_1
X_4202_ net231 _1497_ VGND VGND VPWR VPWR _0080_ sky130_fd_sc_hd__xnor2_1
X_5182_ net356 _2020_ _2077_ VGND VGND VPWR VPWR _2094_ sky130_fd_sc_hd__mux2_1
X_4133_ _1449_ VGND VGND VPWR VPWR _0061_ sky130_fd_sc_hd__clkbuf_1
X_4064_ u_input_buffer.data_in\[2\] VGND VGND VPWR VPWR _1390_ sky130_fd_sc_hd__clkbuf_4
X_8941_ clknet_leaf_39_clk _1030_ VGND VGND VPWR VPWR u_input_buffer.fifo_mem\[4\]\[3\]
+ sky130_fd_sc_hd__dfxtp_1
XFILLER_0_3_55 VGND VGND VPWR VPWR sky130_fd_sc_hd__fill_1
XFILLER_0_78_414 VGND VGND VPWR VPWR sky130_fd_sc_hd__decap_6
X_8872_ clknet_leaf_100_clk _0961_ VGND VGND VPWR VPWR u_input_buffer.fifo_mem\[9\]\[14\]
+ sky130_fd_sc_hd__dfxtp_1
X_7823_ _3910_ VGND VGND VPWR VPWR _1290_ sky130_fd_sc_hd__clkbuf_1
X_7754_ _3868_ VGND VGND VPWR VPWR _1263_ sky130_fd_sc_hd__clkbuf_1
XFILLER_0_74_620 VGND VGND VPWR VPWR sky130_fd_sc_hd__fill_1
X_4966_ _1972_ VGND VGND VPWR VPWR _0371_ sky130_fd_sc_hd__clkbuf_1
XFILLER_0_58_193 VGND VGND VPWR VPWR sky130_fd_sc_hd__decap_3
X_6705_ _2924_ _2956_ VGND VGND VPWR VPWR _2957_ sky130_fd_sc_hd__and2_4
X_4897_ _1935_ VGND VGND VPWR VPWR _0339_ sky130_fd_sc_hd__clkbuf_1
X_7685_ u_register_bank.status_flags\[10\] _3814_ _3808_ u_register_bank.sensor_enable\[10\]
+ VGND VGND VPWR VPWR _3815_ sky130_fd_sc_hd__a22o_1
X_6636_ _1597_ _2889_ _1932_ VGND VGND VPWR VPWR _1123_ sky130_fd_sc_hd__o21a_1
X_6567_ net279 _1408_ _2843_ VGND VGND VPWR VPWR _2849_ sky130_fd_sc_hd__mux2_1
X_5518_ _2281_ VGND VGND VPWR VPWR _0614_ sky130_fd_sc_hd__clkbuf_1
X_8306_ clknet_leaf_13_clk _0395_ VGND VGND VPWR VPWR u_input_buffer.fifo_mem\[44\]\[8\]
+ sky130_fd_sc_hd__dfxtp_1
X_6498_ _2812_ VGND VGND VPWR VPWR _1063_ sky130_fd_sc_hd__clkbuf_1
XFILLER_0_100_633 VGND VGND VPWR VPWR sky130_fd_sc_hd__decap_8
X_8237_ clknet_leaf_16_clk _0326_ VGND VGND VPWR VPWR u_input_buffer.fifo_mem\[48\]\[3\]
+ sky130_fd_sc_hd__dfxtp_1
X_5449_ net1133 _2014_ _2222_ VGND VGND VPWR VPWR _2236_ sky130_fd_sc_hd__mux2_1
X_8168_ clknet_leaf_102_clk _0257_ VGND VGND VPWR VPWR u_input_buffer.fifo_mem\[53\]\[14\]
+ sky130_fd_sc_hd__dfxtp_1
X_7119_ u_input_buffer.fifo_mem\[1\]\[8\] _2932_ _3360_ _3362_ VGND VGND VPWR VPWR
+ _3363_ sky130_fd_sc_hd__a211o_1
Xfanout198 net199 VGND VGND VPWR VPWR net198 sky130_fd_sc_hd__clkbuf_4
Xfanout176 net178 VGND VGND VPWR VPWR net176 sky130_fd_sc_hd__buf_2
Xfanout187 net188 VGND VGND VPWR VPWR net187 sky130_fd_sc_hd__clkbuf_4
X_8099_ clknet_leaf_4_clk _0188_ VGND VGND VPWR VPWR u_input_buffer.fifo_mem\[57\]\[9\]
+ sky130_fd_sc_hd__dfxtp_1
XTAP_1112 VGND VPWR sky130_fd_sc_hd__tapvpwrvgnd_1
XTAP_1123 VGND VPWR sky130_fd_sc_hd__tapvpwrvgnd_1
XTAP_1101 VGND VPWR sky130_fd_sc_hd__tapvpwrvgnd_1
XFILLER_0_69_447 VGND VGND VPWR VPWR sky130_fd_sc_hd__fill_1
XFILLER_0_57_609 VGND VGND VPWR VPWR sky130_fd_sc_hd__fill_1
XTAP_1156 VGND VPWR sky130_fd_sc_hd__tapvpwrvgnd_1
XTAP_1145 VGND VPWR sky130_fd_sc_hd__tapvpwrvgnd_1
XTAP_1134 VGND VPWR sky130_fd_sc_hd__tapvpwrvgnd_1
XTAP_1189 VGND VPWR sky130_fd_sc_hd__tapvpwrvgnd_1
XTAP_1178 VGND VPWR sky130_fd_sc_hd__tapvpwrvgnd_1
XFILLER_0_77_480 VGND VGND VPWR VPWR sky130_fd_sc_hd__fill_2
XTAP_1167 VGND VPWR sky130_fd_sc_hd__tapvpwrvgnd_1
XFILLER_0_107_232 VGND VGND VPWR VPWR sky130_fd_sc_hd__decap_6
XFILLER_0_64_163 VGND VGND VPWR VPWR sky130_fd_sc_hd__fill_1
XFILLER_0_52_347 VGND VGND VPWR VPWR sky130_fd_sc_hd__fill_1
XFILLER_0_110_419 VGND VGND VPWR VPWR sky130_fd_sc_hd__fill_1
XFILLER_0_0_617 VGND VGND VPWR VPWR sky130_fd_sc_hd__decap_8
XTAP_907 VGND VPWR sky130_fd_sc_hd__tapvpwrvgnd_1
XFILLER_0_85_18 VPWR VGND VPWR VGND sky130_ef_sc_hd__decap_12
XTAP_929 VGND VPWR sky130_fd_sc_hd__tapvpwrvgnd_1
XTAP_918 VGND VPWR sky130_fd_sc_hd__tapvpwrvgnd_1
XFILLER_0_109_69 VPWR VGND VPWR VGND sky130_ef_sc_hd__decap_12
XFILLER_0_18_45 VGND VGND VPWR VPWR sky130_fd_sc_hd__fill_1
XFILLER_0_87_277 VGND VGND VPWR VPWR sky130_fd_sc_hd__decap_3
XFILLER_0_75_428 VGND VGND VPWR VPWR sky130_fd_sc_hd__fill_1
X_4820_ _1597_ _1598_ _1638_ VGND VGND VPWR VPWR _1891_ sky130_fd_sc_hd__nor3_2
XFILLER_0_56_642 VGND VGND VPWR VPWR sky130_fd_sc_hd__fill_2
X_4751_ _1592_ _1853_ VGND VGND VPWR VPWR _1854_ sky130_fd_sc_hd__nor2_4
XFILLER_0_55_141 VGND VGND VPWR VPWR sky130_fd_sc_hd__fill_1
X_7470_ _3684_ VGND VGND VPWR VPWR _1163_ sky130_fd_sc_hd__clkbuf_1
XFILLER_0_16_528 VGND VGND VPWR VPWR sky130_fd_sc_hd__fill_1
XFILLER_0_28_399 VGND VGND VPWR VPWR sky130_fd_sc_hd__fill_2
X_4682_ _1816_ VGND VGND VPWR VPWR _1817_ sky130_fd_sc_hd__buf_4
XFILLER_0_50_54 VGND VGND VPWR VPWR sky130_fd_sc_hd__decap_4
X_6421_ net790 _1376_ _2771_ VGND VGND VPWR VPWR _2772_ sky130_fd_sc_hd__mux2_1
XFILLER_0_70_133 VGND VGND VPWR VPWR sky130_fd_sc_hd__decap_6
X_9140_ net174 _1228_ net206 VGND VGND VPWR VPWR u_register_bank.threshold_cfg\[22\]
+ sky130_fd_sc_hd__dfrtp_1
XFILLER_0_3_433 VPWR VGND VPWR VGND sky130_ef_sc_hd__decap_12
XFILLER_0_113_279 VGND VGND VPWR VPWR sky130_fd_sc_hd__fill_1
XFILLER_0_101_408 VGND VGND VPWR VPWR sky130_fd_sc_hd__fill_1
XFILLER_0_11_200 VGND VGND VPWR VPWR sky130_fd_sc_hd__fill_2
X_6352_ _2734_ VGND VGND VPWR VPWR _2735_ sky130_fd_sc_hd__buf_4
X_5303_ net735 _2004_ _2151_ VGND VGND VPWR VPWR _2159_ sky130_fd_sc_hd__mux2_1
X_9071_ clknet_leaf_48_clk _1159_ VGND VGND VPWR VPWR u_input_buffer.fifo_mem\[63\]\[1\]
+ sky130_fd_sc_hd__dfxtp_1
X_6283_ _2697_ VGND VGND VPWR VPWR _2698_ sky130_fd_sc_hd__buf_4
X_5234_ _2122_ VGND VGND VPWR VPWR _0489_ sky130_fd_sc_hd__clkbuf_1
X_8022_ clknet_leaf_87_clk _0111_ VGND VGND VPWR VPWR u_input_buffer.fifo_mem\[62\]\[12\]
+ sky130_fd_sc_hd__dfxtp_1
X_5165_ _2085_ VGND VGND VPWR VPWR _0457_ sky130_fd_sc_hd__clkbuf_1
X_4116_ _1434_ u_sensor_interface.sensor_array\[2\]\[9\] _1379_ VGND VGND VPWR VPWR
+ _1435_ sky130_fd_sc_hd__mux2_1
X_5096_ net505 _2002_ _2042_ VGND VGND VPWR VPWR _2049_ sky130_fd_sc_hd__mux2_1
X_4047_ _1375_ VGND VGND VPWR VPWR _0049_ sky130_fd_sc_hd__clkbuf_1
X_8924_ clknet_leaf_111_clk _1013_ VGND VGND VPWR VPWR u_input_buffer.fifo_mem\[5\]\[2\]
+ sky130_fd_sc_hd__dfxtp_1
X_8855_ clknet_leaf_71_clk _0944_ VGND VGND VPWR VPWR u_input_buffer.fifo_mem\[10\]\[13\]
+ sky130_fd_sc_hd__dfxtp_1
X_7806_ net152 u_analytics_engine.data_in\[13\] _3893_ VGND VGND VPWR VPWR _3901_
+ sky130_fd_sc_hd__mux2_1
XPHY_206 VGND VGND VPWR VPWR sky130_fd_sc_hd__decap_3
XPHY_228 VGND VGND VPWR VPWR sky130_fd_sc_hd__decap_3
XPHY_217 VGND VGND VPWR VPWR sky130_fd_sc_hd__decap_3
X_8786_ clknet_leaf_30_clk _0875_ VGND VGND VPWR VPWR u_input_buffer.fifo_mem\[14\]\[8\]
+ sky130_fd_sc_hd__dfxtp_1
XFILLER_0_59_491 VPWR VGND VPWR VGND sky130_ef_sc_hd__decap_12
X_5998_ _2544_ VGND VGND VPWR VPWR _0831_ sky130_fd_sc_hd__clkbuf_1
X_7737_ _3855_ net127 _3852_ VGND VGND VPWR VPWR _3856_ sky130_fd_sc_hd__mux2_1
X_4949_ _1962_ VGND VGND VPWR VPWR _0364_ sky130_fd_sc_hd__clkbuf_1
X_7668_ _3801_ VGND VGND VPWR VPWR _1244_ sky130_fd_sc_hd__clkbuf_1
X_6619_ _2879_ VGND VGND VPWR VPWR _2880_ sky130_fd_sc_hd__clkbuf_4
X_7599_ net19 u_register_bank.threshold_cfg\[16\] _3748_ VGND VGND VPWR VPWR _3755_
+ sky130_fd_sc_hd__mux2_1
XFILLER_0_15_594 VPWR VGND VPWR VGND sky130_ef_sc_hd__decap_12
XFILLER_0_30_597 VPWR VGND VPWR VGND sky130_ef_sc_hd__decap_12
XFILLER_0_89_509 VGND VGND VPWR VPWR sky130_fd_sc_hd__fill_1
XFILLER_0_69_200 VGND VGND VPWR VPWR sky130_fd_sc_hd__fill_1
XFILLER_0_69_244 VGND VGND VPWR VPWR sky130_fd_sc_hd__fill_1
XFILLER_0_72_409 VGND VGND VPWR VPWR sky130_fd_sc_hd__decap_8
XFILLER_0_53_601 VGND VGND VPWR VPWR sky130_fd_sc_hd__fill_1
XFILLER_0_108_541 VGND VGND VPWR VPWR sky130_fd_sc_hd__fill_1
XFILLER_0_111_15 VPWR VGND VPWR VGND sky130_ef_sc_hd__decap_12
XFILLER_0_108_585 VGND VGND VPWR VPWR sky130_fd_sc_hd__decap_3
XFILLER_0_80_475 VGND VGND VPWR VPWR sky130_fd_sc_hd__fill_1
XFILLER_0_20_46 VGND VGND VPWR VPWR sky130_fd_sc_hd__decap_8
XFILLER_0_52_155 VGND VGND VPWR VPWR sky130_fd_sc_hd__fill_1
XFILLER_0_0_425 VGND VGND VPWR VPWR sky130_fd_sc_hd__decap_8
XFILLER_0_0_447 VGND VGND VPWR VPWR sky130_fd_sc_hd__fill_1
XFILLER_0_0_469 VGND VGND VPWR VPWR sky130_fd_sc_hd__decap_6
XFILLER_0_29_22 VGND VGND VPWR VPWR sky130_fd_sc_hd__fill_2
XTAP_704 VGND VPWR sky130_fd_sc_hd__tapvpwrvgnd_1
XTAP_715 VGND VPWR sky130_fd_sc_hd__tapvpwrvgnd_1
XFILLER_0_29_66 VGND VGND VPWR VPWR sky130_fd_sc_hd__decap_3
XTAP_726 VGND VPWR sky130_fd_sc_hd__tapvpwrvgnd_1
XTAP_737 VGND VPWR sky130_fd_sc_hd__tapvpwrvgnd_1
XTAP_748 VGND VPWR sky130_fd_sc_hd__tapvpwrvgnd_1
XTAP_759 VGND VPWR sky130_fd_sc_hd__tapvpwrvgnd_1
X_6970_ u_input_buffer.fifo_mem\[50\]\[4\] _2995_ _2997_ u_input_buffer.fifo_mem\[4\]\[4\]
+ VGND VGND VPWR VPWR _3218_ sky130_fd_sc_hd__a22o_1
XFILLER_0_24_9 VGND VGND VPWR VPWR sky130_fd_sc_hd__fill_1
X_5921_ _1376_ VGND VGND VPWR VPWR _2496_ sky130_fd_sc_hd__buf_4
XFILLER_0_88_542 VPWR VGND VPWR VGND sky130_ef_sc_hd__decap_12
X_8640_ clknet_leaf_53_clk _0729_ VGND VGND VPWR VPWR u_input_buffer.fifo_mem\[23\]\[6\]
+ sky130_fd_sc_hd__dfxtp_1
X_5852_ _2459_ VGND VGND VPWR VPWR _0770_ sky130_fd_sc_hd__clkbuf_1
X_4803_ _1882_ VGND VGND VPWR VPWR _0298_ sky130_fd_sc_hd__clkbuf_1
X_8571_ clknet_leaf_45_clk _0660_ VGND VGND VPWR VPWR u_input_buffer.fifo_mem\[27\]\[1\]
+ sky130_fd_sc_hd__dfxtp_1
X_5783_ net938 _2274_ _2406_ VGND VGND VPWR VPWR _2423_ sky130_fd_sc_hd__mux2_1
XFILLER_0_29_653 VGND VGND VPWR VPWR sky130_fd_sc_hd__fill_1
XFILLER_0_8_558 VPWR VGND VPWR VGND sky130_ef_sc_hd__decap_12
X_7522_ net15 u_register_bank.window_cfg\[12\] _3711_ VGND VGND VPWR VPWR _3714_ sky130_fd_sc_hd__mux2_1
X_4734_ net278 _1720_ _1836_ VGND VGND VPWR VPWR _1845_ sky130_fd_sc_hd__mux2_1
XFILLER_0_44_645 VGND VGND VPWR VPWR sky130_fd_sc_hd__decap_6
XFILLER_0_114_533 VPWR VGND VPWR VGND sky130_ef_sc_hd__decap_12
X_4665_ _1807_ VGND VGND VPWR VPWR _0235_ sky130_fd_sc_hd__clkbuf_1
X_7453_ net809 net104 _1322_ VGND VGND VPWR VPWR _3675_ sky130_fd_sc_hd__mux2_1
Xhold922 u_input_buffer.fifo_mem\[26\]\[9\] VGND VGND VPWR VPWR net1134 sky130_fd_sc_hd__dlygate4sd3_1
X_4596_ _1768_ VGND VGND VPWR VPWR _0205_ sky130_fd_sc_hd__clkbuf_1
X_6404_ _2762_ VGND VGND VPWR VPWR _1019_ sky130_fd_sc_hd__clkbuf_1
Xhold900 u_input_buffer.fifo_mem\[13\]\[9\] VGND VGND VPWR VPWR net1112 sky130_fd_sc_hd__dlygate4sd3_1
XFILLER_0_31_328 VGND VGND VPWR VPWR sky130_fd_sc_hd__decap_8
X_7384_ net708 _2892_ _3620_ _3621_ VGND VGND VPWR VPWR _1140_ sky130_fd_sc_hd__a22o_1
Xhold911 u_input_buffer.fifo_mem\[33\]\[2\] VGND VGND VPWR VPWR net1123 sky130_fd_sc_hd__dlygate4sd3_1
XFILLER_0_101_81 VPWR VGND VPWR VGND sky130_ef_sc_hd__decap_12
X_9123_ net180 _1211_ net210 VGND VGND VPWR VPWR u_analytics_engine.threshold\[5\]
+ sky130_fd_sc_hd__dfrtp_1
X_6335_ net634 _2514_ _2717_ VGND VGND VPWR VPWR _2726_ sky130_fd_sc_hd__mux2_1
Xhold944 u_input_buffer.fifo_mem\[21\]\[2\] VGND VGND VPWR VPWR net1156 sky130_fd_sc_hd__dlygate4sd3_1
Xhold955 u_input_buffer.fifo_mem\[17\]\[15\] VGND VGND VPWR VPWR net1167 sky130_fd_sc_hd__dlygate4sd3_1
Xhold933 u_input_buffer.fifo_mem\[25\]\[1\] VGND VGND VPWR VPWR net1145 sky130_fd_sc_hd__dlygate4sd3_1
X_9054_ clknet_leaf_27_clk _1143_ VGND VGND VPWR VPWR u_sensor_interface.sensor_array\[3\]\[1\]
+ sky130_fd_sc_hd__dfxtp_1
Xhold988 u_input_buffer.fifo_mem\[29\]\[13\] VGND VGND VPWR VPWR net1200 sky130_fd_sc_hd__dlygate4sd3_1
Xhold977 u_input_buffer.fifo_mem\[10\]\[15\] VGND VGND VPWR VPWR net1189 sky130_fd_sc_hd__dlygate4sd3_1
Xhold966 u_input_buffer.fifo_mem\[33\]\[1\] VGND VGND VPWR VPWR net1178 sky130_fd_sc_hd__dlygate4sd3_1
X_8005_ clknet_leaf_62_clk _0094_ net196 VGND VGND VPWR VPWR u_sample_counter.sample_count\[28\]
+ sky130_fd_sc_hd__dfrtp_1
X_6266_ _1618_ net1243 _2680_ VGND VGND VPWR VPWR _2689_ sky130_fd_sc_hd__mux2_1
Xhold999 u_input_buffer.fifo_mem\[25\]\[7\] VGND VGND VPWR VPWR net1211 sky130_fd_sc_hd__dlygate4sd3_1
X_6197_ _2652_ VGND VGND VPWR VPWR _0922_ sky130_fd_sc_hd__clkbuf_1
X_5217_ net493 _2020_ _2096_ VGND VGND VPWR VPWR _2113_ sky130_fd_sc_hd__mux2_1
X_5148_ _1469_ net854 _2059_ VGND VGND VPWR VPWR _2076_ sky130_fd_sc_hd__mux2_1
X_5079_ _2039_ VGND VGND VPWR VPWR _0417_ sky130_fd_sc_hd__clkbuf_1
X_8907_ clknet_leaf_55_clk _0996_ VGND VGND VPWR VPWR u_input_buffer.fifo_mem\[6\]\[1\]
+ sky130_fd_sc_hd__dfxtp_1
XFILLER_0_94_523 VGND VGND VPWR VPWR sky130_fd_sc_hd__fill_1
X_8838_ clknet_leaf_9_clk _0927_ VGND VGND VPWR VPWR u_input_buffer.fifo_mem\[11\]\[12\]
+ sky130_fd_sc_hd__dfxtp_1
X_8769_ clknet_leaf_33_clk _0858_ VGND VGND VPWR VPWR u_input_buffer.fifo_mem\[15\]\[7\]
+ sky130_fd_sc_hd__dfxtp_1
XFILLER_0_66_247 VGND VGND VPWR VPWR sky130_fd_sc_hd__decap_4
XFILLER_0_94_589 VPWR VGND VPWR VGND sky130_ef_sc_hd__decap_12
XFILLER_0_62_464 VGND VGND VPWR VPWR sky130_fd_sc_hd__fill_1
XFILLER_0_15_57 VPWR VGND VPWR VGND sky130_ef_sc_hd__decap_12
XFILLER_0_85_545 VGND VGND VPWR VPWR sky130_fd_sc_hd__fill_1
XFILLER_0_57_225 VGND VGND VPWR VPWR sky130_fd_sc_hd__fill_1
XFILLER_0_57_214 VGND VGND VPWR VPWR sky130_fd_sc_hd__fill_1
XFILLER_0_5_517 VPWR VGND VPWR VGND sky130_ef_sc_hd__decap_12
XFILLER_0_41_604 VGND VGND VPWR VPWR sky130_fd_sc_hd__fill_1
Xhold207 u_input_buffer.fifo_mem\[19\]\[2\] VGND VGND VPWR VPWR net419 sky130_fd_sc_hd__dlygate4sd3_1
X_4450_ _1634_ _1680_ VGND VGND VPWR VPWR _1681_ sky130_fd_sc_hd__and2_1
XFILLER_0_41_648 VGND VGND VPWR VPWR sky130_fd_sc_hd__fill_2
Xhold218 u_input_buffer.fifo_mem\[2\]\[4\] VGND VGND VPWR VPWR net430 sky130_fd_sc_hd__dlygate4sd3_1
Xhold229 u_input_buffer.fifo_mem\[31\]\[6\] VGND VGND VPWR VPWR net441 sky130_fd_sc_hd__dlygate4sd3_1
X_4381_ _1385_ net1276 _1641_ VGND VGND VPWR VPWR _1643_ sky130_fd_sc_hd__mux2_1
X_6120_ _2611_ VGND VGND VPWR VPWR _0886_ sky130_fd_sc_hd__clkbuf_1
XTAP_501 VGND VPWR sky130_fd_sc_hd__tapvpwrvgnd_1
XTAP_512 VGND VPWR sky130_fd_sc_hd__tapvpwrvgnd_1
XTAP_523 VGND VPWR sky130_fd_sc_hd__tapvpwrvgnd_1
XTAP_534 VGND VPWR sky130_fd_sc_hd__tapvpwrvgnd_1
X_6051_ net694 _2506_ _2569_ VGND VGND VPWR VPWR _2574_ sky130_fd_sc_hd__mux2_1
XTAP_545 VGND VPWR sky130_fd_sc_hd__tapvpwrvgnd_1
XTAP_556 VGND VPWR sky130_fd_sc_hd__tapvpwrvgnd_1
XTAP_567 VGND VPWR sky130_fd_sc_hd__tapvpwrvgnd_1
X_5002_ _1384_ VGND VGND VPWR VPWR _1992_ sky130_fd_sc_hd__buf_4
XTAP_578 VGND VPWR sky130_fd_sc_hd__tapvpwrvgnd_1
XTAP_589 VGND VPWR sky130_fd_sc_hd__tapvpwrvgnd_1
X_6953_ _3183_ _3192_ _3201_ VGND VGND VPWR VPWR _3202_ sky130_fd_sc_hd__or3_1
Xclkbuf_3_5__f_clk clknet_0_clk VGND VGND VPWR VPWR clknet_3_5__leaf_clk sky130_fd_sc_hd__clkbuf_16
X_5904_ _2487_ VGND VGND VPWR VPWR _0794_ sky130_fd_sc_hd__clkbuf_1
X_6884_ u_input_buffer.fifo_mem\[29\]\[2\] _2939_ _2941_ u_input_buffer.fifo_mem\[13\]\[2\]
+ _3133_ VGND VGND VPWR VPWR _3134_ sky130_fd_sc_hd__a221o_1
X_8623_ clknet_leaf_61_clk _0712_ VGND VGND VPWR VPWR u_input_buffer.fifo_mem\[24\]\[5\]
+ sky130_fd_sc_hd__dfxtp_1
X_5835_ _1616_ net1288 _2443_ VGND VGND VPWR VPWR _2451_ sky130_fd_sc_hd__mux2_1
X_8554_ clknet_leaf_52_clk _0643_ VGND VGND VPWR VPWR u_input_buffer.fifo_mem\[28\]\[0\]
+ sky130_fd_sc_hd__dfxtp_1
X_5766_ _2414_ VGND VGND VPWR VPWR _0729_ sky130_fd_sc_hd__clkbuf_1
XFILLER_0_91_559 VGND VGND VPWR VPWR sky130_fd_sc_hd__fill_1
X_7505_ net38 u_register_bank.window_cfg\[4\] _3700_ VGND VGND VPWR VPWR _3705_ sky130_fd_sc_hd__mux2_1
X_8485_ clknet_leaf_107_clk _0574_ VGND VGND VPWR VPWR u_input_buffer.fifo_mem\[33\]\[11\]
+ sky130_fd_sc_hd__dfxtp_1
X_5697_ _2377_ VGND VGND VPWR VPWR _0697_ sky130_fd_sc_hd__clkbuf_1
X_4717_ _1835_ VGND VGND VPWR VPWR _1836_ sky130_fd_sc_hd__buf_4
X_4648_ net427 _1700_ _1798_ VGND VGND VPWR VPWR _1799_ sky130_fd_sc_hd__mux2_1
X_7436_ _3666_ VGND VGND VPWR VPWR _1147_ sky130_fd_sc_hd__clkbuf_1
XFILLER_0_32_648 VPWR VGND VPWR VGND sky130_ef_sc_hd__decap_12
Xhold730 u_input_buffer.fifo_mem\[17\]\[11\] VGND VGND VPWR VPWR net942 sky130_fd_sc_hd__dlygate4sd3_1
XFILLER_0_31_169 VGND VGND VPWR VPWR sky130_fd_sc_hd__fill_2
X_4579_ net857 _1708_ _1757_ VGND VGND VPWR VPWR _1760_ sky130_fd_sc_hd__mux2_1
X_9106_ net176 _1194_ net208 VGND VGND VPWR VPWR u_register_bank.window_cfg\[20\]
+ sky130_fd_sc_hd__dfrtp_1
Xhold763 u_input_buffer.fifo_mem\[41\]\[8\] VGND VGND VPWR VPWR net975 sky130_fd_sc_hd__dlygate4sd3_1
Xhold741 u_input_buffer.fifo_mem\[2\]\[10\] VGND VGND VPWR VPWR net953 sky130_fd_sc_hd__dlygate4sd3_1
Xhold752 u_input_buffer.fifo_mem\[26\]\[14\] VGND VGND VPWR VPWR net964 sky130_fd_sc_hd__dlygate4sd3_1
X_7367_ u_input_buffer.fifo_mem\[27\]\[14\] _3012_ _3014_ u_input_buffer.fifo_mem\[59\]\[14\]
+ _3604_ VGND VGND VPWR VPWR _3605_ sky130_fd_sc_hd__a221o_1
Xhold774 u_input_buffer.fifo_mem\[48\]\[9\] VGND VGND VPWR VPWR net986 sky130_fd_sc_hd__dlygate4sd3_1
X_6318_ _2716_ VGND VGND VPWR VPWR _2717_ sky130_fd_sc_hd__buf_4
Xhold796 u_input_buffer.fifo_mem\[53\]\[12\] VGND VGND VPWR VPWR net1008 sky130_fd_sc_hd__dlygate4sd3_1
Xhold785 u_input_buffer.count\[3\] VGND VGND VPWR VPWR net997 sky130_fd_sc_hd__dlygate4sd3_1
X_7298_ u_input_buffer.fifo_mem\[10\]\[12\] _3055_ _3057_ u_input_buffer.fifo_mem\[44\]\[12\]
+ _3537_ VGND VGND VPWR VPWR _3538_ sky130_fd_sc_hd__a221o_1
X_9037_ clknet_leaf_48_clk _1126_ VGND VGND VPWR VPWR u_analytics_engine.data_in\[0\]
+ sky130_fd_sc_hd__dfxtp_2
X_6249_ _2679_ VGND VGND VPWR VPWR _2680_ sky130_fd_sc_hd__buf_4
XFILLER_0_99_648 VGND VGND VPWR VPWR sky130_fd_sc_hd__decap_4
XFILLER_0_86_309 VGND VGND VPWR VPWR sky130_fd_sc_hd__fill_1
XFILLER_0_79_372 VGND VGND VPWR VPWR sky130_fd_sc_hd__fill_1
XFILLER_0_94_353 VGND VGND VPWR VPWR sky130_fd_sc_hd__decap_8
XFILLER_0_67_589 VGND VGND VPWR VPWR sky130_fd_sc_hd__decap_8
XFILLER_0_35_442 VGND VGND VPWR VPWR sky130_fd_sc_hd__fill_2
XFILLER_0_62_261 VGND VGND VPWR VPWR sky130_fd_sc_hd__fill_2
XFILLER_0_23_615 VGND VGND VPWR VPWR sky130_fd_sc_hd__fill_1
XFILLER_0_22_136 VGND VGND VPWR VPWR sky130_fd_sc_hd__fill_1
Xhold90 u_input_buffer.fifo_mem\[42\]\[10\] VGND VGND VPWR VPWR net302 sky130_fd_sc_hd__dlygate4sd3_1
XFILLER_0_97_180 VGND VGND VPWR VPWR sky130_fd_sc_hd__fill_1
X_3950_ net1058 net72 _1323_ VGND VGND VPWR VPWR _1325_ sky130_fd_sc_hd__mux2_1
XFILLER_0_85_353 VGND VGND VPWR VPWR sky130_fd_sc_hd__decap_6
XFILLER_0_58_589 VGND VGND VPWR VPWR sky130_fd_sc_hd__decap_3
X_5620_ net783 _2248_ _2334_ VGND VGND VPWR VPWR _2337_ sky130_fd_sc_hd__mux2_1
XFILLER_0_26_431 VGND VGND VPWR VPWR sky130_fd_sc_hd__fill_1
X_5551_ _1391_ net918 _2297_ VGND VGND VPWR VPWR _2300_ sky130_fd_sc_hd__mux2_1
XFILLER_0_115_149 VGND VGND VPWR VPWR sky130_fd_sc_hd__fill_1
X_4502_ net1028 _1712_ _1704_ VGND VGND VPWR VPWR _1713_ sky130_fd_sc_hd__mux2_1
X_8270_ clknet_leaf_36_clk _0359_ VGND VGND VPWR VPWR u_input_buffer.fifo_mem\[46\]\[4\]
+ sky130_fd_sc_hd__dfxtp_1
XFILLER_0_13_103 VGND VGND VPWR VPWR sky130_fd_sc_hd__fill_2
XFILLER_0_111_300 VGND VGND VPWR VPWR sky130_fd_sc_hd__fill_1
X_5482_ _1420_ VGND VGND VPWR VPWR _2258_ sky130_fd_sc_hd__clkbuf_4
X_7221_ u_input_buffer.fifo_mem\[3\]\[10\] _3069_ _3071_ u_input_buffer.fifo_mem\[60\]\[10\]
+ VGND VGND VPWR VPWR _3463_ sky130_fd_sc_hd__a22o_1
X_4433_ net428 _1620_ _1661_ VGND VGND VPWR VPWR _1671_ sky130_fd_sc_hd__mux2_1
X_4364_ _1629_ VGND VGND VPWR VPWR _0112_ sky130_fd_sc_hd__clkbuf_1
X_7152_ u_input_buffer.fifo_mem\[33\]\[9\] _2898_ _2904_ u_input_buffer.fifo_mem\[61\]\[9\]
+ _3394_ VGND VGND VPWR VPWR _3395_ sky130_fd_sc_hd__a221o_1
X_7083_ u_input_buffer.fifo_mem\[16\]\[7\] _2971_ _2973_ u_input_buffer.fifo_mem\[49\]\[7\]
+ _2975_ VGND VGND VPWR VPWR _3328_ sky130_fd_sc_hd__a221o_1
X_4295_ _1572_ _1574_ _1573_ VGND VGND VPWR VPWR _1575_ sky130_fd_sc_hd__or3b_1
XTAP_342 VGND VPWR sky130_fd_sc_hd__tapvpwrvgnd_1
XTAP_320 VGND VPWR sky130_fd_sc_hd__tapvpwrvgnd_1
XTAP_331 VGND VPWR sky130_fd_sc_hd__tapvpwrvgnd_1
XFILLER_0_1_597 VPWR VGND VPWR VGND sky130_ef_sc_hd__decap_12
X_6103_ net466 _2524_ _2586_ VGND VGND VPWR VPWR _2601_ sky130_fd_sc_hd__mux2_1
XTAP_375 VGND VPWR sky130_fd_sc_hd__tapvpwrvgnd_1
XTAP_364 VGND VPWR sky130_fd_sc_hd__tapvpwrvgnd_1
XTAP_353 VGND VPWR sky130_fd_sc_hd__tapvpwrvgnd_1
X_6034_ _2563_ VGND VGND VPWR VPWR _0848_ sky130_fd_sc_hd__clkbuf_1
XTAP_397 VGND VPWR sky130_fd_sc_hd__tapvpwrvgnd_1
XTAP_386 VGND VPWR sky130_fd_sc_hd__tapvpwrvgnd_1
X_7985_ clknet_leaf_58_clk _0074_ net199 VGND VGND VPWR VPWR u_sample_counter.sample_count\[8\]
+ sky130_fd_sc_hd__dfrtp_1
XFILLER_0_83_95 VGND VGND VPWR VPWR sky130_fd_sc_hd__fill_2
XTAP_1508 VGND VPWR sky130_fd_sc_hd__tapvpwrvgnd_1
XTAP_1519 VGND VPWR sky130_fd_sc_hd__tapvpwrvgnd_1
X_6936_ u_input_buffer.fifo_mem\[8\]\[3\] _3004_ _3006_ u_input_buffer.fifo_mem\[19\]\[3\]
+ _3184_ VGND VGND VPWR VPWR _3185_ sky130_fd_sc_hd__a221o_1
XPHY_26 VGND VGND VPWR VPWR sky130_fd_sc_hd__decap_3
XPHY_15 VGND VGND VPWR VPWR sky130_fd_sc_hd__decap_3
XPHY_37 VGND VGND VPWR VPWR sky130_fd_sc_hd__decap_3
XPHY_48 VGND VGND VPWR VPWR sky130_fd_sc_hd__decap_3
XPHY_59 VGND VGND VPWR VPWR sky130_fd_sc_hd__decap_3
X_6867_ u_input_buffer.fifo_mem\[23\]\[1\] _3046_ _3048_ u_input_buffer.fifo_mem\[20\]\[1\]
+ _3117_ VGND VGND VPWR VPWR _3118_ sky130_fd_sc_hd__a221o_1
XFILLER_0_9_653 VPWR VGND VPWR VGND sky130_ef_sc_hd__decap_12
XFILLER_0_107_617 VGND VGND VPWR VPWR sky130_fd_sc_hd__decap_3
X_6798_ _3049_ VGND VGND VPWR VPWR _3050_ sky130_fd_sc_hd__clkbuf_4
X_5818_ _2441_ VGND VGND VPWR VPWR _0754_ sky130_fd_sc_hd__clkbuf_1
X_8606_ clknet_leaf_4_clk _0695_ VGND VGND VPWR VPWR u_input_buffer.fifo_mem\[25\]\[4\]
+ sky130_fd_sc_hd__dfxtp_1
X_8537_ clknet_leaf_85_clk _0626_ VGND VGND VPWR VPWR u_input_buffer.fifo_mem\[30\]\[15\]
+ sky130_fd_sc_hd__dfxtp_1
X_5749_ _2404_ VGND VGND VPWR VPWR _0722_ sky130_fd_sc_hd__clkbuf_1
XFILLER_0_44_250 VGND VGND VPWR VPWR sky130_fd_sc_hd__fill_2
XFILLER_0_106_149 VGND VGND VPWR VPWR sky130_fd_sc_hd__decap_3
X_8468_ clknet_leaf_11_clk _0557_ VGND VGND VPWR VPWR u_input_buffer.fifo_mem\[34\]\[10\]
+ sky130_fd_sc_hd__dfxtp_1
X_8399_ clknet_leaf_46_clk _0488_ VGND VGND VPWR VPWR u_input_buffer.fifo_mem\[38\]\[5\]
+ sky130_fd_sc_hd__dfxtp_1
XFILLER_0_4_391 VGND VGND VPWR VPWR sky130_fd_sc_hd__fill_2
X_7419_ u_input_buffer.fifo_mem\[63\]\[15\] _2886_ _3075_ u_input_buffer.fifo_mem\[55\]\[15\]
+ _3655_ VGND VGND VPWR VPWR _3656_ sky130_fd_sc_hd__a221o_1
Xhold571 u_input_buffer.fifo_mem\[27\]\[2\] VGND VGND VPWR VPWR net783 sky130_fd_sc_hd__dlygate4sd3_1
Xhold560 u_input_buffer.fifo_mem\[4\]\[15\] VGND VGND VPWR VPWR net772 sky130_fd_sc_hd__dlygate4sd3_1
Xhold593 u_input_buffer.fifo_mem\[34\]\[6\] VGND VGND VPWR VPWR net805 sky130_fd_sc_hd__dlygate4sd3_1
Xhold582 u_input_buffer.fifo_mem\[28\]\[8\] VGND VGND VPWR VPWR net794 sky130_fd_sc_hd__dlygate4sd3_1
XFILLER_0_67_331 VGND VGND VPWR VPWR sky130_fd_sc_hd__decap_4
XFILLER_0_103_27 VPWR VGND VPWR VGND sky130_ef_sc_hd__decap_12
XFILLER_0_113_609 VGND VGND VPWR VPWR sky130_fd_sc_hd__decap_6
XFILLER_0_63_592 VGND VGND VPWR VPWR sky130_fd_sc_hd__fill_1
XFILLER_0_88_29 VPWR VGND VPWR VGND sky130_ef_sc_hd__decap_12
XFILLER_0_11_629 VPWR VGND VPWR VGND sky130_ef_sc_hd__decap_12
XFILLER_0_10_117 VGND VGND VPWR VPWR sky130_fd_sc_hd__fill_2
XFILLER_0_50_286 VGND VGND VPWR VPWR sky130_fd_sc_hd__fill_1
X_4080_ u_sensor_interface.sensor_array\[0\]\[4\] u_sensor_interface.sensor_array\[1\]\[4\]
+ _1318_ VGND VGND VPWR VPWR _1404_ sky130_fd_sc_hd__mux2_1
XFILLER_0_37_44 VGND VGND VPWR VPWR sky130_fd_sc_hd__fill_1
X_7770_ _3880_ VGND VGND VPWR VPWR _1267_ sky130_fd_sc_hd__clkbuf_1
X_4982_ _1980_ VGND VGND VPWR VPWR _0379_ sky130_fd_sc_hd__clkbuf_1
XFILLER_0_53_76 VGND VGND VPWR VPWR sky130_fd_sc_hd__fill_1
X_6721_ _2972_ VGND VGND VPWR VPWR _2973_ sky130_fd_sc_hd__clkbuf_4
XFILLER_0_6_601 VPWR VGND VPWR VGND sky130_ef_sc_hd__decap_12
X_6652_ _2903_ VGND VGND VPWR VPWR _2904_ sky130_fd_sc_hd__clkbuf_4
XFILLER_0_6_645 VPWR VGND VPWR VGND sky130_ef_sc_hd__decap_12
X_5603_ net275 _2266_ _2314_ VGND VGND VPWR VPWR _2327_ sky130_fd_sc_hd__mux2_1
X_8322_ clknet_leaf_14_clk _0411_ VGND VGND VPWR VPWR u_input_buffer.fifo_mem\[43\]\[8\]
+ sky130_fd_sc_hd__dfxtp_1
XFILLER_0_26_250 VGND VGND VPWR VPWR sky130_fd_sc_hd__fill_2
X_6583_ net523 _1456_ _2842_ VGND VGND VPWR VPWR _2857_ sky130_fd_sc_hd__mux2_1
X_5534_ _2289_ VGND VGND VPWR VPWR _0622_ sky130_fd_sc_hd__clkbuf_1
XFILLER_0_112_631 VPWR VGND VPWR VGND sky130_ef_sc_hd__decap_12
X_5465_ net1279 _2246_ _2244_ VGND VGND VPWR VPWR _2247_ sky130_fd_sc_hd__mux2_1
X_8253_ clknet_leaf_65_clk _0342_ VGND VGND VPWR VPWR u_input_buffer.fifo_mem\[47\]\[3\]
+ sky130_fd_sc_hd__dfxtp_1
X_4416_ _1662_ VGND VGND VPWR VPWR _0131_ sky130_fd_sc_hd__clkbuf_1
XFILLER_0_68_3 VGND VGND VPWR VPWR sky130_fd_sc_hd__decap_3
X_7204_ u_input_buffer.fifo_mem\[50\]\[10\] _2994_ _2996_ u_input_buffer.fifo_mem\[4\]\[10\]
+ VGND VGND VPWR VPWR _3446_ sky130_fd_sc_hd__a22o_1
X_8184_ clknet_leaf_74_clk _0273_ VGND VGND VPWR VPWR u_input_buffer.fifo_mem\[52\]\[14\]
+ sky130_fd_sc_hd__dfxtp_1
X_7135_ u_input_buffer.fifo_mem\[7\]\[8\] _3025_ _3027_ u_input_buffer.fifo_mem\[22\]\[8\]
+ _3378_ VGND VGND VPWR VPWR _3379_ sky130_fd_sc_hd__a221o_1
X_5396_ _2208_ VGND VGND VPWR VPWR _0565_ sky130_fd_sc_hd__clkbuf_1
X_4347_ u_input_buffer.data_in\[8\] VGND VGND VPWR VPWR _1618_ sky130_fd_sc_hd__clkbuf_4
X_7066_ u_input_buffer.fifo_mem\[26\]\[6\] _3066_ _3068_ u_input_buffer.fifo_mem\[62\]\[6\]
+ _3311_ VGND VGND VPWR VPWR _3312_ sky130_fd_sc_hd__a221o_1
X_4278_ _1539_ _1555_ _1550_ _1557_ VGND VGND VPWR VPWR _1558_ sky130_fd_sc_hd__or4_2
XFILLER_0_94_83 VGND VGND VPWR VPWR sky130_fd_sc_hd__fill_1
X_6017_ net573 _2508_ _2549_ VGND VGND VPWR VPWR _2555_ sky130_fd_sc_hd__mux2_1
XTAP_1305 VGND VPWR sky130_fd_sc_hd__tapvpwrvgnd_1
XTAP_1338 VGND VPWR sky130_fd_sc_hd__tapvpwrvgnd_1
XTAP_1327 VGND VPWR sky130_fd_sc_hd__tapvpwrvgnd_1
XTAP_1316 VGND VPWR sky130_fd_sc_hd__tapvpwrvgnd_1
X_7968_ clknet_leaf_16_clk _0058_ net193 VGND VGND VPWR VPWR u_input_buffer.data_in\[8\]
+ sky130_fd_sc_hd__dfrtp_1
XTAP_1349 VGND VPWR sky130_fd_sc_hd__tapvpwrvgnd_1
X_6919_ u_input_buffer.fifo_mem\[37\]\[3\] _2923_ _2926_ u_input_buffer.fifo_mem\[9\]\[3\]
+ VGND VGND VPWR VPWR _3168_ sky130_fd_sc_hd__a22o_1
X_7899_ clknet_leaf_79_clk net242 net191 VGND VGND VPWR VPWR u_register_bank.status_flags\[19\]
+ sky130_fd_sc_hd__dfrtp_1
XFILLER_0_9_483 VPWR VGND VPWR VGND sky130_ef_sc_hd__decap_12
XFILLER_0_17_294 VGND VGND VPWR VPWR sky130_fd_sc_hd__decap_6
XFILLER_0_103_631 VGND VGND VPWR VPWR sky130_fd_sc_hd__fill_1
XFILLER_0_102_141 VGND VGND VPWR VPWR sky130_fd_sc_hd__decap_6
Xhold390 u_input_buffer.fifo_mem\[26\]\[1\] VGND VGND VPWR VPWR net602 sky130_fd_sc_hd__dlygate4sd3_1
Xhold1090 u_input_buffer.fifo_mem\[59\]\[0\] VGND VGND VPWR VPWR net1302 sky130_fd_sc_hd__dlygate4sd3_1
XFILLER_0_114_26 VGND VGND VPWR VPWR sky130_fd_sc_hd__fill_2
XFILLER_0_83_643 VGND VGND VPWR VPWR sky130_fd_sc_hd__fill_2
XFILLER_0_99_39 VPWR VGND VPWR VGND sky130_ef_sc_hd__decap_12
XFILLER_0_3_615 VGND VGND VPWR VPWR sky130_fd_sc_hd__fill_1
XFILLER_0_23_253 VGND VGND VPWR VPWR sky130_fd_sc_hd__fill_1
X_5250_ _2130_ VGND VGND VPWR VPWR _0497_ sky130_fd_sc_hd__clkbuf_1
X_4201_ _1499_ VGND VGND VPWR VPWR _0079_ sky130_fd_sc_hd__clkbuf_1
XFILLER_0_54_9 VGND VGND VPWR VPWR sky130_fd_sc_hd__fill_2
X_5181_ _2093_ VGND VGND VPWR VPWR _0465_ sky130_fd_sc_hd__clkbuf_1
X_4132_ _1445_ _1448_ _1320_ VGND VGND VPWR VPWR _1449_ sky130_fd_sc_hd__mux2_1
X_8940_ clknet_leaf_37_clk _1029_ VGND VGND VPWR VPWR u_input_buffer.fifo_mem\[4\]\[2\]
+ sky130_fd_sc_hd__dfxtp_1
X_4063_ _1389_ VGND VGND VPWR VPWR _0051_ sky130_fd_sc_hd__clkbuf_1
XFILLER_0_64_53 VGND VGND VPWR VPWR sky130_fd_sc_hd__fill_2
X_8871_ clknet_leaf_108_clk _0960_ VGND VGND VPWR VPWR u_input_buffer.fifo_mem\[9\]\[13\]
+ sky130_fd_sc_hd__dfxtp_1
X_7822_ net38 u_register_bank.sensor_enable\[4\] _3905_ VGND VGND VPWR VPWR _3910_
+ sky130_fd_sc_hd__mux2_1
X_7753_ _3867_ net131 _3852_ VGND VGND VPWR VPWR _3868_ sky130_fd_sc_hd__mux2_1
XFILLER_0_80_41 VGND VGND VPWR VPWR sky130_fd_sc_hd__decap_6
X_4965_ _1377_ net495 _1971_ VGND VGND VPWR VPWR _1972_ sky130_fd_sc_hd__mux2_1
XFILLER_0_19_537 VGND VGND VPWR VPWR sky130_fd_sc_hd__fill_2
X_6704_ u_input_buffer.rd_ptr\[0\] u_input_buffer.rd_ptr\[1\] u_input_buffer.rd_ptr\[3\]
+ u_input_buffer.rd_ptr\[2\] VGND VGND VPWR VPWR _2956_ sky130_fd_sc_hd__and4b_1
X_4896_ net699 _1700_ _1934_ VGND VGND VPWR VPWR _1935_ sky130_fd_sc_hd__mux2_1
XFILLER_0_80_85 VGND VGND VPWR VPWR sky130_fd_sc_hd__fill_1
XFILLER_0_74_665 VGND VGND VPWR VPWR sky130_fd_sc_hd__fill_1
X_7684_ _3774_ VGND VGND VPWR VPWR _3814_ sky130_fd_sc_hd__clkbuf_4
XFILLER_0_46_356 VGND VGND VPWR VPWR sky130_fd_sc_hd__decap_8
X_6635_ _2889_ _2890_ VGND VGND VPWR VPWR _1122_ sky130_fd_sc_hd__nor2_1
XFILLER_0_34_518 VGND VGND VPWR VPWR sky130_fd_sc_hd__decap_4
XFILLER_0_104_417 VGND VGND VPWR VPWR sky130_fd_sc_hd__decap_3
X_6566_ _2848_ VGND VGND VPWR VPWR _1095_ sky130_fd_sc_hd__clkbuf_1
X_8305_ clknet_leaf_34_clk _0394_ VGND VGND VPWR VPWR u_input_buffer.fifo_mem\[44\]\[7\]
+ sky130_fd_sc_hd__dfxtp_1
XFILLER_0_89_94 VGND VGND VPWR VPWR sky130_fd_sc_hd__fill_2
X_5517_ net686 _2250_ _2277_ VGND VGND VPWR VPWR _2281_ sky130_fd_sc_hd__mux2_1
X_8236_ clknet_leaf_25_clk _0325_ VGND VGND VPWR VPWR u_input_buffer.fifo_mem\[48\]\[2\]
+ sky130_fd_sc_hd__dfxtp_1
X_6497_ net430 _1402_ _2807_ VGND VGND VPWR VPWR _2812_ sky130_fd_sc_hd__mux2_1
XFILLER_0_2_681 VGND VGND VPWR VPWR sky130_fd_sc_hd__decap_4
X_5448_ _2235_ VGND VGND VPWR VPWR _0590_ sky130_fd_sc_hd__clkbuf_1
XFILLER_0_100_667 VGND VGND VPWR VPWR sky130_fd_sc_hd__fill_1
X_8167_ clknet_leaf_108_clk _0256_ VGND VGND VPWR VPWR u_input_buffer.fifo_mem\[53\]\[13\]
+ sky130_fd_sc_hd__dfxtp_1
XFILLER_0_1_191 VGND VGND VPWR VPWR sky130_fd_sc_hd__fill_1
X_5379_ net528 _2012_ _2186_ VGND VGND VPWR VPWR _2199_ sky130_fd_sc_hd__mux2_1
X_7118_ u_input_buffer.fifo_mem\[29\]\[8\] _2939_ _2941_ u_input_buffer.fifo_mem\[13\]\[8\]
+ _3361_ VGND VGND VPWR VPWR _3362_ sky130_fd_sc_hd__a221o_1
X_8098_ clknet_leaf_1_clk _0187_ VGND VGND VPWR VPWR u_input_buffer.fifo_mem\[57\]\[8\]
+ sky130_fd_sc_hd__dfxtp_1
Xfanout199 net200 VGND VGND VPWR VPWR net199 sky130_fd_sc_hd__buf_4
X_7049_ u_input_buffer.fifo_mem\[51\]\[6\] _2990_ _2993_ u_input_buffer.fifo_mem\[11\]\[6\]
+ _3294_ VGND VGND VPWR VPWR _3295_ sky130_fd_sc_hd__a221o_1
Xfanout177 net178 VGND VGND VPWR VPWR net177 sky130_fd_sc_hd__buf_2
Xfanout188 net189 VGND VGND VPWR VPWR net188 sky130_fd_sc_hd__clkbuf_2
XTAP_1113 VGND VPWR sky130_fd_sc_hd__tapvpwrvgnd_1
XTAP_1102 VGND VPWR sky130_fd_sc_hd__tapvpwrvgnd_1
XFILLER_0_69_437 VGND VGND VPWR VPWR sky130_fd_sc_hd__fill_1
XTAP_1146 VGND VPWR sky130_fd_sc_hd__tapvpwrvgnd_1
XTAP_1135 VGND VPWR sky130_fd_sc_hd__tapvpwrvgnd_1
XTAP_1124 VGND VPWR sky130_fd_sc_hd__tapvpwrvgnd_1
XTAP_1179 VGND VPWR sky130_fd_sc_hd__tapvpwrvgnd_1
XTAP_1168 VGND VPWR sky130_fd_sc_hd__tapvpwrvgnd_1
XTAP_1157 VGND VPWR sky130_fd_sc_hd__tapvpwrvgnd_1
XFILLER_0_65_665 VGND VGND VPWR VPWR sky130_fd_sc_hd__decap_6
XFILLER_0_60_392 VGND VGND VPWR VPWR sky130_fd_sc_hd__decap_3
XTAP_908 VGND VPWR sky130_fd_sc_hd__tapvpwrvgnd_1
XTAP_919 VGND VPWR sky130_fd_sc_hd__tapvpwrvgnd_1
XFILLER_0_109_15 VPWR VGND VPWR VGND sky130_ef_sc_hd__decap_12
XFILLER_0_34_45 VGND VGND VPWR VPWR sky130_fd_sc_hd__decap_3
XFILLER_0_87_267 VGND VGND VPWR VPWR sky130_fd_sc_hd__fill_2
XFILLER_0_87_256 VGND VGND VPWR VPWR sky130_fd_sc_hd__fill_2
X_4750_ _1597_ _1598_ _1678_ VGND VGND VPWR VPWR _1853_ sky130_fd_sc_hd__or3_4
X_4681_ _1634_ _1815_ VGND VGND VPWR VPWR _1816_ sky130_fd_sc_hd__nand2_4
XFILLER_0_50_66 VGND VGND VPWR VPWR sky130_fd_sc_hd__fill_1
X_6420_ _2770_ VGND VGND VPWR VPWR _2771_ sky130_fd_sc_hd__clkbuf_4
XFILLER_0_113_225 VPWR VGND VPWR VGND sky130_ef_sc_hd__decap_12
XFILLER_0_70_156 VGND VGND VPWR VPWR sky130_fd_sc_hd__fill_2
XFILLER_0_3_445 VGND VGND VPWR VPWR sky130_fd_sc_hd__decap_3
X_6351_ _1796_ _2567_ VGND VGND VPWR VPWR _2734_ sky130_fd_sc_hd__nor2_4
XFILLER_0_113_258 VGND VGND VPWR VPWR sky130_fd_sc_hd__decap_4
X_5302_ _2158_ VGND VGND VPWR VPWR _0521_ sky130_fd_sc_hd__clkbuf_1
X_9070_ clknet_leaf_48_clk _1158_ VGND VGND VPWR VPWR u_input_buffer.fifo_mem\[63\]\[0\]
+ sky130_fd_sc_hd__dfxtp_1
X_6282_ _1755_ _2567_ VGND VGND VPWR VPWR _2697_ sky130_fd_sc_hd__nor2_4
X_5233_ net323 _2002_ _2115_ VGND VGND VPWR VPWR _2122_ sky130_fd_sc_hd__mux2_1
X_8021_ clknet_leaf_89_clk _0110_ VGND VGND VPWR VPWR u_input_buffer.fifo_mem\[62\]\[11\]
+ sky130_fd_sc_hd__dfxtp_1
X_5164_ net940 _2002_ _2078_ VGND VGND VPWR VPWR _2085_ sky130_fd_sc_hd__mux2_1
X_4115_ u_sensor_interface.sensor_array\[0\]\[9\] u_sensor_interface.sensor_array\[1\]\[9\]
+ net111 VGND VGND VPWR VPWR _1434_ sky130_fd_sc_hd__mux2_1
X_5095_ _2048_ VGND VGND VPWR VPWR _0424_ sky130_fd_sc_hd__clkbuf_1
X_4046_ net267 net52 _1367_ VGND VGND VPWR VPWR _1375_ sky130_fd_sc_hd__mux2_1
X_8923_ clknet_leaf_111_clk _1012_ VGND VGND VPWR VPWR u_input_buffer.fifo_mem\[5\]\[1\]
+ sky130_fd_sc_hd__dfxtp_1
X_8854_ clknet_leaf_71_clk _0943_ VGND VGND VPWR VPWR u_input_buffer.fifo_mem\[10\]\[12\]
+ sky130_fd_sc_hd__dfxtp_1
XPHY_207 VGND VGND VPWR VPWR sky130_fd_sc_hd__decap_3
XFILLER_0_93_204 VGND VGND VPWR VPWR sky130_fd_sc_hd__fill_1
X_7805_ _3900_ VGND VGND VPWR VPWR _1282_ sky130_fd_sc_hd__clkbuf_1
XFILLER_0_115_91 VGND VGND VPWR VPWR sky130_fd_sc_hd__decap_3
XPHY_229 VGND VGND VPWR VPWR sky130_fd_sc_hd__decap_3
XPHY_218 VGND VGND VPWR VPWR sky130_fd_sc_hd__decap_3
X_8785_ clknet_leaf_32_clk _0874_ VGND VGND VPWR VPWR u_input_buffer.fifo_mem\[14\]\[7\]
+ sky130_fd_sc_hd__dfxtp_1
X_5997_ _1626_ net1105 _2530_ VGND VGND VPWR VPWR _2544_ sky130_fd_sc_hd__mux2_1
X_7736_ u_register_bank.window_cfg\[21\] _3847_ _3848_ u_register_bank.threshold_cfg\[21\]
+ _3854_ VGND VGND VPWR VPWR _3855_ sky130_fd_sc_hd__a221o_1
X_4948_ net469 _1722_ _1952_ VGND VGND VPWR VPWR _1962_ sky130_fd_sc_hd__mux2_1
X_7667_ _3800_ net142 _3782_ VGND VGND VPWR VPWR _3801_ sky130_fd_sc_hd__mux2_1
XFILLER_0_74_473 VGND VGND VPWR VPWR sky130_fd_sc_hd__decap_3
XFILLER_0_46_153 VGND VGND VPWR VPWR sky130_fd_sc_hd__fill_1
X_4879_ _1923_ VGND VGND VPWR VPWR _0333_ sky130_fd_sc_hd__clkbuf_1
X_6618_ _2878_ VGND VGND VPWR VPWR _2879_ sky130_fd_sc_hd__clkbuf_4
XFILLER_0_46_197 VGND VGND VPWR VPWR sky130_fd_sc_hd__decap_3
X_7598_ _3754_ VGND VGND VPWR VPWR _1221_ sky130_fd_sc_hd__clkbuf_1
X_6549_ _1628_ net1060 _2824_ VGND VGND VPWR VPWR _2839_ sky130_fd_sc_hd__mux2_1
XFILLER_0_112_280 VGND VGND VPWR VPWR sky130_fd_sc_hd__fill_1
X_9199_ net179 _1286_ net209 VGND VGND VPWR VPWR u_register_bank.sensor_enable\[0\]
+ sky130_fd_sc_hd__dfrtp_1
X_8219_ clknet_leaf_23_clk _0308_ VGND VGND VPWR VPWR u_input_buffer.fifo_mem\[49\]\[1\]
+ sky130_fd_sc_hd__dfxtp_1
XFILLER_0_97_521 VGND VGND VPWR VPWR sky130_fd_sc_hd__fill_1
XFILLER_0_69_223 VGND VGND VPWR VPWR sky130_fd_sc_hd__fill_1
XFILLER_0_38_610 VGND VGND VPWR VPWR sky130_fd_sc_hd__fill_1
XFILLER_0_38_643 VGND VGND VPWR VPWR sky130_fd_sc_hd__fill_1
XFILLER_0_112_9 VPWR VGND VPWR VGND sky130_ef_sc_hd__decap_12
XFILLER_0_111_27 VPWR VGND VPWR VGND sky130_ef_sc_hd__decap_12
XFILLER_0_80_421 VGND VGND VPWR VPWR sky130_fd_sc_hd__fill_2
XFILLER_0_65_495 VGND VGND VPWR VPWR sky130_fd_sc_hd__fill_2
XFILLER_0_25_337 VGND VGND VPWR VPWR sky130_fd_sc_hd__decap_4
XFILLER_0_96_29 VPWR VGND VPWR VGND sky130_ef_sc_hd__decap_12
XTAP_705 VGND VPWR sky130_fd_sc_hd__tapvpwrvgnd_1
XTAP_716 VGND VPWR sky130_fd_sc_hd__tapvpwrvgnd_1
XTAP_727 VGND VPWR sky130_fd_sc_hd__tapvpwrvgnd_1
XTAP_738 VGND VPWR sky130_fd_sc_hd__tapvpwrvgnd_1
XTAP_749 VGND VPWR sky130_fd_sc_hd__tapvpwrvgnd_1
XFILLER_0_45_55 VGND VGND VPWR VPWR sky130_fd_sc_hd__fill_1
X_5920_ _2495_ VGND VGND VPWR VPWR _0802_ sky130_fd_sc_hd__clkbuf_1
XFILLER_0_88_587 VGND VGND VPWR VPWR sky130_fd_sc_hd__fill_1
XFILLER_0_88_554 VGND VGND VPWR VPWR sky130_fd_sc_hd__decap_8
XFILLER_0_0_57 VPWR VGND VPWR VGND sky130_ef_sc_hd__decap_12
XFILLER_0_0_35 VGND VGND VPWR VPWR sky130_fd_sc_hd__fill_1
X_5851_ _1632_ net1082 _2442_ VGND VGND VPWR VPWR _2459_ sky130_fd_sc_hd__mux2_1
XFILLER_0_48_429 VGND VGND VPWR VPWR sky130_fd_sc_hd__fill_1
X_8570_ clknet_leaf_46_clk _0659_ VGND VGND VPWR VPWR u_input_buffer.fifo_mem\[27\]\[0\]
+ sky130_fd_sc_hd__dfxtp_1
X_4802_ net437 _1718_ _1874_ VGND VGND VPWR VPWR _1882_ sky130_fd_sc_hd__mux2_1
XFILLER_0_8_537 VGND VGND VPWR VPWR sky130_fd_sc_hd__fill_1
X_5782_ _2422_ VGND VGND VPWR VPWR _0737_ sky130_fd_sc_hd__clkbuf_1
X_4733_ _1844_ VGND VGND VPWR VPWR _0266_ sky130_fd_sc_hd__clkbuf_1
XFILLER_0_71_410 VGND VGND VPWR VPWR sky130_fd_sc_hd__fill_1
XFILLER_0_28_164 VGND VGND VPWR VPWR sky130_fd_sc_hd__fill_2
X_7521_ _3713_ VGND VGND VPWR VPWR _1185_ sky130_fd_sc_hd__clkbuf_1
X_7452_ _3674_ VGND VGND VPWR VPWR _1155_ sky130_fd_sc_hd__clkbuf_1
XFILLER_0_28_197 VGND VGND VPWR VPWR sky130_fd_sc_hd__fill_1
XFILLER_0_114_545 VPWR VGND VPWR VGND sky130_ef_sc_hd__decap_12
X_4664_ net496 _1720_ _1798_ VGND VGND VPWR VPWR _1807_ sky130_fd_sc_hd__mux2_1
X_6403_ _1618_ net1114 _2753_ VGND VGND VPWR VPWR _2762_ sky130_fd_sc_hd__mux2_1
Xhold901 u_input_buffer.fifo_mem\[46\]\[5\] VGND VGND VPWR VPWR net1113 sky130_fd_sc_hd__dlygate4sd3_1
Xhold912 u_input_buffer.fifo_mem\[63\]\[10\] VGND VGND VPWR VPWR net1124 sky130_fd_sc_hd__dlygate4sd3_1
XFILLER_0_12_521 VGND VGND VPWR VPWR sky130_fd_sc_hd__decap_8
X_7383_ net648 _3085_ _3087_ VGND VGND VPWR VPWR _3621_ sky130_fd_sc_hd__o21a_1
X_4595_ net364 _1724_ _1756_ VGND VGND VPWR VPWR _1768_ sky130_fd_sc_hd__mux2_1
XFILLER_0_114_589 VPWR VGND VPWR VGND sky130_ef_sc_hd__decap_12
XFILLER_0_101_93 VGND VGND VPWR VPWR sky130_fd_sc_hd__decap_3
X_6334_ _2725_ VGND VGND VPWR VPWR _0986_ sky130_fd_sc_hd__clkbuf_1
X_9122_ net182 _1210_ net211 VGND VGND VPWR VPWR u_analytics_engine.threshold\[4\]
+ sky130_fd_sc_hd__dfrtp_1
Xhold923 u_input_buffer.fifo_mem\[45\]\[12\] VGND VGND VPWR VPWR net1135 sky130_fd_sc_hd__dlygate4sd3_1
Xhold945 u_input_buffer.fifo_mem\[5\]\[2\] VGND VGND VPWR VPWR net1157 sky130_fd_sc_hd__dlygate4sd3_1
Xhold934 u_input_buffer.fifo_mem\[57\]\[4\] VGND VGND VPWR VPWR net1146 sky130_fd_sc_hd__dlygate4sd3_1
Xhold989 u_input_buffer.fifo_mem\[39\]\[5\] VGND VGND VPWR VPWR net1201 sky130_fd_sc_hd__dlygate4sd3_1
X_9053_ clknet_leaf_26_clk _1142_ VGND VGND VPWR VPWR u_sensor_interface.sensor_array\[3\]\[0\]
+ sky130_fd_sc_hd__dfxtp_1
X_6265_ _2688_ VGND VGND VPWR VPWR _0954_ sky130_fd_sc_hd__clkbuf_1
Xhold956 u_input_buffer.fifo_mem\[17\]\[3\] VGND VGND VPWR VPWR net1168 sky130_fd_sc_hd__dlygate4sd3_1
Xhold978 u_input_buffer.fifo_mem\[17\]\[9\] VGND VGND VPWR VPWR net1190 sky130_fd_sc_hd__dlygate4sd3_1
Xhold967 u_input_buffer.fifo_mem\[57\]\[2\] VGND VGND VPWR VPWR net1179 sky130_fd_sc_hd__dlygate4sd3_1
X_5216_ _2112_ VGND VGND VPWR VPWR _0481_ sky130_fd_sc_hd__clkbuf_1
XFILLER_0_50_3 VGND VGND VPWR VPWR sky130_fd_sc_hd__decap_3
X_8004_ clknet_leaf_78_clk _0093_ net190 VGND VGND VPWR VPWR u_sample_counter.sample_count\[27\]
+ sky130_fd_sc_hd__dfrtp_1
X_6196_ net611 _2512_ _2644_ VGND VGND VPWR VPWR _2652_ sky130_fd_sc_hd__mux2_1
X_5147_ _2075_ VGND VGND VPWR VPWR _0449_ sky130_fd_sc_hd__clkbuf_1
X_5078_ net413 _2018_ _2023_ VGND VGND VPWR VPWR _2039_ sky130_fd_sc_hd__mux2_1
X_4029_ u_sensor_interface.sensor_array\[0\]\[7\] net107 _1356_ VGND VGND VPWR VPWR
+ _1366_ sky130_fd_sc_hd__mux2_1
X_8906_ clknet_leaf_52_clk _0995_ VGND VGND VPWR VPWR u_input_buffer.fifo_mem\[6\]\[0\]
+ sky130_fd_sc_hd__dfxtp_1
XFILLER_0_39_418 VGND VGND VPWR VPWR sky130_fd_sc_hd__decap_3
X_8837_ clknet_leaf_98_clk _0926_ VGND VGND VPWR VPWR u_input_buffer.fifo_mem\[11\]\[11\]
+ sky130_fd_sc_hd__dfxtp_1
X_8768_ clknet_leaf_35_clk _0857_ VGND VGND VPWR VPWR u_input_buffer.fifo_mem\[15\]\[6\]
+ sky130_fd_sc_hd__dfxtp_1
XFILLER_0_19_164 VGND VGND VPWR VPWR sky130_fd_sc_hd__fill_1
X_7719_ u_register_bank.window_cfg\[18\] _3812_ _3813_ u_register_bank.threshold_cfg\[18\]
+ _3840_ VGND VGND VPWR VPWR _3841_ sky130_fd_sc_hd__a221o_1
XFILLER_0_105_501 VGND VGND VPWR VPWR sky130_fd_sc_hd__decap_3
X_8699_ clknet_leaf_67_clk _0788_ VGND VGND VPWR VPWR u_input_buffer.fifo_mem\[19\]\[1\]
+ sky130_fd_sc_hd__dfxtp_1
XFILLER_0_85_502 VGND VGND VPWR VPWR sky130_fd_sc_hd__fill_2
XFILLER_0_15_69 VPWR VGND VPWR VGND sky130_ef_sc_hd__decap_12
XFILLER_0_38_440 VGND VGND VPWR VPWR sky130_fd_sc_hd__fill_2
XFILLER_0_5_529 VPWR VGND VPWR VGND sky130_ef_sc_hd__decap_12
XFILLER_0_31_57 VGND VGND VPWR VPWR sky130_fd_sc_hd__decap_6
XFILLER_0_80_251 VGND VGND VPWR VPWR sky130_fd_sc_hd__fill_1
Xhold208 u_input_buffer.fifo_mem\[42\]\[3\] VGND VGND VPWR VPWR net420 sky130_fd_sc_hd__dlygate4sd3_1
Xhold219 u_input_buffer.fifo_mem\[47\]\[9\] VGND VGND VPWR VPWR net431 sky130_fd_sc_hd__dlygate4sd3_1
X_4380_ _1642_ VGND VGND VPWR VPWR _0115_ sky130_fd_sc_hd__clkbuf_1
XFILLER_0_0_278 VGND VGND VPWR VPWR sky130_fd_sc_hd__fill_2
XTAP_502 VGND VPWR sky130_fd_sc_hd__tapvpwrvgnd_1
XTAP_513 VGND VPWR sky130_fd_sc_hd__tapvpwrvgnd_1
XTAP_524 VGND VPWR sky130_fd_sc_hd__tapvpwrvgnd_1
X_6050_ _2573_ VGND VGND VPWR VPWR _0854_ sky130_fd_sc_hd__clkbuf_1
XFILLER_0_0_289 VGND VGND VPWR VPWR sky130_fd_sc_hd__fill_2
XTAP_535 VGND VPWR sky130_fd_sc_hd__tapvpwrvgnd_1
XTAP_546 VGND VPWR sky130_fd_sc_hd__tapvpwrvgnd_1
XTAP_557 VGND VPWR sky130_fd_sc_hd__tapvpwrvgnd_1
X_5001_ _1991_ VGND VGND VPWR VPWR _0387_ sky130_fd_sc_hd__clkbuf_1
XTAP_568 VGND VPWR sky130_fd_sc_hd__tapvpwrvgnd_1
XTAP_579 VGND VPWR sky130_fd_sc_hd__tapvpwrvgnd_1
X_6952_ _3194_ _3196_ _3198_ _3200_ VGND VGND VPWR VPWR _3201_ sky130_fd_sc_hd__or4_1
X_5903_ net820 _2258_ _2479_ VGND VGND VPWR VPWR _2487_ sky130_fd_sc_hd__mux2_1
X_6883_ u_input_buffer.fifo_mem\[17\]\[2\] _2943_ _2945_ u_input_buffer.fifo_mem\[5\]\[2\]
+ VGND VGND VPWR VPWR _3133_ sky130_fd_sc_hd__a22o_1
X_8622_ clknet_leaf_66_clk _0711_ VGND VGND VPWR VPWR u_input_buffer.fifo_mem\[24\]\[4\]
+ sky130_fd_sc_hd__dfxtp_1
X_5834_ _2450_ VGND VGND VPWR VPWR _0761_ sky130_fd_sc_hd__clkbuf_1
X_5765_ net554 _2256_ _2407_ VGND VGND VPWR VPWR _2414_ sky130_fd_sc_hd__mux2_1
XFILLER_0_56_270 VGND VGND VPWR VPWR sky130_fd_sc_hd__fill_2
X_8553_ clknet_leaf_103_clk _0642_ VGND VGND VPWR VPWR u_input_buffer.fifo_mem\[29\]\[15\]
+ sky130_fd_sc_hd__dfxtp_1
XFILLER_0_98_3 VPWR VGND VPWR VGND sky130_ef_sc_hd__decap_12
X_7504_ _3704_ VGND VGND VPWR VPWR _1177_ sky130_fd_sc_hd__clkbuf_1
X_8484_ clknet_leaf_106_clk _0573_ VGND VGND VPWR VPWR u_input_buffer.fifo_mem\[33\]\[10\]
+ sky130_fd_sc_hd__dfxtp_1
X_4716_ _1592_ _1834_ VGND VGND VPWR VPWR _1835_ sky130_fd_sc_hd__nor2_4
X_5696_ _1614_ net839 _2370_ VGND VGND VPWR VPWR _2377_ sky130_fd_sc_hd__mux2_1
X_4647_ _1797_ VGND VGND VPWR VPWR _1798_ sky130_fd_sc_hd__buf_4
X_7435_ u_sensor_interface.sensor_array\[3\]\[5\] net94 _3662_ VGND VGND VPWR VPWR
+ _3666_ sky130_fd_sc_hd__mux2_1
Xhold720 u_input_buffer.fifo_mem\[51\]\[0\] VGND VGND VPWR VPWR net932 sky130_fd_sc_hd__dlygate4sd3_1
XFILLER_0_31_148 VGND VGND VPWR VPWR sky130_fd_sc_hd__fill_2
X_7366_ u_input_buffer.fifo_mem\[31\]\[14\] _3016_ _3019_ u_input_buffer.fifo_mem\[38\]\[14\]
+ VGND VGND VPWR VPWR _3604_ sky130_fd_sc_hd__a22o_1
X_4578_ _1759_ VGND VGND VPWR VPWR _0196_ sky130_fd_sc_hd__clkbuf_1
Xhold753 u_input_buffer.fifo_mem\[27\]\[9\] VGND VGND VPWR VPWR net965 sky130_fd_sc_hd__dlygate4sd3_1
Xhold731 u_input_buffer.fifo_mem\[59\]\[8\] VGND VGND VPWR VPWR net943 sky130_fd_sc_hd__dlygate4sd3_1
Xhold742 u_input_buffer.fifo_mem\[58\]\[14\] VGND VGND VPWR VPWR net954 sky130_fd_sc_hd__dlygate4sd3_1
Xhold764 u_input_buffer.fifo_mem\[17\]\[7\] VGND VGND VPWR VPWR net976 sky130_fd_sc_hd__dlygate4sd3_1
X_6317_ _2715_ VGND VGND VPWR VPWR _2716_ sky130_fd_sc_hd__clkbuf_4
X_9105_ net173 _1193_ net203 VGND VGND VPWR VPWR u_register_bank.window_cfg\[19\]
+ sky130_fd_sc_hd__dfrtp_1
Xhold775 u_input_buffer.fifo_mem\[53\]\[10\] VGND VGND VPWR VPWR net987 sky130_fd_sc_hd__dlygate4sd3_1
Xhold786 u_input_buffer.fifo_mem\[54\]\[11\] VGND VGND VPWR VPWR net998 sky130_fd_sc_hd__dlygate4sd3_1
Xhold797 u_input_buffer.fifo_mem\[41\]\[12\] VGND VGND VPWR VPWR net1009 sky130_fd_sc_hd__dlygate4sd3_1
X_7297_ u_input_buffer.fifo_mem\[15\]\[12\] _3059_ _3061_ u_input_buffer.fifo_mem\[43\]\[12\]
+ VGND VGND VPWR VPWR _3537_ sky130_fd_sc_hd__a22o_1
XFILLER_0_110_581 VGND VGND VPWR VPWR sky130_fd_sc_hd__decap_6
X_6248_ _1736_ _2605_ VGND VGND VPWR VPWR _2679_ sky130_fd_sc_hd__nand2_4
X_9036_ clknet_leaf_97_clk _1125_ net185 VGND VGND VPWR VPWR u_input_buffer.wr_ptr\[5\]
+ sky130_fd_sc_hd__dfrtp_2
X_6179_ _1680_ _2605_ VGND VGND VPWR VPWR _2642_ sky130_fd_sc_hd__and2_1
XFILLER_0_99_605 VGND VGND VPWR VPWR sky130_fd_sc_hd__fill_1
XFILLER_0_67_502 VGND VGND VPWR VPWR sky130_fd_sc_hd__fill_2
XFILLER_0_67_513 VGND VGND VPWR VPWR sky130_fd_sc_hd__fill_1
XFILLER_0_109_169 VGND VGND VPWR VPWR sky130_fd_sc_hd__fill_1
XFILLER_0_75_590 VPWR VGND VPWR VGND sky130_ef_sc_hd__decap_12
XFILLER_0_35_476 VGND VGND VPWR VPWR sky130_fd_sc_hd__fill_1
XFILLER_0_105_386 VGND VGND VPWR VPWR sky130_fd_sc_hd__decap_3
XFILLER_0_105_397 VGND VGND VPWR VPWR sky130_fd_sc_hd__fill_1
XFILLER_0_31_682 VGND VGND VPWR VPWR sky130_fd_sc_hd__decap_4
Xhold80 u_input_buffer.fifo_mem\[36\]\[4\] VGND VGND VPWR VPWR net292 sky130_fd_sc_hd__dlygate4sd3_1
Xhold91 u_input_buffer.fifo_mem\[27\]\[4\] VGND VGND VPWR VPWR net303 sky130_fd_sc_hd__dlygate4sd3_1
Xclkbuf_leaf_70_clk clknet_3_6__leaf_clk VGND VGND VPWR VPWR clknet_leaf_70_clk sky130_fd_sc_hd__clkbuf_16
XFILLER_0_109_681 VGND VGND VPWR VPWR sky130_fd_sc_hd__fill_1
XFILLER_0_26_443 VGND VGND VPWR VPWR sky130_fd_sc_hd__decap_3
X_5550_ _2299_ VGND VGND VPWR VPWR _0628_ sky130_fd_sc_hd__clkbuf_1
X_4501_ _1402_ VGND VGND VPWR VPWR _1712_ sky130_fd_sc_hd__buf_4
X_5481_ _2257_ VGND VGND VPWR VPWR _0601_ sky130_fd_sc_hd__clkbuf_1
X_4432_ _1670_ VGND VGND VPWR VPWR _0139_ sky130_fd_sc_hd__clkbuf_1
X_7220_ u_input_buffer.fifo_mem\[10\]\[10\] _3055_ _3057_ u_input_buffer.fifo_mem\[44\]\[10\]
+ _3461_ VGND VGND VPWR VPWR _3462_ sky130_fd_sc_hd__a221o_1
XFILLER_0_111_334 VGND VGND VPWR VPWR sky130_fd_sc_hd__fill_2
XFILLER_0_1_532 VGND VGND VPWR VPWR sky130_fd_sc_hd__decap_8
XFILLER_0_22_671 VGND VGND VPWR VPWR sky130_fd_sc_hd__fill_2
X_4363_ net695 _1628_ _1601_ VGND VGND VPWR VPWR _1629_ sky130_fd_sc_hd__mux2_1
X_7151_ u_input_buffer.fifo_mem\[21\]\[9\] _2909_ _2913_ u_input_buffer.fifo_mem\[25\]\[9\]
+ VGND VGND VPWR VPWR _3394_ sky130_fd_sc_hd__a22o_1
X_7082_ u_input_buffer.fifo_mem\[36\]\[7\] _2951_ _2955_ u_input_buffer.fifo_mem\[35\]\[7\]
+ _3326_ VGND VGND VPWR VPWR _3327_ sky130_fd_sc_hd__a221o_1
X_4294_ _1571_ u_analytics_engine.data_in\[2\] VGND VGND VPWR VPWR _1574_ sky130_fd_sc_hd__nor2_1
XTAP_321 VGND VPWR sky130_fd_sc_hd__tapvpwrvgnd_1
XTAP_332 VGND VPWR sky130_fd_sc_hd__tapvpwrvgnd_1
XFILLER_0_6_89 VGND VGND VPWR VPWR sky130_fd_sc_hd__decap_4
XTAP_310 VGND VPWR sky130_fd_sc_hd__tapvpwrvgnd_1
X_6102_ _2600_ VGND VGND VPWR VPWR _0879_ sky130_fd_sc_hd__clkbuf_1
XTAP_376 VGND VPWR sky130_fd_sc_hd__tapvpwrvgnd_1
XTAP_365 VGND VPWR sky130_fd_sc_hd__tapvpwrvgnd_1
XTAP_354 VGND VPWR sky130_fd_sc_hd__tapvpwrvgnd_1
XTAP_343 VGND VPWR sky130_fd_sc_hd__tapvpwrvgnd_1
X_6033_ net408 _2524_ _2548_ VGND VGND VPWR VPWR _2563_ sky130_fd_sc_hd__mux2_1
XTAP_398 VGND VPWR sky130_fd_sc_hd__tapvpwrvgnd_1
XTAP_387 VGND VPWR sky130_fd_sc_hd__tapvpwrvgnd_1
X_7984_ clknet_leaf_57_clk _0073_ net199 VGND VGND VPWR VPWR u_sample_counter.sample_count\[7\]
+ sky130_fd_sc_hd__dfrtp_1
XFILLER_0_13_3 VPWR VGND VPWR VGND sky130_ef_sc_hd__decap_12
XTAP_1509 VGND VPWR sky130_fd_sc_hd__tapvpwrvgnd_1
XFILLER_0_89_682 VGND VGND VPWR VPWR sky130_fd_sc_hd__decap_4
XFILLER_0_89_671 VGND VGND VPWR VPWR sky130_fd_sc_hd__fill_1
X_6935_ u_input_buffer.fifo_mem\[47\]\[3\] _2880_ _3007_ _3009_ u_input_buffer.fifo_mem\[24\]\[3\]
+ VGND VGND VPWR VPWR _3184_ sky130_fd_sc_hd__a32o_1
XPHY_16 VGND VGND VPWR VPWR sky130_fd_sc_hd__decap_3
XPHY_27 VGND VGND VPWR VPWR sky130_fd_sc_hd__decap_3
XPHY_38 VGND VGND VPWR VPWR sky130_fd_sc_hd__decap_3
XPHY_49 VGND VGND VPWR VPWR sky130_fd_sc_hd__decap_3
X_6866_ u_input_buffer.fifo_mem\[39\]\[1\] _3050_ _3052_ u_input_buffer.fifo_mem\[40\]\[1\]
+ VGND VGND VPWR VPWR _3117_ sky130_fd_sc_hd__a22o_1
Xclkbuf_leaf_61_clk clknet_3_6__leaf_clk VGND VGND VPWR VPWR clknet_leaf_61_clk sky130_fd_sc_hd__clkbuf_16
XFILLER_0_91_335 VGND VGND VPWR VPWR sky130_fd_sc_hd__fill_1
XFILLER_0_9_665 VGND VGND VPWR VPWR sky130_fd_sc_hd__decap_6
X_5817_ net1108 _2274_ _2424_ VGND VGND VPWR VPWR _2441_ sky130_fd_sc_hd__mux2_1
XFILLER_0_29_281 VGND VGND VPWR VPWR sky130_fd_sc_hd__fill_1
X_6797_ _2916_ _3023_ VGND VGND VPWR VPWR _3049_ sky130_fd_sc_hd__and2_4
X_8605_ clknet_leaf_5_clk _0694_ VGND VGND VPWR VPWR u_input_buffer.fifo_mem\[25\]\[3\]
+ sky130_fd_sc_hd__dfxtp_1
X_8536_ clknet_leaf_85_clk _0625_ VGND VGND VPWR VPWR u_input_buffer.fifo_mem\[30\]\[14\]
+ sky130_fd_sc_hd__dfxtp_1
X_5748_ net264 _2274_ _2387_ VGND VGND VPWR VPWR _2404_ sky130_fd_sc_hd__mux2_1
XFILLER_0_115_651 VPWR VGND VPWR VGND sky130_ef_sc_hd__decap_12
X_8467_ clknet_leaf_15_clk _0556_ VGND VGND VPWR VPWR u_input_buffer.fifo_mem\[34\]\[9\]
+ sky130_fd_sc_hd__dfxtp_1
X_5679_ _2367_ VGND VGND VPWR VPWR _0689_ sky130_fd_sc_hd__clkbuf_1
X_8398_ clknet_leaf_45_clk _0487_ VGND VGND VPWR VPWR u_input_buffer.fifo_mem\[38\]\[4\]
+ sky130_fd_sc_hd__dfxtp_1
X_7418_ u_input_buffer.fifo_mem\[54\]\[15\] _3077_ _3079_ u_input_buffer.fifo_mem\[46\]\[15\]
+ VGND VGND VPWR VPWR _3655_ sky130_fd_sc_hd__a22o_1
Xhold550 u_input_buffer.fifo_mem\[4\]\[9\] VGND VGND VPWR VPWR net762 sky130_fd_sc_hd__dlygate4sd3_1
XFILLER_0_12_181 VGND VGND VPWR VPWR sky130_fd_sc_hd__fill_2
Xhold561 u_sensor_interface.sensor_array\[1\]\[10\] VGND VGND VPWR VPWR net773 sky130_fd_sc_hd__dlygate4sd3_1
X_7349_ u_input_buffer.fifo_mem\[41\]\[14\] _2918_ _2920_ u_input_buffer.fifo_mem\[45\]\[14\]
+ _3586_ VGND VGND VPWR VPWR _3587_ sky130_fd_sc_hd__a221o_1
Xhold572 u_input_buffer.fifo_mem\[27\]\[13\] VGND VGND VPWR VPWR net784 sky130_fd_sc_hd__dlygate4sd3_1
Xhold594 u_input_buffer.fifo_mem\[58\]\[2\] VGND VGND VPWR VPWR net806 sky130_fd_sc_hd__dlygate4sd3_1
XFILLER_0_12_192 VGND VGND VPWR VPWR sky130_fd_sc_hd__decap_4
Xhold583 u_input_buffer.fifo_mem\[44\]\[15\] VGND VGND VPWR VPWR net795 sky130_fd_sc_hd__dlygate4sd3_1
X_9019_ clknet_leaf_86_clk _1108_ net189 VGND VGND VPWR VPWR u_input_buffer.count\[1\]
+ sky130_fd_sc_hd__dfrtp_1
XFILLER_0_99_402 VGND VGND VPWR VPWR sky130_fd_sc_hd__decap_3
XFILLER_0_67_321 VGND VGND VPWR VPWR sky130_fd_sc_hd__fill_1
Xclkbuf_leaf_52_clk clknet_3_7__leaf_clk VGND VGND VPWR VPWR clknet_leaf_52_clk sky130_fd_sc_hd__clkbuf_16
XFILLER_0_103_39 VPWR VGND VPWR VGND sky130_ef_sc_hd__decap_12
XFILLER_0_94_195 VGND VGND VPWR VPWR sky130_fd_sc_hd__fill_1
XFILLER_0_94_184 VGND VGND VPWR VPWR sky130_fd_sc_hd__fill_2
XFILLER_0_12_15 VPWR VGND VPWR VGND sky130_ef_sc_hd__decap_12
XFILLER_0_82_368 VGND VGND VPWR VPWR sky130_fd_sc_hd__fill_2
XFILLER_0_112_109 VPWR VGND VPWR VGND sky130_ef_sc_hd__decap_12
XFILLER_0_50_243 VGND VGND VPWR VPWR sky130_fd_sc_hd__fill_1
XFILLER_0_37_78 VGND VGND VPWR VPWR sky130_fd_sc_hd__fill_1
X_4981_ _1427_ net650 _1971_ VGND VGND VPWR VPWR _1980_ sky130_fd_sc_hd__mux2_1
Xclkbuf_leaf_43_clk clknet_3_6__leaf_clk VGND VGND VPWR VPWR clknet_leaf_43_clk sky130_fd_sc_hd__clkbuf_16
X_6720_ _2899_ _2894_ VGND VGND VPWR VPWR _2972_ sky130_fd_sc_hd__nor2_2
X_6651_ _2900_ _2902_ VGND VGND VPWR VPWR _2903_ sky130_fd_sc_hd__nor2_4
XFILLER_0_73_346 VGND VGND VPWR VPWR sky130_fd_sc_hd__decap_3
XFILLER_0_6_613 VPWR VGND VPWR VGND sky130_ef_sc_hd__decap_12
X_6582_ _2856_ VGND VGND VPWR VPWR _1103_ sky130_fd_sc_hd__clkbuf_1
X_5602_ _2326_ VGND VGND VPWR VPWR _0653_ sky130_fd_sc_hd__clkbuf_1
X_8321_ clknet_leaf_33_clk _0410_ VGND VGND VPWR VPWR u_input_buffer.fifo_mem\[43\]\[7\]
+ sky130_fd_sc_hd__dfxtp_1
XFILLER_0_6_657 VPWR VGND VPWR VGND sky130_ef_sc_hd__decap_12
X_5533_ net504 _2266_ _2276_ VGND VGND VPWR VPWR _2289_ sky130_fd_sc_hd__mux2_1
XFILLER_0_5_178 VGND VGND VPWR VPWR sky130_fd_sc_hd__fill_2
XFILLER_0_112_643 VGND VGND VPWR VPWR sky130_fd_sc_hd__fill_1
X_8252_ clknet_leaf_59_clk _0341_ VGND VGND VPWR VPWR u_input_buffer.fifo_mem\[47\]\[2\]
+ sky130_fd_sc_hd__dfxtp_1
X_5464_ _1384_ VGND VGND VPWR VPWR _2246_ sky130_fd_sc_hd__clkbuf_4
XFILLER_0_78_41 VPWR VGND VPWR VGND sky130_ef_sc_hd__decap_12
X_4415_ net571 _1588_ _1661_ VGND VGND VPWR VPWR _1662_ sky130_fd_sc_hd__mux2_1
XFILLER_0_78_85 VGND VGND VPWR VPWR sky130_fd_sc_hd__fill_2
X_7203_ u_input_buffer.fifo_mem\[12\]\[10\] _2979_ _2981_ u_input_buffer.fifo_mem\[18\]\[10\]
+ _3444_ VGND VGND VPWR VPWR _3445_ sky130_fd_sc_hd__a221o_1
X_8183_ clknet_leaf_73_clk _0272_ VGND VGND VPWR VPWR u_input_buffer.fifo_mem\[52\]\[13\]
+ sky130_fd_sc_hd__dfxtp_1
X_5395_ _1391_ net1123 _2205_ VGND VGND VPWR VPWR _2208_ sky130_fd_sc_hd__mux2_1
X_4346_ _1617_ VGND VGND VPWR VPWR _0106_ sky130_fd_sc_hd__clkbuf_1
X_7134_ u_input_buffer.fifo_mem\[30\]\[8\] _3029_ _3031_ u_input_buffer.fifo_mem\[58\]\[8\]
+ VGND VGND VPWR VPWR _3378_ sky130_fd_sc_hd__a22o_1
X_7065_ u_input_buffer.fifo_mem\[3\]\[6\] _3070_ _3072_ u_input_buffer.fifo_mem\[60\]\[6\]
+ VGND VGND VPWR VPWR _3311_ sky130_fd_sc_hd__a22o_1
X_4277_ _1556_ _1552_ _1541_ VGND VGND VPWR VPWR _1557_ sky130_fd_sc_hd__or3b_1
X_6016_ _2554_ VGND VGND VPWR VPWR _0839_ sky130_fd_sc_hd__clkbuf_1
XTAP_1339 VGND VPWR sky130_fd_sc_hd__tapvpwrvgnd_1
XTAP_1328 VGND VPWR sky130_fd_sc_hd__tapvpwrvgnd_1
XTAP_1317 VGND VPWR sky130_fd_sc_hd__tapvpwrvgnd_1
XTAP_1306 VGND VPWR sky130_fd_sc_hd__tapvpwrvgnd_1
X_7967_ clknet_leaf_16_clk _0057_ net193 VGND VGND VPWR VPWR u_input_buffer.data_in\[7\]
+ sky130_fd_sc_hd__dfrtp_1
Xclkbuf_leaf_34_clk clknet_3_5__leaf_clk VGND VGND VPWR VPWR clknet_leaf_34_clk sky130_fd_sc_hd__clkbuf_16
X_7898_ clknet_leaf_81_clk net217 net188 VGND VGND VPWR VPWR u_register_bank.status_flags\[18\]
+ sky130_fd_sc_hd__dfrtp_1
X_6918_ u_input_buffer.fifo_mem\[33\]\[3\] _2898_ _2904_ u_input_buffer.fifo_mem\[61\]\[3\]
+ _3166_ VGND VGND VPWR VPWR _3167_ sky130_fd_sc_hd__a221o_1
X_6849_ u_input_buffer.fifo_mem\[16\]\[1\] _2971_ _2973_ u_input_buffer.fifo_mem\[49\]\[1\]
+ _2975_ VGND VGND VPWR VPWR _3100_ sky130_fd_sc_hd__a221o_1
XFILLER_0_9_495 VGND VGND VPWR VPWR sky130_fd_sc_hd__decap_8
X_8519_ clknet_leaf_92_clk _0608_ VGND VGND VPWR VPWR u_input_buffer.fifo_mem\[31\]\[13\]
+ sky130_fd_sc_hd__dfxtp_1
Xhold380 u_input_buffer.fifo_mem\[3\]\[3\] VGND VGND VPWR VPWR net592 sky130_fd_sc_hd__dlygate4sd3_1
XFILLER_0_2_3 VPWR VGND VPWR VGND sky130_ef_sc_hd__decap_12
Xhold391 u_input_buffer.fifo_mem\[16\]\[0\] VGND VGND VPWR VPWR net603 sky130_fd_sc_hd__dlygate4sd3_1
Xhold1080 u_input_buffer.fifo_mem\[38\]\[1\] VGND VGND VPWR VPWR net1292 sky130_fd_sc_hd__dlygate4sd3_1
XFILLER_0_59_107 VGND VGND VPWR VPWR sky130_fd_sc_hd__fill_2
Xhold1091 net153 VGND VGND VPWR VPWR net1303 sky130_fd_sc_hd__dlygate4sd3_1
Xclkbuf_leaf_25_clk clknet_3_5__leaf_clk VGND VGND VPWR VPWR clknet_leaf_25_clk sky130_fd_sc_hd__clkbuf_16
XFILLER_0_68_685 VGND VGND VPWR VPWR sky130_fd_sc_hd__fill_1
XFILLER_0_2_126 VPWR VGND VPWR VGND sky130_ef_sc_hd__decap_12
XFILLER_0_11_449 VPWR VGND VPWR VGND sky130_ef_sc_hd__decap_12
X_4200_ _1497_ _1498_ VGND VGND VPWR VPWR _1499_ sky130_fd_sc_hd__and2_1
X_5180_ net534 _2018_ _2077_ VGND VGND VPWR VPWR _2093_ sky130_fd_sc_hd__mux2_1
XFILLER_0_48_44 VGND VGND VPWR VPWR sky130_fd_sc_hd__decap_4
X_4131_ _1447_ u_sensor_interface.sensor_array\[3\]\[11\] net113 VGND VGND VPWR VPWR
+ _1448_ sky130_fd_sc_hd__mux2_1
X_4062_ _1385_ _1388_ _0000_ VGND VGND VPWR VPWR _1389_ sky130_fd_sc_hd__mux2_1
XFILLER_0_3_57 VPWR VGND VPWR VGND sky130_ef_sc_hd__decap_12
X_8870_ clknet_leaf_107_clk _0959_ VGND VGND VPWR VPWR u_input_buffer.fifo_mem\[9\]\[12\]
+ sky130_fd_sc_hd__dfxtp_1
XFILLER_0_64_98 VGND VGND VPWR VPWR sky130_fd_sc_hd__fill_1
X_7821_ _3909_ VGND VGND VPWR VPWR _1289_ sky130_fd_sc_hd__clkbuf_1
X_7752_ u_register_bank.window_cfg\[25\] _3847_ _3848_ u_register_bank.threshold_cfg\[25\]
+ _3866_ VGND VGND VPWR VPWR _3867_ sky130_fd_sc_hd__a221o_1
Xclkbuf_leaf_16_clk clknet_3_4__leaf_clk VGND VGND VPWR VPWR clknet_leaf_16_clk sky130_fd_sc_hd__clkbuf_16
X_4964_ _1970_ VGND VGND VPWR VPWR _1971_ sky130_fd_sc_hd__buf_4
X_6703_ _2954_ VGND VGND VPWR VPWR _2955_ sky130_fd_sc_hd__clkbuf_4
X_7683_ _3735_ VGND VGND VPWR VPWR _3813_ sky130_fd_sc_hd__clkbuf_4
X_4895_ _1933_ VGND VGND VPWR VPWR _1934_ sky130_fd_sc_hd__buf_4
XFILLER_0_73_165 VGND VGND VPWR VPWR sky130_fd_sc_hd__decap_3
XFILLER_0_6_454 VGND VGND VPWR VPWR sky130_fd_sc_hd__fill_2
X_6634_ net1325 _1637_ _1598_ VGND VGND VPWR VPWR _2890_ sky130_fd_sc_hd__a21oi_1
XFILLER_0_89_51 VGND VGND VPWR VPWR sky130_fd_sc_hd__decap_4
X_6565_ net807 _1402_ _2843_ VGND VGND VPWR VPWR _2848_ sky130_fd_sc_hd__mux2_1
XFILLER_0_80_3 VGND VGND VPWR VPWR sky130_fd_sc_hd__decap_6
XFILLER_0_73_198 VGND VGND VPWR VPWR sky130_fd_sc_hd__fill_1
XFILLER_0_42_530 VGND VGND VPWR VPWR sky130_fd_sc_hd__fill_2
X_8304_ clknet_leaf_35_clk _0393_ VGND VGND VPWR VPWR u_input_buffer.fifo_mem\[44\]\[6\]
+ sky130_fd_sc_hd__dfxtp_1
X_5516_ _2280_ VGND VGND VPWR VPWR _0613_ sky130_fd_sc_hd__clkbuf_1
X_6496_ _2811_ VGND VGND VPWR VPWR _1062_ sky130_fd_sc_hd__clkbuf_1
X_8235_ clknet_leaf_17_clk _0324_ VGND VGND VPWR VPWR u_input_buffer.fifo_mem\[48\]\[1\]
+ sky130_fd_sc_hd__dfxtp_1
X_5447_ net481 _2012_ _2222_ VGND VGND VPWR VPWR _2235_ sky130_fd_sc_hd__mux2_1
XFILLER_0_10_460 VGND VGND VPWR VPWR sky130_fd_sc_hd__fill_1
X_8166_ clknet_leaf_105_clk _0255_ VGND VGND VPWR VPWR u_input_buffer.fifo_mem\[53\]\[12\]
+ sky130_fd_sc_hd__dfxtp_1
X_5378_ _2198_ VGND VGND VPWR VPWR _0557_ sky130_fd_sc_hd__clkbuf_1
X_4329_ u_input_buffer.data_in\[2\] VGND VGND VPWR VPWR _1606_ sky130_fd_sc_hd__buf_4
X_7117_ u_input_buffer.fifo_mem\[17\]\[8\] _2943_ _2945_ u_input_buffer.fifo_mem\[5\]\[8\]
+ VGND VGND VPWR VPWR _3361_ sky130_fd_sc_hd__a22o_1
X_8097_ clknet_leaf_8_clk _0186_ VGND VGND VPWR VPWR u_input_buffer.fifo_mem\[57\]\[7\]
+ sky130_fd_sc_hd__dfxtp_1
X_7048_ u_input_buffer.fifo_mem\[50\]\[6\] _2995_ _2997_ u_input_buffer.fifo_mem\[4\]\[6\]
+ VGND VGND VPWR VPWR _3294_ sky130_fd_sc_hd__a22o_1
Xfanout178 net183 VGND VGND VPWR VPWR net178 sky130_fd_sc_hd__clkbuf_2
Xfanout189 net200 VGND VGND VPWR VPWR net189 sky130_fd_sc_hd__buf_4
XFILLER_0_96_246 VGND VGND VPWR VPWR sky130_fd_sc_hd__decap_6
XTAP_1114 VGND VPWR sky130_fd_sc_hd__tapvpwrvgnd_1
XTAP_1103 VGND VPWR sky130_fd_sc_hd__tapvpwrvgnd_1
X_8999_ clknet_leaf_108_clk _1088_ VGND VGND VPWR VPWR u_input_buffer.fifo_mem\[1\]\[13\]
+ sky130_fd_sc_hd__dfxtp_1
XTAP_1147 VGND VPWR sky130_fd_sc_hd__tapvpwrvgnd_1
XTAP_1136 VGND VPWR sky130_fd_sc_hd__tapvpwrvgnd_1
XTAP_1125 VGND VPWR sky130_fd_sc_hd__tapvpwrvgnd_1
XTAP_1169 VGND VPWR sky130_fd_sc_hd__tapvpwrvgnd_1
XTAP_1158 VGND VPWR sky130_fd_sc_hd__tapvpwrvgnd_1
XFILLER_0_92_452 VGND VGND VPWR VPWR sky130_fd_sc_hd__fill_2
XFILLER_0_100_29 VPWR VGND VPWR VGND sky130_ef_sc_hd__decap_12
XFILLER_0_100_18 VGND VGND VPWR VPWR sky130_fd_sc_hd__decap_8
XFILLER_0_0_608 VGND VGND VPWR VPWR sky130_fd_sc_hd__decap_8
XFILLER_0_103_473 VGND VGND VPWR VPWR sky130_fd_sc_hd__fill_1
XTAP_909 VGND VPWR sky130_fd_sc_hd__tapvpwrvgnd_1
XFILLER_0_109_27 VPWR VGND VPWR VGND sky130_ef_sc_hd__decap_12
XFILLER_0_87_235 VGND VGND VPWR VPWR sky130_fd_sc_hd__decap_4
XFILLER_0_28_357 VGND VGND VPWR VPWR sky130_fd_sc_hd__decap_6
X_4680_ _1638_ _1774_ VGND VGND VPWR VPWR _1815_ sky130_fd_sc_hd__nor2_4
XFILLER_0_113_237 VGND VGND VPWR VPWR sky130_fd_sc_hd__decap_4
X_6350_ _2733_ VGND VGND VPWR VPWR _0994_ sky130_fd_sc_hd__clkbuf_1
X_5301_ net583 _2002_ _2151_ VGND VGND VPWR VPWR _2158_ sky130_fd_sc_hd__mux2_1
X_6281_ _2696_ VGND VGND VPWR VPWR _0962_ sky130_fd_sc_hd__clkbuf_1
X_5232_ _2121_ VGND VGND VPWR VPWR _0488_ sky130_fd_sc_hd__clkbuf_1
X_8020_ clknet_leaf_87_clk _0109_ VGND VGND VPWR VPWR u_input_buffer.fifo_mem\[62\]\[10\]
+ sky130_fd_sc_hd__dfxtp_1
Xclkbuf_leaf_5_clk clknet_3_1__leaf_clk VGND VGND VPWR VPWR clknet_leaf_5_clk sky130_fd_sc_hd__clkbuf_16
X_5163_ _2084_ VGND VGND VPWR VPWR _0456_ sky130_fd_sc_hd__clkbuf_1
XFILLER_0_45_6 VGND VGND VPWR VPWR sky130_fd_sc_hd__decap_4
XFILLER_0_75_53 VGND VGND VPWR VPWR sky130_fd_sc_hd__decap_3
X_4114_ _1432_ VGND VGND VPWR VPWR _1433_ sky130_fd_sc_hd__buf_2
X_5094_ net952 _2000_ _2042_ VGND VGND VPWR VPWR _2048_ sky130_fd_sc_hd__mux2_1
X_4045_ _1374_ VGND VGND VPWR VPWR _0048_ sky130_fd_sc_hd__clkbuf_1
X_8922_ clknet_leaf_111_clk _1011_ VGND VGND VPWR VPWR u_input_buffer.fifo_mem\[5\]\[0\]
+ sky130_fd_sc_hd__dfxtp_1
XFILLER_0_91_30 VPWR VGND VPWR VGND sky130_ef_sc_hd__decap_12
X_8853_ clknet_leaf_95_clk _0942_ VGND VGND VPWR VPWR u_input_buffer.fifo_mem\[10\]\[11\]
+ sky130_fd_sc_hd__dfxtp_1
X_7804_ net1308 u_analytics_engine.data_in\[12\] _3893_ VGND VGND VPWR VPWR _3900_
+ sky130_fd_sc_hd__mux2_1
XPHY_219 VGND VGND VPWR VPWR sky130_fd_sc_hd__decap_3
XPHY_208 VGND VGND VPWR VPWR sky130_fd_sc_hd__decap_3
X_8784_ clknet_leaf_31_clk _0873_ VGND VGND VPWR VPWR u_input_buffer.fifo_mem\[14\]\[6\]
+ sky130_fd_sc_hd__dfxtp_1
X_5996_ _2543_ VGND VGND VPWR VPWR _0830_ sky130_fd_sc_hd__clkbuf_1
X_7735_ u_register_bank.status_flags\[21\] _3849_ _3843_ u_register_bank.sensor_enable\[21\]
+ VGND VGND VPWR VPWR _3854_ sky130_fd_sc_hd__a22o_1
X_4947_ _1961_ VGND VGND VPWR VPWR _0363_ sky130_fd_sc_hd__clkbuf_1
X_7666_ u_register_bank.window_cfg\[6\] _3772_ _3773_ u_analytics_engine.threshold\[6\]
+ _3799_ VGND VGND VPWR VPWR _3800_ sky130_fd_sc_hd__a221o_1
X_4878_ net640 _1724_ _1911_ VGND VGND VPWR VPWR _1923_ sky130_fd_sc_hd__mux2_1
XFILLER_0_61_135 VGND VGND VPWR VPWR sky130_fd_sc_hd__decap_3
X_6617_ _2872_ _2873_ _2877_ _2876_ VGND VGND VPWR VPWR _2878_ sky130_fd_sc_hd__and4_1
XFILLER_0_15_552 VGND VGND VPWR VPWR sky130_fd_sc_hd__decap_8
X_7597_ net18 u_analytics_engine.threshold\[15\] _3748_ VGND VGND VPWR VPWR _3754_
+ sky130_fd_sc_hd__mux2_1
X_6548_ _2838_ VGND VGND VPWR VPWR _1087_ sky130_fd_sc_hd__clkbuf_1
X_6479_ net850 _1450_ _2788_ VGND VGND VPWR VPWR _2802_ sky130_fd_sc_hd__mux2_1
X_8218_ clknet_leaf_24_clk _0307_ VGND VGND VPWR VPWR u_input_buffer.fifo_mem\[49\]\[0\]
+ sky130_fd_sc_hd__dfxtp_1
X_9198_ clknet_leaf_105_clk _0001_ net184 VGND VGND VPWR VPWR net147 sky130_fd_sc_hd__dfrtp_1
X_8149_ clknet_leaf_101_clk _0238_ VGND VGND VPWR VPWR u_input_buffer.fifo_mem\[54\]\[11\]
+ sky130_fd_sc_hd__dfxtp_1
XFILLER_0_97_555 VGND VGND VPWR VPWR sky130_fd_sc_hd__decap_4
XFILLER_0_84_249 VGND VGND VPWR VPWR sky130_fd_sc_hd__decap_3
XFILLER_0_65_474 VGND VGND VPWR VPWR sky130_fd_sc_hd__decap_4
XFILLER_0_25_316 VGND VGND VPWR VPWR sky130_fd_sc_hd__fill_1
XFILLER_0_92_293 VGND VGND VPWR VPWR sky130_fd_sc_hd__fill_1
XFILLER_0_92_282 VGND VGND VPWR VPWR sky130_fd_sc_hd__fill_2
XFILLER_0_111_39 VPWR VGND VPWR VGND sky130_ef_sc_hd__decap_12
XFILLER_0_80_477 VGND VGND VPWR VPWR sky130_fd_sc_hd__decap_4
XFILLER_0_33_371 VPWR VGND VPWR VGND sky130_ef_sc_hd__decap_12
XFILLER_0_0_405 VPWR VGND VPWR VGND sky130_ef_sc_hd__decap_12
XFILLER_0_0_449 VGND VGND VPWR VPWR sky130_fd_sc_hd__fill_2
XTAP_706 VGND VPWR sky130_fd_sc_hd__tapvpwrvgnd_1
XTAP_728 VGND VPWR sky130_fd_sc_hd__tapvpwrvgnd_1
XTAP_717 VGND VPWR sky130_fd_sc_hd__tapvpwrvgnd_1
XTAP_739 VGND VPWR sky130_fd_sc_hd__tapvpwrvgnd_1
XFILLER_0_75_205 VGND VGND VPWR VPWR sky130_fd_sc_hd__decap_4
XFILLER_0_61_11 VGND VGND VPWR VPWR sky130_fd_sc_hd__fill_1
X_5850_ _2458_ VGND VGND VPWR VPWR _0769_ sky130_fd_sc_hd__clkbuf_1
X_4801_ _1881_ VGND VGND VPWR VPWR _0297_ sky130_fd_sc_hd__clkbuf_1
XFILLER_0_0_69 VGND VGND VPWR VPWR sky130_fd_sc_hd__decap_4
X_5781_ net460 _2272_ _2406_ VGND VGND VPWR VPWR _2422_ sky130_fd_sc_hd__mux2_1
X_4732_ net1089 _1718_ _1836_ VGND VGND VPWR VPWR _1844_ sky130_fd_sc_hd__mux2_1
XFILLER_0_29_666 VGND VGND VPWR VPWR sky130_fd_sc_hd__decap_3
X_7520_ net14 u_register_bank.window_cfg\[11\] _3711_ VGND VGND VPWR VPWR _3713_ sky130_fd_sc_hd__mux2_1
X_4663_ _1806_ VGND VGND VPWR VPWR _0234_ sky130_fd_sc_hd__clkbuf_1
XFILLER_0_83_293 VGND VGND VPWR VPWR sky130_fd_sc_hd__fill_2
XFILLER_0_83_271 VGND VGND VPWR VPWR sky130_fd_sc_hd__fill_1
X_7451_ net414 net103 _1322_ VGND VGND VPWR VPWR _3674_ sky130_fd_sc_hd__mux2_1
XFILLER_0_43_124 VGND VGND VPWR VPWR sky130_fd_sc_hd__fill_1
XFILLER_0_44_658 VGND VGND VPWR VPWR sky130_fd_sc_hd__decap_4
X_6402_ _2761_ VGND VGND VPWR VPWR _1018_ sky130_fd_sc_hd__clkbuf_1
XFILLER_0_114_557 VPWR VGND VPWR VGND sky130_ef_sc_hd__decap_12
X_4594_ _1767_ VGND VGND VPWR VPWR _0204_ sky130_fd_sc_hd__clkbuf_1
Xhold913 u_input_buffer.fifo_mem\[5\]\[12\] VGND VGND VPWR VPWR net1125 sky130_fd_sc_hd__dlygate4sd3_1
Xhold902 u_input_buffer.fifo_mem\[5\]\[8\] VGND VGND VPWR VPWR net1114 sky130_fd_sc_hd__dlygate4sd3_1
X_7382_ _3601_ _3610_ _3619_ VGND VGND VPWR VPWR _3620_ sky130_fd_sc_hd__or3_1
Xhold946 u_input_buffer.fifo_mem\[20\]\[4\] VGND VGND VPWR VPWR net1158 sky130_fd_sc_hd__dlygate4sd3_1
X_6333_ net370 _2512_ _2717_ VGND VGND VPWR VPWR _2725_ sky130_fd_sc_hd__mux2_1
X_9121_ net175 _1209_ net207 VGND VGND VPWR VPWR u_analytics_engine.threshold\[3\]
+ sky130_fd_sc_hd__dfrtp_1
XFILLER_0_12_533 VPWR VGND VPWR VGND sky130_ef_sc_hd__decap_12
Xhold935 u_input_buffer.fifo_mem\[7\]\[10\] VGND VGND VPWR VPWR net1147 sky130_fd_sc_hd__dlygate4sd3_1
Xhold924 u_input_buffer.fifo_mem\[33\]\[8\] VGND VGND VPWR VPWR net1136 sky130_fd_sc_hd__dlygate4sd3_1
X_6264_ _1616_ net893 _2680_ VGND VGND VPWR VPWR _2688_ sky130_fd_sc_hd__mux2_1
Xhold968 u_input_buffer.fifo_mem\[22\]\[13\] VGND VGND VPWR VPWR net1180 sky130_fd_sc_hd__dlygate4sd3_1
Xhold957 u_input_buffer.fifo_mem\[1\]\[5\] VGND VGND VPWR VPWR net1169 sky130_fd_sc_hd__dlygate4sd3_1
X_9052_ clknet_leaf_93_clk _1141_ VGND VGND VPWR VPWR u_analytics_engine.data_in\[15\]
+ sky130_fd_sc_hd__dfxtp_2
Xhold979 u_input_buffer.fifo_mem\[33\]\[4\] VGND VGND VPWR VPWR net1191 sky130_fd_sc_hd__dlygate4sd3_1
XFILLER_0_86_41 VPWR VGND VPWR VGND sky130_ef_sc_hd__decap_12
X_5215_ net827 _2018_ _2096_ VGND VGND VPWR VPWR _2112_ sky130_fd_sc_hd__mux2_1
X_8003_ clknet_leaf_78_clk _0092_ net190 VGND VGND VPWR VPWR u_sample_counter.sample_count\[26\]
+ sky130_fd_sc_hd__dfrtp_1
X_6195_ _2651_ VGND VGND VPWR VPWR _0921_ sky130_fd_sc_hd__clkbuf_1
XFILLER_0_86_85 VGND VGND VPWR VPWR sky130_fd_sc_hd__decap_4
XFILLER_0_43_3 VGND VGND VPWR VPWR sky130_fd_sc_hd__fill_2
X_5146_ _1463_ net929 _2059_ VGND VGND VPWR VPWR _2075_ sky130_fd_sc_hd__mux2_1
X_5077_ _2038_ VGND VGND VPWR VPWR _0416_ sky130_fd_sc_hd__clkbuf_1
X_4028_ _1365_ VGND VGND VPWR VPWR _0040_ sky130_fd_sc_hd__clkbuf_1
X_8905_ clknet_leaf_91_clk _0994_ VGND VGND VPWR VPWR u_input_buffer.fifo_mem\[7\]\[15\]
+ sky130_fd_sc_hd__dfxtp_1
XFILLER_0_79_555 VGND VGND VPWR VPWR sky130_fd_sc_hd__fill_2
X_8836_ clknet_leaf_14_clk _0925_ VGND VGND VPWR VPWR u_input_buffer.fifo_mem\[11\]\[10\]
+ sky130_fd_sc_hd__dfxtp_1
X_8767_ clknet_leaf_34_clk _0856_ VGND VGND VPWR VPWR u_input_buffer.fifo_mem\[15\]\[5\]
+ sky130_fd_sc_hd__dfxtp_1
X_5979_ _1608_ net1168 _2531_ VGND VGND VPWR VPWR _2535_ sky130_fd_sc_hd__mux2_1
XFILLER_0_47_430 VGND VGND VPWR VPWR sky130_fd_sc_hd__fill_2
XFILLER_0_81_219 VGND VGND VPWR VPWR sky130_fd_sc_hd__decap_4
X_7718_ u_register_bank.status_flags\[18\] _3814_ _3808_ u_register_bank.sensor_enable\[18\]
+ VGND VGND VPWR VPWR _3840_ sky130_fd_sc_hd__a22o_1
X_8698_ clknet_leaf_67_clk _0787_ VGND VGND VPWR VPWR u_input_buffer.fifo_mem\[19\]\[0\]
+ sky130_fd_sc_hd__dfxtp_1
XFILLER_0_34_102 VGND VGND VPWR VPWR sky130_fd_sc_hd__fill_2
XFILLER_0_47_496 VGND VGND VPWR VPWR sky130_fd_sc_hd__decap_8
X_7649_ u_register_bank.status_flags\[2\] _3775_ _3778_ u_register_bank.sensor_enable\[2\]
+ VGND VGND VPWR VPWR _3787_ sky130_fd_sc_hd__a22o_1
XFILLER_0_62_477 VGND VGND VPWR VPWR sky130_fd_sc_hd__fill_1
XFILLER_0_105_546 VGND VGND VPWR VPWR sky130_fd_sc_hd__fill_2
XFILLER_0_34_179 VGND VGND VPWR VPWR sky130_fd_sc_hd__fill_1
XFILLER_0_15_393 VGND VGND VPWR VPWR sky130_fd_sc_hd__fill_1
XFILLER_0_30_363 VGND VGND VPWR VPWR sky130_fd_sc_hd__fill_1
XFILLER_0_89_319 VGND VGND VPWR VPWR sky130_fd_sc_hd__fill_1
XFILLER_0_97_352 VGND VGND VPWR VPWR sky130_fd_sc_hd__fill_2
XFILLER_0_15_15 VPWR VGND VPWR VGND sky130_ef_sc_hd__decap_12
XFILLER_0_85_558 VGND VGND VPWR VPWR sky130_fd_sc_hd__fill_2
XFILLER_0_41_617 VGND VGND VPWR VPWR sky130_fd_sc_hd__decap_4
XFILLER_0_40_105 VGND VGND VPWR VPWR sky130_fd_sc_hd__fill_2
XFILLER_0_111_505 VGND VGND VPWR VPWR sky130_fd_sc_hd__fill_1
Xhold209 u_input_buffer.fifo_mem\[16\]\[3\] VGND VGND VPWR VPWR net421 sky130_fd_sc_hd__dlygate4sd3_1
XTAP_503 VGND VPWR sky130_fd_sc_hd__tapvpwrvgnd_1
XTAP_514 VGND VPWR sky130_fd_sc_hd__tapvpwrvgnd_1
XTAP_525 VGND VPWR sky130_fd_sc_hd__tapvpwrvgnd_1
X_5000_ net766 _1988_ _1990_ VGND VGND VPWR VPWR _1991_ sky130_fd_sc_hd__mux2_1
XTAP_536 VGND VPWR sky130_fd_sc_hd__tapvpwrvgnd_1
XTAP_547 VGND VPWR sky130_fd_sc_hd__tapvpwrvgnd_1
XTAP_558 VGND VPWR sky130_fd_sc_hd__tapvpwrvgnd_1
XTAP_569 VGND VPWR sky130_fd_sc_hd__tapvpwrvgnd_1
X_6951_ u_input_buffer.fifo_mem\[63\]\[3\] _2887_ _3076_ u_input_buffer.fifo_mem\[55\]\[3\]
+ _3199_ VGND VGND VPWR VPWR _3200_ sky130_fd_sc_hd__a221o_1
X_5902_ _2486_ VGND VGND VPWR VPWR _0793_ sky130_fd_sc_hd__clkbuf_1
X_6882_ u_input_buffer.fifo_mem\[53\]\[2\] _2934_ _2936_ u_input_buffer.fifo_mem\[57\]\[2\]
+ VGND VGND VPWR VPWR _3132_ sky130_fd_sc_hd__a22o_1
X_8621_ clknet_leaf_65_clk _0710_ VGND VGND VPWR VPWR u_input_buffer.fifo_mem\[24\]\[3\]
+ sky130_fd_sc_hd__dfxtp_1
X_5833_ _1614_ net1094 _2443_ VGND VGND VPWR VPWR _2450_ sky130_fd_sc_hd__mux2_1
XFILLER_0_48_238 VGND VGND VPWR VPWR sky130_fd_sc_hd__decap_3
X_8552_ clknet_leaf_103_clk _0641_ VGND VGND VPWR VPWR u_input_buffer.fifo_mem\[29\]\[14\]
+ sky130_fd_sc_hd__dfxtp_1
X_5764_ _2413_ VGND VGND VPWR VPWR _0728_ sky130_fd_sc_hd__clkbuf_1
X_7503_ net37 u_register_bank.window_cfg\[3\] _3700_ VGND VGND VPWR VPWR _3704_ sky130_fd_sc_hd__mux2_1
X_8483_ clknet_leaf_19_clk _0572_ VGND VGND VPWR VPWR u_input_buffer.fifo_mem\[33\]\[9\]
+ sky130_fd_sc_hd__dfxtp_1
X_4715_ _1658_ _1795_ VGND VGND VPWR VPWR _1834_ sky130_fd_sc_hd__nand2_4
X_5695_ _2376_ VGND VGND VPWR VPWR _0696_ sky130_fd_sc_hd__clkbuf_1
XFILLER_0_114_354 VGND VGND VPWR VPWR sky130_fd_sc_hd__fill_1
X_7434_ _3665_ VGND VGND VPWR VPWR _1146_ sky130_fd_sc_hd__clkbuf_1
X_4646_ _1592_ _1796_ VGND VGND VPWR VPWR _1797_ sky130_fd_sc_hd__nor2_4
XFILLER_0_114_365 VGND VGND VPWR VPWR sky130_fd_sc_hd__fill_2
Xhold710 u_sensor_interface.sensor_array\[0\]\[8\] VGND VGND VPWR VPWR net922 sky130_fd_sc_hd__dlygate4sd3_1
X_4577_ net282 _1706_ _1757_ VGND VGND VPWR VPWR _1759_ sky130_fd_sc_hd__mux2_1
Xhold721 u_input_buffer.fifo_mem\[35\]\[13\] VGND VGND VPWR VPWR net933 sky130_fd_sc_hd__dlygate4sd3_1
X_7365_ u_input_buffer.fifo_mem\[8\]\[14\] _3003_ _3005_ u_input_buffer.fifo_mem\[19\]\[14\]
+ _3602_ VGND VGND VPWR VPWR _3603_ sky130_fd_sc_hd__a221o_1
XFILLER_0_31_127 VGND VGND VPWR VPWR sky130_fd_sc_hd__fill_1
Xhold732 u_input_buffer.fifo_mem\[48\]\[2\] VGND VGND VPWR VPWR net944 sky130_fd_sc_hd__dlygate4sd3_1
Xhold754 u_input_buffer.fifo_mem\[43\]\[13\] VGND VGND VPWR VPWR net966 sky130_fd_sc_hd__dlygate4sd3_1
Xhold743 u_input_buffer.fifo_mem\[21\]\[12\] VGND VGND VPWR VPWR net955 sky130_fd_sc_hd__dlygate4sd3_1
X_9104_ net169 _1192_ net201 VGND VGND VPWR VPWR u_register_bank.window_cfg\[18\]
+ sky130_fd_sc_hd__dfrtp_1
X_6316_ _1775_ _2605_ VGND VGND VPWR VPWR _2715_ sky130_fd_sc_hd__and2_1
Xhold776 u_input_buffer.fifo_mem\[55\]\[4\] VGND VGND VPWR VPWR net988 sky130_fd_sc_hd__dlygate4sd3_1
Xhold787 u_input_buffer.fifo_mem\[26\]\[8\] VGND VGND VPWR VPWR net999 sky130_fd_sc_hd__dlygate4sd3_1
X_7296_ u_input_buffer.fifo_mem\[23\]\[12\] _3045_ _3047_ u_input_buffer.fifo_mem\[20\]\[12\]
+ _3535_ VGND VGND VPWR VPWR _3536_ sky130_fd_sc_hd__a221o_1
Xhold765 u_input_buffer.fifo_mem\[23\]\[10\] VGND VGND VPWR VPWR net977 sky130_fd_sc_hd__dlygate4sd3_1
X_9035_ clknet_leaf_97_clk _1124_ net185 VGND VGND VPWR VPWR u_input_buffer.wr_ptr\[4\]
+ sky130_fd_sc_hd__dfrtp_4
Xhold798 u_input_buffer.fifo_mem\[57\]\[1\] VGND VGND VPWR VPWR net1010 sky130_fd_sc_hd__dlygate4sd3_1
X_6247_ _2678_ VGND VGND VPWR VPWR _0946_ sky130_fd_sc_hd__clkbuf_1
X_6178_ _2641_ VGND VGND VPWR VPWR _0914_ sky130_fd_sc_hd__clkbuf_1
X_5129_ _2066_ VGND VGND VPWR VPWR _0440_ sky130_fd_sc_hd__clkbuf_1
X_8819_ clknet_leaf_19_clk _0908_ VGND VGND VPWR VPWR u_input_buffer.fifo_mem\[12\]\[9\]
+ sky130_fd_sc_hd__dfxtp_1
XFILLER_0_15_190 VGND VGND VPWR VPWR sky130_fd_sc_hd__fill_1
XFILLER_0_50_458 VGND VGND VPWR VPWR sky130_fd_sc_hd__fill_1
XFILLER_0_89_105 VGND VGND VPWR VPWR sky130_fd_sc_hd__decap_6
XFILLER_0_26_14 VGND VGND VPWR VPWR sky130_fd_sc_hd__decap_8
Xhold70 u_input_buffer.fifo_mem\[56\]\[1\] VGND VGND VPWR VPWR net282 sky130_fd_sc_hd__dlygate4sd3_1
Xhold81 u_input_buffer.fifo_mem\[3\]\[8\] VGND VGND VPWR VPWR net293 sky130_fd_sc_hd__dlygate4sd3_1
XFILLER_0_26_25 VGND VGND VPWR VPWR sky130_fd_sc_hd__decap_3
Xhold92 u_input_buffer.fifo_mem\[50\]\[15\] VGND VGND VPWR VPWR net304 sky130_fd_sc_hd__dlygate4sd3_1
XFILLER_0_42_79 VGND VGND VPWR VPWR sky130_fd_sc_hd__decap_4
XFILLER_0_115_118 VGND VGND VPWR VPWR sky130_fd_sc_hd__decap_8
XFILLER_0_109_671 VGND VGND VPWR VPWR sky130_fd_sc_hd__fill_1
XFILLER_0_108_181 VGND VGND VPWR VPWR sky130_fd_sc_hd__decap_3
X_5480_ net441 _2256_ _2244_ VGND VGND VPWR VPWR _2257_ sky130_fd_sc_hd__mux2_1
X_4500_ _1711_ VGND VGND VPWR VPWR _0166_ sky130_fd_sc_hd__clkbuf_1
XFILLER_0_101_3 VPWR VGND VPWR VGND sky130_ef_sc_hd__decap_12
XFILLER_0_77_9 VGND VGND VPWR VPWR sky130_fd_sc_hd__fill_1
X_4431_ net804 _1618_ _1661_ VGND VGND VPWR VPWR _1670_ sky130_fd_sc_hd__mux2_1
XANTENNA_1 _1321_ VGND VGND VPWR VPWR sky130_fd_sc_hd__diode_2
XFILLER_0_1_522 VGND VGND VPWR VPWR sky130_fd_sc_hd__fill_1
X_7150_ u_analytics_engine.data_in\[8\] _2893_ _3392_ _3393_ VGND VGND VPWR VPWR _1134_
+ sky130_fd_sc_hd__a22o_1
X_4362_ u_input_buffer.data_in\[13\] VGND VGND VPWR VPWR _1628_ sky130_fd_sc_hd__clkbuf_4
X_7081_ u_input_buffer.fifo_mem\[14\]\[7\] _2958_ _2961_ u_input_buffer.fifo_mem\[42\]\[7\]
+ VGND VGND VPWR VPWR _3326_ sky130_fd_sc_hd__a22o_1
X_4293_ _1570_ u_analytics_engine.data_in\[3\] VGND VGND VPWR VPWR _1573_ sky130_fd_sc_hd__or2_1
XTAP_322 VGND VPWR sky130_fd_sc_hd__tapvpwrvgnd_1
XTAP_333 VGND VPWR sky130_fd_sc_hd__tapvpwrvgnd_1
XTAP_311 VGND VPWR sky130_fd_sc_hd__tapvpwrvgnd_1
XTAP_300 VGND VPWR sky130_fd_sc_hd__tapvpwrvgnd_1
X_6101_ net575 _2522_ _2586_ VGND VGND VPWR VPWR _2600_ sky130_fd_sc_hd__mux2_1
XTAP_366 VGND VPWR sky130_fd_sc_hd__tapvpwrvgnd_1
XTAP_355 VGND VPWR sky130_fd_sc_hd__tapvpwrvgnd_1
XTAP_344 VGND VPWR sky130_fd_sc_hd__tapvpwrvgnd_1
X_6032_ _2562_ VGND VGND VPWR VPWR _0847_ sky130_fd_sc_hd__clkbuf_1
XTAP_399 VGND VPWR sky130_fd_sc_hd__tapvpwrvgnd_1
XTAP_388 VGND VPWR sky130_fd_sc_hd__tapvpwrvgnd_1
XTAP_377 VGND VPWR sky130_fd_sc_hd__tapvpwrvgnd_1
X_7983_ clknet_leaf_57_clk _0072_ net198 VGND VGND VPWR VPWR u_sample_counter.sample_count\[6\]
+ sky130_fd_sc_hd__dfrtp_1
X_6934_ _3167_ _3169_ _3173_ _3182_ VGND VGND VPWR VPWR _3183_ sky130_fd_sc_hd__or4_2
XPHY_28 VGND VGND VPWR VPWR sky130_fd_sc_hd__decap_3
XPHY_17 VGND VGND VPWR VPWR sky130_fd_sc_hd__decap_3
XPHY_39 VGND VGND VPWR VPWR sky130_fd_sc_hd__decap_3
X_6865_ _3109_ _3111_ _3113_ _3115_ VGND VGND VPWR VPWR _3116_ sky130_fd_sc_hd__or4_1
X_8604_ clknet_leaf_5_clk _0693_ VGND VGND VPWR VPWR u_input_buffer.fifo_mem\[25\]\[2\]
+ sky130_fd_sc_hd__dfxtp_1
X_6796_ _3047_ VGND VGND VPWR VPWR _3048_ sky130_fd_sc_hd__clkbuf_4
X_5816_ _2440_ VGND VGND VPWR VPWR _0753_ sky130_fd_sc_hd__clkbuf_1
XFILLER_0_8_165 VGND VGND VPWR VPWR sky130_fd_sc_hd__decap_6
X_8535_ clknet_leaf_86_clk _0624_ VGND VGND VPWR VPWR u_input_buffer.fifo_mem\[30\]\[13\]
+ sky130_fd_sc_hd__dfxtp_1
X_5747_ _2403_ VGND VGND VPWR VPWR _0721_ sky130_fd_sc_hd__clkbuf_1
X_8466_ clknet_leaf_15_clk _0555_ VGND VGND VPWR VPWR u_input_buffer.fifo_mem\[34\]\[8\]
+ sky130_fd_sc_hd__dfxtp_1
XFILLER_0_115_663 VGND VGND VPWR VPWR sky130_fd_sc_hd__decap_6
X_5678_ net964 _2272_ _2351_ VGND VGND VPWR VPWR _2367_ sky130_fd_sc_hd__mux2_1
X_7417_ u_input_buffer.fifo_mem\[26\]\[15\] _3065_ _3067_ u_input_buffer.fifo_mem\[62\]\[15\]
+ _3653_ VGND VGND VPWR VPWR _3654_ sky130_fd_sc_hd__a221o_1
XFILLER_0_114_195 VGND VGND VPWR VPWR sky130_fd_sc_hd__fill_1
X_8397_ clknet_leaf_68_clk _0486_ VGND VGND VPWR VPWR u_input_buffer.fifo_mem\[38\]\[3\]
+ sky130_fd_sc_hd__dfxtp_1
X_4629_ _1787_ VGND VGND VPWR VPWR _0219_ sky130_fd_sc_hd__clkbuf_1
XFILLER_0_13_661 VGND VGND VPWR VPWR sky130_fd_sc_hd__decap_8
Xhold562 u_input_buffer.fifo_mem\[22\]\[7\] VGND VGND VPWR VPWR net774 sky130_fd_sc_hd__dlygate4sd3_1
Xhold540 u_input_buffer.fifo_mem\[48\]\[1\] VGND VGND VPWR VPWR net752 sky130_fd_sc_hd__dlygate4sd3_1
X_7348_ u_input_buffer.fifo_mem\[37\]\[14\] _2922_ _2925_ u_input_buffer.fifo_mem\[9\]\[14\]
+ VGND VGND VPWR VPWR _3586_ sky130_fd_sc_hd__a22o_1
Xhold551 u_input_buffer.fifo_mem\[42\]\[12\] VGND VGND VPWR VPWR net763 sky130_fd_sc_hd__dlygate4sd3_1
Xhold595 u_input_buffer.fifo_mem\[0\]\[4\] VGND VGND VPWR VPWR net807 sky130_fd_sc_hd__dlygate4sd3_1
Xhold573 u_input_buffer.fifo_mem\[45\]\[2\] VGND VGND VPWR VPWR net785 sky130_fd_sc_hd__dlygate4sd3_1
X_7279_ u_input_buffer.fifo_mem\[34\]\[12\] _2965_ _2968_ u_input_buffer.fifo_mem\[48\]\[12\]
+ _3518_ VGND VGND VPWR VPWR _3519_ sky130_fd_sc_hd__a221o_1
Xhold584 u_input_buffer.fifo_mem\[11\]\[14\] VGND VGND VPWR VPWR net796 sky130_fd_sc_hd__dlygate4sd3_1
X_9018_ clknet_leaf_86_clk _1107_ net189 VGND VGND VPWR VPWR u_input_buffer.count\[0\]
+ sky130_fd_sc_hd__dfrtp_1
XFILLER_0_82_336 VGND VGND VPWR VPWR sky130_fd_sc_hd__fill_2
XFILLER_0_12_27 VGND VGND VPWR VPWR sky130_fd_sc_hd__fill_1
XFILLER_0_63_561 VGND VGND VPWR VPWR sky130_fd_sc_hd__fill_2
XFILLER_0_105_140 VGND VGND VPWR VPWR sky130_fd_sc_hd__fill_2
XFILLER_0_23_447 VGND VGND VPWR VPWR sky130_fd_sc_hd__fill_1
XFILLER_0_50_211 VGND VGND VPWR VPWR sky130_fd_sc_hd__fill_2
XFILLER_0_50_222 VGND VGND VPWR VPWR sky130_fd_sc_hd__decap_4
X_4980_ _1979_ VGND VGND VPWR VPWR _0378_ sky130_fd_sc_hd__clkbuf_1
XFILLER_0_18_219 VGND VGND VPWR VPWR sky130_fd_sc_hd__fill_1
X_6650_ _2873_ _2901_ _2872_ VGND VGND VPWR VPWR _2902_ sky130_fd_sc_hd__or3b_4
XFILLER_0_6_625 VPWR VGND VPWR VGND sky130_ef_sc_hd__decap_12
X_6581_ net562 _1450_ _2842_ VGND VGND VPWR VPWR _2856_ sky130_fd_sc_hd__mux2_1
X_5601_ net680 _2264_ _2314_ VGND VGND VPWR VPWR _2326_ sky130_fd_sc_hd__mux2_1
X_8320_ clknet_leaf_33_clk _0409_ VGND VGND VPWR VPWR u_input_buffer.fifo_mem\[43\]\[6\]
+ sky130_fd_sc_hd__dfxtp_1
XFILLER_0_6_669 VPWR VGND VPWR VGND sky130_ef_sc_hd__decap_12
X_5532_ _2288_ VGND VGND VPWR VPWR _0621_ sky130_fd_sc_hd__clkbuf_1
X_5463_ _2245_ VGND VGND VPWR VPWR _0595_ sky130_fd_sc_hd__clkbuf_1
X_8251_ clknet_leaf_60_clk _0340_ VGND VGND VPWR VPWR u_input_buffer.fifo_mem\[47\]\[1\]
+ sky130_fd_sc_hd__dfxtp_1
XFILLER_0_78_53 VGND VGND VPWR VPWR sky130_fd_sc_hd__decap_8
X_4414_ _1660_ VGND VGND VPWR VPWR _1661_ sky130_fd_sc_hd__clkbuf_4
X_7202_ u_input_buffer.fifo_mem\[2\]\[10\] _2983_ _2985_ u_input_buffer.fifo_mem\[32\]\[10\]
+ VGND VGND VPWR VPWR _3444_ sky130_fd_sc_hd__a22o_1
X_8182_ clknet_leaf_75_clk _0271_ VGND VGND VPWR VPWR u_input_buffer.fifo_mem\[52\]\[12\]
+ sky130_fd_sc_hd__dfxtp_1
X_5394_ _2207_ VGND VGND VPWR VPWR _0564_ sky130_fd_sc_hd__clkbuf_1
X_4345_ net645 _1616_ _1602_ VGND VGND VPWR VPWR _1617_ sky130_fd_sc_hd__mux2_1
X_7133_ u_input_buffer.fifo_mem\[27\]\[8\] _3013_ _3015_ u_input_buffer.fifo_mem\[59\]\[8\]
+ _3376_ VGND VGND VPWR VPWR _3377_ sky130_fd_sc_hd__a221o_1
X_7064_ u_input_buffer.fifo_mem\[10\]\[6\] _3056_ _3058_ u_input_buffer.fifo_mem\[44\]\[6\]
+ _3309_ VGND VGND VPWR VPWR _3310_ sky130_fd_sc_hd__a221o_1
XFILLER_0_94_41 VPWR VGND VPWR VGND sky130_ef_sc_hd__decap_12
X_4276_ _1549_ u_analytics_engine.data_in\[8\] VGND VGND VPWR VPWR _1556_ sky130_fd_sc_hd__nor2_1
X_6015_ net327 _2506_ _2549_ VGND VGND VPWR VPWR _2554_ sky130_fd_sc_hd__mux2_1
XTAP_1329 VGND VPWR sky130_fd_sc_hd__tapvpwrvgnd_1
XTAP_1318 VGND VPWR sky130_fd_sc_hd__tapvpwrvgnd_1
XTAP_1307 VGND VPWR sky130_fd_sc_hd__tapvpwrvgnd_1
X_7966_ clknet_leaf_16_clk _0056_ net193 VGND VGND VPWR VPWR u_input_buffer.data_in\[6\]
+ sky130_fd_sc_hd__dfrtp_1
X_7897_ clknet_leaf_82_clk net232 net187 VGND VGND VPWR VPWR u_register_bank.status_flags\[17\]
+ sky130_fd_sc_hd__dfrtp_1
X_6917_ u_input_buffer.fifo_mem\[21\]\[3\] _2909_ _2913_ u_input_buffer.fifo_mem\[25\]\[3\]
+ VGND VGND VPWR VPWR _3166_ sky130_fd_sc_hd__a22o_1
X_6848_ u_input_buffer.fifo_mem\[36\]\[1\] _2951_ _2955_ u_input_buffer.fifo_mem\[35\]\[1\]
+ _3098_ VGND VGND VPWR VPWR _3099_ sky130_fd_sc_hd__a221o_1
XFILLER_0_76_185 VGND VGND VPWR VPWR sky130_fd_sc_hd__fill_2
XFILLER_0_9_452 VGND VGND VPWR VPWR sky130_fd_sc_hd__decap_8
XFILLER_0_92_645 VPWR VGND VPWR VGND sky130_ef_sc_hd__decap_12
XFILLER_0_91_122 VGND VGND VPWR VPWR sky130_fd_sc_hd__fill_1
X_6779_ _3030_ VGND VGND VPWR VPWR _3031_ sky130_fd_sc_hd__clkbuf_4
X_8518_ clknet_leaf_92_clk _0607_ VGND VGND VPWR VPWR u_input_buffer.fifo_mem\[31\]\[12\]
+ sky130_fd_sc_hd__dfxtp_1
X_8449_ clknet_leaf_32_clk _0538_ VGND VGND VPWR VPWR u_input_buffer.fifo_mem\[35\]\[7\]
+ sky130_fd_sc_hd__dfxtp_1
Xhold381 u_input_buffer.fifo_mem\[24\]\[3\] VGND VGND VPWR VPWR net593 sky130_fd_sc_hd__dlygate4sd3_1
Xhold370 u_input_buffer.fifo_mem\[10\]\[14\] VGND VGND VPWR VPWR net582 sky130_fd_sc_hd__dlygate4sd3_1
Xhold392 u_input_buffer.fifo_mem\[24\]\[4\] VGND VGND VPWR VPWR net604 sky130_fd_sc_hd__dlygate4sd3_1
Xhold1092 u_input_buffer.fifo_mem\[49\]\[1\] VGND VGND VPWR VPWR net1304 sky130_fd_sc_hd__dlygate4sd3_1
Xhold1081 u_input_buffer.count\[2\] VGND VGND VPWR VPWR net1293 sky130_fd_sc_hd__dlygate4sd3_1
Xhold1070 u_input_buffer.fifo_mem\[5\]\[5\] VGND VGND VPWR VPWR net1282 sky130_fd_sc_hd__dlygate4sd3_1
XFILLER_0_95_494 VGND VGND VPWR VPWR sky130_fd_sc_hd__fill_2
XFILLER_0_82_166 VGND VGND VPWR VPWR sky130_fd_sc_hd__decap_6
XFILLER_0_63_391 VGND VGND VPWR VPWR sky130_fd_sc_hd__fill_1
XFILLER_0_3_617 VPWR VGND VPWR VGND sky130_ef_sc_hd__decap_12
XFILLER_0_2_116 VGND VGND VPWR VPWR sky130_fd_sc_hd__decap_6
XFILLER_0_2_138 VGND VGND VPWR VPWR sky130_fd_sc_hd__fill_2
XFILLER_0_51_542 VGND VGND VPWR VPWR sky130_fd_sc_hd__fill_1
X_4130_ _1446_ u_sensor_interface.sensor_array\[2\]\[11\] net112 VGND VGND VPWR VPWR
+ _1447_ sky130_fd_sc_hd__mux2_1
XFILLER_0_48_78 VGND VGND VPWR VPWR sky130_fd_sc_hd__decap_3
X_4061_ _1387_ u_sensor_interface.sensor_array\[3\]\[1\] _1381_ VGND VGND VPWR VPWR
+ _1388_ sky130_fd_sc_hd__mux2_1
XFILLER_0_64_44 VGND VGND VPWR VPWR sky130_fd_sc_hd__fill_1
XFILLER_0_3_69 VPWR VGND VPWR VGND sky130_ef_sc_hd__decap_12
X_7820_ net37 u_register_bank.sensor_enable\[3\] _3905_ VGND VGND VPWR VPWR _3909_
+ sky130_fd_sc_hd__mux2_1
X_7751_ u_register_bank.status_flags\[25\] _3849_ _3843_ u_register_bank.sensor_enable\[25\]
+ VGND VGND VPWR VPWR _3866_ sky130_fd_sc_hd__a22o_1
X_4963_ _1639_ _1969_ VGND VGND VPWR VPWR _1970_ sky130_fd_sc_hd__nand2_4
XFILLER_0_58_174 VGND VGND VPWR VPWR sky130_fd_sc_hd__fill_2
X_7682_ _3698_ VGND VGND VPWR VPWR _3812_ sky130_fd_sc_hd__clkbuf_4
X_6702_ _2896_ _2953_ VGND VGND VPWR VPWR _2954_ sky130_fd_sc_hd__nor2_4
X_6633_ u_input_buffer.wr_ptr\[1\] _1598_ _1637_ VGND VGND VPWR VPWR _2889_ sky130_fd_sc_hd__and3_1
X_4894_ _1930_ _1932_ VGND VGND VPWR VPWR _1933_ sky130_fd_sc_hd__nor2_4
XFILLER_0_104_83 VGND VGND VPWR VPWR sky130_fd_sc_hd__fill_1
XFILLER_0_27_550 VGND VGND VPWR VPWR sky130_fd_sc_hd__fill_2
XFILLER_0_27_561 VGND VGND VPWR VPWR sky130_fd_sc_hd__decap_3
XFILLER_0_73_188 VGND VGND VPWR VPWR sky130_fd_sc_hd__fill_1
X_6564_ _2847_ VGND VGND VPWR VPWR _1094_ sky130_fd_sc_hd__clkbuf_1
XFILLER_0_54_380 VGND VGND VPWR VPWR sky130_fd_sc_hd__decap_3
X_8303_ clknet_leaf_50_clk _0392_ VGND VGND VPWR VPWR u_input_buffer.fifo_mem\[44\]\[5\]
+ sky130_fd_sc_hd__dfxtp_1
X_5515_ net830 _2248_ _2277_ VGND VGND VPWR VPWR _2280_ sky130_fd_sc_hd__mux2_1
XFILLER_0_89_85 VGND VGND VPWR VPWR sky130_fd_sc_hd__decap_6
X_6495_ net546 _1396_ _2807_ VGND VGND VPWR VPWR _2811_ sky130_fd_sc_hd__mux2_1
XFILLER_0_6_488 VPWR VGND VPWR VGND sky130_ef_sc_hd__decap_12
XFILLER_0_42_542 VGND VGND VPWR VPWR sky130_fd_sc_hd__fill_2
XFILLER_0_42_553 VGND VGND VPWR VPWR sky130_fd_sc_hd__decap_3
X_8234_ clknet_leaf_25_clk _0323_ VGND VGND VPWR VPWR u_input_buffer.fifo_mem\[48\]\[0\]
+ sky130_fd_sc_hd__dfxtp_1
XFILLER_0_73_3 VGND VGND VPWR VPWR sky130_fd_sc_hd__decap_6
X_5446_ _2234_ VGND VGND VPWR VPWR _0589_ sky130_fd_sc_hd__clkbuf_1
XFILLER_0_14_277 VGND VGND VPWR VPWR sky130_fd_sc_hd__fill_1
XFILLER_0_14_266 VGND VGND VPWR VPWR sky130_fd_sc_hd__fill_2
X_8165_ clknet_leaf_108_clk _0254_ VGND VGND VPWR VPWR u_input_buffer.fifo_mem\[53\]\[11\]
+ sky130_fd_sc_hd__dfxtp_1
X_5377_ net336 _2010_ _2186_ VGND VGND VPWR VPWR _2198_ sky130_fd_sc_hd__mux2_1
X_4328_ _1605_ VGND VGND VPWR VPWR _0100_ sky130_fd_sc_hd__clkbuf_1
X_7116_ u_input_buffer.fifo_mem\[53\]\[8\] _2934_ _2936_ u_input_buffer.fifo_mem\[57\]\[8\]
+ VGND VGND VPWR VPWR _3360_ sky130_fd_sc_hd__a22o_1
X_8096_ clknet_leaf_8_clk _0185_ VGND VGND VPWR VPWR u_input_buffer.fifo_mem\[57\]\[6\]
+ sky130_fd_sc_hd__dfxtp_1
Xfanout179 net182 VGND VGND VPWR VPWR net179 sky130_fd_sc_hd__buf_2
X_7047_ u_input_buffer.fifo_mem\[12\]\[6\] _2980_ _2982_ u_input_buffer.fifo_mem\[18\]\[6\]
+ _3292_ VGND VGND VPWR VPWR _3293_ sky130_fd_sc_hd__a221o_1
Xfanout168 net171 VGND VGND VPWR VPWR net168 sky130_fd_sc_hd__buf_2
X_4259_ _1533_ u_analytics_engine.data_in\[14\] _1535_ _1538_ VGND VGND VPWR VPWR
+ _1539_ sky130_fd_sc_hd__o211ai_1
XTAP_1104 VGND VPWR sky130_fd_sc_hd__tapvpwrvgnd_1
X_8998_ clknet_leaf_105_clk _1087_ VGND VGND VPWR VPWR u_input_buffer.fifo_mem\[1\]\[12\]
+ sky130_fd_sc_hd__dfxtp_1
XTAP_1137 VGND VPWR sky130_fd_sc_hd__tapvpwrvgnd_1
XTAP_1115 VGND VPWR sky130_fd_sc_hd__tapvpwrvgnd_1
XTAP_1126 VGND VPWR sky130_fd_sc_hd__tapvpwrvgnd_1
X_7949_ clknet_leaf_109_clk _0039_ VGND VGND VPWR VPWR u_sensor_interface.sensor_array\[0\]\[5\]
+ sky130_fd_sc_hd__dfxtp_1
XTAP_1159 VGND VPWR sky130_fd_sc_hd__tapvpwrvgnd_1
XTAP_1148 VGND VPWR sky130_fd_sc_hd__tapvpwrvgnd_1
XFILLER_0_37_358 VGND VGND VPWR VPWR sky130_fd_sc_hd__fill_2
XFILLER_0_107_279 VGND VGND VPWR VPWR sky130_fd_sc_hd__fill_1
XFILLER_0_109_39 VPWR VGND VPWR VGND sky130_ef_sc_hd__decap_12
XFILLER_0_18_15 VPWR VGND VPWR VGND sky130_ef_sc_hd__decap_12
XFILLER_0_87_225 VGND VGND VPWR VPWR sky130_fd_sc_hd__fill_1
XFILLER_0_68_494 VGND VGND VPWR VPWR sky130_fd_sc_hd__fill_1
XFILLER_0_55_111 VGND VGND VPWR VPWR sky130_fd_sc_hd__fill_1
XFILLER_0_71_615 VGND VGND VPWR VPWR sky130_fd_sc_hd__fill_1
XFILLER_0_71_659 VGND VGND VPWR VPWR sky130_fd_sc_hd__fill_1
XFILLER_0_24_542 VGND VGND VPWR VPWR sky130_fd_sc_hd__decap_4
XFILLER_0_24_564 VGND VGND VPWR VPWR sky130_fd_sc_hd__decap_3
X_5300_ _2157_ VGND VGND VPWR VPWR _0520_ sky130_fd_sc_hd__clkbuf_1
XFILLER_0_59_55 VGND VGND VPWR VPWR sky130_fd_sc_hd__fill_1
X_6280_ _1632_ net862 _2679_ VGND VGND VPWR VPWR _2696_ sky130_fd_sc_hd__mux2_1
X_5231_ net718 _2000_ _2115_ VGND VGND VPWR VPWR _2121_ sky130_fd_sc_hd__mux2_1
XFILLER_0_59_99 VGND VGND VPWR VPWR sky130_fd_sc_hd__decap_8
X_5162_ net845 _2000_ _2078_ VGND VGND VPWR VPWR _2084_ sky130_fd_sc_hd__mux2_1
X_5093_ _2047_ VGND VGND VPWR VPWR _0423_ sky130_fd_sc_hd__clkbuf_1
X_4113_ u_input_buffer.data_in\[9\] VGND VGND VPWR VPWR _1432_ sky130_fd_sc_hd__clkbuf_4
X_8921_ clknet_leaf_92_clk _1010_ VGND VGND VPWR VPWR u_input_buffer.fifo_mem\[6\]\[15\]
+ sky130_fd_sc_hd__dfxtp_1
X_4044_ u_sensor_interface.sensor_array\[0\]\[14\] net51 _1367_ VGND VGND VPWR VPWR
+ _1374_ sky130_fd_sc_hd__mux2_1
XFILLER_0_91_42 VPWR VGND VPWR VGND sky130_ef_sc_hd__decap_12
X_8852_ clknet_leaf_70_clk _0941_ VGND VGND VPWR VPWR u_input_buffer.fifo_mem\[10\]\[10\]
+ sky130_fd_sc_hd__dfxtp_1
X_8783_ clknet_leaf_32_clk _0872_ VGND VGND VPWR VPWR u_input_buffer.fifo_mem\[14\]\[5\]
+ sky130_fd_sc_hd__dfxtp_1
X_7803_ _3899_ VGND VGND VPWR VPWR _1281_ sky130_fd_sc_hd__clkbuf_1
XFILLER_0_78_247 VGND VGND VPWR VPWR sky130_fd_sc_hd__fill_1
X_7734_ _3853_ VGND VGND VPWR VPWR _1258_ sky130_fd_sc_hd__clkbuf_1
XPHY_209 VGND VGND VPWR VPWR sky130_fd_sc_hd__decap_3
X_5995_ _1624_ net942 _2530_ VGND VGND VPWR VPWR _2543_ sky130_fd_sc_hd__mux2_1
X_4946_ net550 _1720_ _1952_ VGND VGND VPWR VPWR _1961_ sky130_fd_sc_hd__mux2_1
X_7665_ u_register_bank.status_flags\[6\] _3775_ _3778_ u_register_bank.sensor_enable\[6\]
+ VGND VGND VPWR VPWR _3799_ sky130_fd_sc_hd__a22o_1
X_4877_ _1922_ VGND VGND VPWR VPWR _0332_ sky130_fd_sc_hd__clkbuf_1
XFILLER_0_61_103 VGND VGND VPWR VPWR sky130_fd_sc_hd__fill_1
X_7596_ _3753_ VGND VGND VPWR VPWR _1220_ sky130_fd_sc_hd__clkbuf_1
XFILLER_0_34_339 VGND VGND VPWR VPWR sky130_fd_sc_hd__fill_2
X_6616_ u_input_buffer.rd_ptr\[3\] VGND VGND VPWR VPWR _2877_ sky130_fd_sc_hd__clkbuf_2
X_6547_ _1626_ net1070 _2824_ VGND VGND VPWR VPWR _2838_ sky130_fd_sc_hd__mux2_1
XFILLER_0_104_249 VGND VGND VPWR VPWR sky130_fd_sc_hd__decap_3
X_6478_ _2801_ VGND VGND VPWR VPWR _1054_ sky130_fd_sc_hd__clkbuf_1
X_5429_ net270 _1994_ _2223_ VGND VGND VPWR VPWR _2226_ sky130_fd_sc_hd__mux2_1
X_9197_ clknet_leaf_83_clk _1285_ net200 VGND VGND VPWR VPWR net154 sky130_fd_sc_hd__dfrtp_1
X_8217_ clknet_leaf_98_clk _0306_ VGND VGND VPWR VPWR u_input_buffer.fifo_mem\[50\]\[15\]
+ sky130_fd_sc_hd__dfxtp_1
XFILLER_0_100_455 VGND VGND VPWR VPWR sky130_fd_sc_hd__decap_4
XFILLER_0_10_280 VGND VGND VPWR VPWR sky130_fd_sc_hd__fill_2
X_8148_ clknet_leaf_101_clk _0237_ VGND VGND VPWR VPWR u_input_buffer.fifo_mem\[54\]\[10\]
+ sky130_fd_sc_hd__dfxtp_1
XFILLER_0_10_291 VGND VGND VPWR VPWR sky130_fd_sc_hd__decap_4
X_8079_ clknet_leaf_59_clk _0168_ VGND VGND VPWR VPWR u_input_buffer.fifo_mem\[58\]\[5\]
+ sky130_fd_sc_hd__dfxtp_1
XFILLER_0_97_501 VGND VGND VPWR VPWR sky130_fd_sc_hd__decap_3
XFILLER_0_69_225 VGND VGND VPWR VPWR sky130_fd_sc_hd__decap_3
XFILLER_0_69_214 VGND VGND VPWR VPWR sky130_fd_sc_hd__fill_1
XFILLER_0_97_589 VGND VGND VPWR VPWR sky130_fd_sc_hd__fill_1
XFILLER_0_84_217 VGND VGND VPWR VPWR sky130_fd_sc_hd__fill_1
XFILLER_0_37_111 VGND VGND VPWR VPWR sky130_fd_sc_hd__fill_1
XFILLER_0_108_566 VGND VGND VPWR VPWR sky130_fd_sc_hd__decap_3
XFILLER_0_25_328 VGND VGND VPWR VPWR sky130_fd_sc_hd__decap_8
XFILLER_0_52_125 VGND VGND VPWR VPWR sky130_fd_sc_hd__decap_3
XFILLER_0_20_27 VGND VGND VPWR VPWR sky130_fd_sc_hd__fill_1
XFILLER_0_110_208 VGND VGND VPWR VPWR sky130_fd_sc_hd__decap_3
XFILLER_0_103_260 VPWR VGND VPWR VGND sky130_ef_sc_hd__decap_12
XFILLER_0_0_417 VGND VGND VPWR VPWR sky130_fd_sc_hd__decap_3
XFILLER_0_33_383 VGND VGND VPWR VPWR sky130_fd_sc_hd__decap_4
XFILLER_0_21_567 VGND VGND VPWR VPWR sky130_fd_sc_hd__fill_2
XTAP_707 VGND VPWR sky130_fd_sc_hd__tapvpwrvgnd_1
XTAP_729 VGND VPWR sky130_fd_sc_hd__tapvpwrvgnd_1
XTAP_718 VGND VPWR sky130_fd_sc_hd__tapvpwrvgnd_1
XFILLER_0_88_523 VGND VGND VPWR VPWR sky130_fd_sc_hd__fill_1
XFILLER_0_88_578 VGND VGND VPWR VPWR sky130_fd_sc_hd__fill_1
X_4800_ net615 _1716_ _1874_ VGND VGND VPWR VPWR _1881_ sky130_fd_sc_hd__mux2_1
XFILLER_0_56_431 VGND VGND VPWR VPWR sky130_fd_sc_hd__fill_1
X_5780_ _2421_ VGND VGND VPWR VPWR _0736_ sky130_fd_sc_hd__clkbuf_1
XFILLER_0_28_133 VGND VGND VPWR VPWR sky130_fd_sc_hd__fill_1
X_4731_ _1843_ VGND VGND VPWR VPWR _0265_ sky130_fd_sc_hd__clkbuf_1
XTAP_1490 VGND VPWR sky130_fd_sc_hd__tapvpwrvgnd_1
XFILLER_0_56_475 VGND VGND VPWR VPWR sky130_fd_sc_hd__fill_1
XFILLER_0_28_155 VGND VGND VPWR VPWR sky130_fd_sc_hd__fill_1
X_4662_ net446 _1718_ _1798_ VGND VGND VPWR VPWR _1806_ sky130_fd_sc_hd__mux2_1
X_7450_ _3673_ VGND VGND VPWR VPWR _1154_ sky130_fd_sc_hd__clkbuf_1
XFILLER_0_114_503 VGND VGND VPWR VPWR sky130_fd_sc_hd__decap_6
XFILLER_0_3_211 VGND VGND VPWR VPWR sky130_fd_sc_hd__fill_2
X_6401_ _1616_ net920 _2753_ VGND VGND VPWR VPWR _2761_ sky130_fd_sc_hd__mux2_1
XFILLER_0_114_569 VPWR VGND VPWR VGND sky130_ef_sc_hd__decap_12
XFILLER_0_101_51 VGND VGND VPWR VPWR sky130_fd_sc_hd__decap_4
Xhold903 u_input_buffer.fifo_mem\[41\]\[2\] VGND VGND VPWR VPWR net1115 sky130_fd_sc_hd__dlygate4sd3_1
XFILLER_0_71_478 VGND VGND VPWR VPWR sky130_fd_sc_hd__decap_4
X_9120_ net174 _1208_ net206 VGND VGND VPWR VPWR u_analytics_engine.threshold\[2\]
+ sky130_fd_sc_hd__dfrtp_1
X_4593_ net1025 _1722_ _1757_ VGND VGND VPWR VPWR _1767_ sky130_fd_sc_hd__mux2_1
XFILLER_0_3_222 VGND VGND VPWR VPWR sky130_fd_sc_hd__fill_2
X_7381_ _3612_ _3614_ _3616_ _3618_ VGND VGND VPWR VPWR _3619_ sky130_fd_sc_hd__or4_1
X_6332_ _2724_ VGND VGND VPWR VPWR _0985_ sky130_fd_sc_hd__clkbuf_1
XFILLER_0_12_545 VPWR VGND VPWR VGND sky130_ef_sc_hd__decap_12
Xhold936 u_input_buffer.fifo_mem\[1\]\[10\] VGND VGND VPWR VPWR net1148 sky130_fd_sc_hd__dlygate4sd3_1
XFILLER_0_3_255 VGND VGND VPWR VPWR sky130_fd_sc_hd__decap_4
Xhold925 u_input_buffer.fifo_mem\[28\]\[15\] VGND VGND VPWR VPWR net1137 sky130_fd_sc_hd__dlygate4sd3_1
Xhold914 u_input_buffer.fifo_mem\[5\]\[6\] VGND VGND VPWR VPWR net1126 sky130_fd_sc_hd__dlygate4sd3_1
X_6263_ _2687_ VGND VGND VPWR VPWR _0953_ sky130_fd_sc_hd__clkbuf_1
Xhold947 u_input_buffer.fifo_mem\[62\]\[15\] VGND VGND VPWR VPWR net1159 sky130_fd_sc_hd__dlygate4sd3_1
Xhold969 u_input_buffer.fifo_mem\[33\]\[13\] VGND VGND VPWR VPWR net1181 sky130_fd_sc_hd__dlygate4sd3_1
X_9051_ clknet_leaf_74_clk _1140_ VGND VGND VPWR VPWR u_analytics_engine.data_in\[14\]
+ sky130_fd_sc_hd__dfxtp_1
Xhold958 u_input_buffer.fifo_mem\[12\]\[15\] VGND VGND VPWR VPWR net1170 sky130_fd_sc_hd__dlygate4sd3_1
XFILLER_0_86_53 VPWR VGND VPWR VGND sky130_ef_sc_hd__decap_12
X_5214_ _2111_ VGND VGND VPWR VPWR _0480_ sky130_fd_sc_hd__clkbuf_1
X_8002_ clknet_leaf_78_clk _0091_ net190 VGND VGND VPWR VPWR u_sample_counter.sample_count\[25\]
+ sky130_fd_sc_hd__dfrtp_1
X_6194_ net647 _2510_ _2644_ VGND VGND VPWR VPWR _2651_ sky130_fd_sc_hd__mux2_1
X_5145_ _2074_ VGND VGND VPWR VPWR _0448_ sky130_fd_sc_hd__clkbuf_1
X_5076_ net966 _2016_ _2023_ VGND VGND VPWR VPWR _2038_ sky130_fd_sc_hd__mux2_1
X_4027_ u_sensor_interface.sensor_array\[0\]\[6\] net106 _1356_ VGND VGND VPWR VPWR
+ _1365_ sky130_fd_sc_hd__mux2_1
X_8904_ clknet_leaf_81_clk _0993_ VGND VGND VPWR VPWR u_input_buffer.fifo_mem\[7\]\[14\]
+ sky130_fd_sc_hd__dfxtp_1
XFILLER_0_79_545 VGND VGND VPWR VPWR sky130_fd_sc_hd__fill_1
X_8835_ clknet_leaf_15_clk _0924_ VGND VGND VPWR VPWR u_input_buffer.fifo_mem\[11\]\[9\]
+ sky130_fd_sc_hd__dfxtp_1
X_8766_ clknet_leaf_37_clk _0855_ VGND VGND VPWR VPWR u_input_buffer.fifo_mem\[15\]\[4\]
+ sky130_fd_sc_hd__dfxtp_1
X_5978_ _2534_ VGND VGND VPWR VPWR _0821_ sky130_fd_sc_hd__clkbuf_1
XFILLER_0_47_420 VGND VGND VPWR VPWR sky130_fd_sc_hd__decap_3
XFILLER_0_74_250 VGND VGND VPWR VPWR sky130_fd_sc_hd__fill_2
X_4929_ _1951_ VGND VGND VPWR VPWR _1952_ sky130_fd_sc_hd__buf_4
X_8697_ clknet_leaf_89_clk _0786_ VGND VGND VPWR VPWR u_input_buffer.fifo_mem\[20\]\[15\]
+ sky130_fd_sc_hd__dfxtp_1
X_7717_ _3839_ VGND VGND VPWR VPWR _1255_ sky130_fd_sc_hd__clkbuf_1
X_7648_ _3786_ VGND VGND VPWR VPWR _1239_ sky130_fd_sc_hd__clkbuf_1
XFILLER_0_62_456 VGND VGND VPWR VPWR sky130_fd_sc_hd__decap_8
XFILLER_0_7_561 VGND VGND VPWR VPWR sky130_fd_sc_hd__decap_8
X_7579_ _3744_ VGND VGND VPWR VPWR _1212_ sky130_fd_sc_hd__clkbuf_1
XFILLER_0_106_29 VPWR VGND VPWR VGND sky130_ef_sc_hd__decap_12
XFILLER_0_15_27 VPWR VGND VPWR VGND sky130_ef_sc_hd__decap_12
XFILLER_0_93_592 VGND VGND VPWR VPWR sky130_fd_sc_hd__decap_4
XFILLER_0_38_497 VGND VGND VPWR VPWR sky130_fd_sc_hd__decap_3
XFILLER_0_53_445 VGND VGND VPWR VPWR sky130_fd_sc_hd__decap_3
XFILLER_0_0_225 VGND VGND VPWR VPWR sky130_fd_sc_hd__fill_1
XFILLER_0_21_386 VGND VGND VPWR VPWR sky130_fd_sc_hd__fill_2
XTAP_504 VGND VPWR sky130_fd_sc_hd__tapvpwrvgnd_1
XTAP_515 VGND VPWR sky130_fd_sc_hd__tapvpwrvgnd_1
XTAP_526 VGND VPWR sky130_fd_sc_hd__tapvpwrvgnd_1
XTAP_537 VGND VPWR sky130_fd_sc_hd__tapvpwrvgnd_1
XTAP_548 VGND VPWR sky130_fd_sc_hd__tapvpwrvgnd_1
XTAP_559 VGND VPWR sky130_fd_sc_hd__tapvpwrvgnd_1
XFILLER_0_56_78 VGND VGND VPWR VPWR sky130_fd_sc_hd__decap_6
X_6950_ u_input_buffer.fifo_mem\[54\]\[3\] _3078_ _3080_ u_input_buffer.fifo_mem\[46\]\[3\]
+ VGND VGND VPWR VPWR _3199_ sky130_fd_sc_hd__a22o_1
X_5901_ net860 _2256_ _2479_ VGND VGND VPWR VPWR _2486_ sky130_fd_sc_hd__mux2_1
X_6881_ u_input_buffer.fifo_mem\[41\]\[2\] _2919_ _2921_ u_input_buffer.fifo_mem\[45\]\[2\]
+ _3130_ VGND VGND VPWR VPWR _3131_ sky130_fd_sc_hd__a221o_1
X_8620_ clknet_leaf_60_clk _0709_ VGND VGND VPWR VPWR u_input_buffer.fifo_mem\[24\]\[2\]
+ sky130_fd_sc_hd__dfxtp_1
XFILLER_0_72_88 VGND VGND VPWR VPWR sky130_fd_sc_hd__decap_4
X_5832_ _2449_ VGND VGND VPWR VPWR _0760_ sky130_fd_sc_hd__clkbuf_1
X_5763_ net1046 _2254_ _2407_ VGND VGND VPWR VPWR _2413_ sky130_fd_sc_hd__mux2_1
X_8551_ clknet_leaf_109_clk _0640_ VGND VGND VPWR VPWR u_input_buffer.fifo_mem\[29\]\[13\]
+ sky130_fd_sc_hd__dfxtp_1
XFILLER_0_17_604 VPWR VGND VPWR VGND sky130_ef_sc_hd__decap_12
X_7502_ _3703_ VGND VGND VPWR VPWR _1176_ sky130_fd_sc_hd__clkbuf_1
X_4714_ _1833_ VGND VGND VPWR VPWR _0258_ sky130_fd_sc_hd__clkbuf_1
XFILLER_0_17_626 VGND VGND VPWR VPWR sky130_fd_sc_hd__decap_3
XFILLER_0_114_300 VGND VGND VPWR VPWR sky130_fd_sc_hd__decap_8
X_5694_ _1612_ net1184 _2370_ VGND VGND VPWR VPWR _2376_ sky130_fd_sc_hd__mux2_1
X_8482_ clknet_leaf_7_clk _0571_ VGND VGND VPWR VPWR u_input_buffer.fifo_mem\[33\]\[8\]
+ sky130_fd_sc_hd__dfxtp_1
XFILLER_0_112_83 VGND VGND VPWR VPWR sky130_fd_sc_hd__fill_1
XFILLER_0_71_275 VGND VGND VPWR VPWR sky130_fd_sc_hd__fill_2
X_7433_ u_sensor_interface.sensor_array\[3\]\[4\] net93 _3662_ VGND VGND VPWR VPWR
+ _3665_ sky130_fd_sc_hd__mux2_1
X_4645_ _1596_ _1795_ VGND VGND VPWR VPWR _1796_ sky130_fd_sc_hd__nand2_4
X_4576_ _1758_ VGND VGND VPWR VPWR _0195_ sky130_fd_sc_hd__clkbuf_1
Xhold700 u_input_buffer.fifo_mem\[47\]\[2\] VGND VGND VPWR VPWR net912 sky130_fd_sc_hd__dlygate4sd3_1
Xhold711 u_input_buffer.fifo_mem\[29\]\[15\] VGND VGND VPWR VPWR net923 sky130_fd_sc_hd__dlygate4sd3_1
X_7364_ u_input_buffer.fifo_mem\[47\]\[14\] _2879_ _2917_ _3008_ u_input_buffer.fifo_mem\[24\]\[14\]
+ VGND VGND VPWR VPWR _3602_ sky130_fd_sc_hd__a32o_1
XFILLER_0_114_388 VGND VGND VPWR VPWR sky130_fd_sc_hd__decap_6
Xhold722 u_input_buffer.fifo_mem\[14\]\[2\] VGND VGND VPWR VPWR net934 sky130_fd_sc_hd__dlygate4sd3_1
Xhold744 u_input_buffer.fifo_mem\[62\]\[6\] VGND VGND VPWR VPWR net956 sky130_fd_sc_hd__dlygate4sd3_1
X_9103_ net168 _1191_ net201 VGND VGND VPWR VPWR u_register_bank.window_cfg\[17\]
+ sky130_fd_sc_hd__dfrtp_1
X_6315_ _2714_ VGND VGND VPWR VPWR _0978_ sky130_fd_sc_hd__clkbuf_1
Xhold755 u_input_buffer.fifo_mem\[57\]\[0\] VGND VGND VPWR VPWR net967 sky130_fd_sc_hd__dlygate4sd3_1
Xhold733 u_input_buffer.fifo_mem\[33\]\[7\] VGND VGND VPWR VPWR net945 sky130_fd_sc_hd__dlygate4sd3_1
Xhold766 u_input_buffer.fifo_mem\[26\]\[3\] VGND VGND VPWR VPWR net978 sky130_fd_sc_hd__dlygate4sd3_1
Xhold777 u_input_buffer.fifo_mem\[25\]\[12\] VGND VGND VPWR VPWR net989 sky130_fd_sc_hd__dlygate4sd3_1
X_9034_ clknet_leaf_97_clk _1123_ net185 VGND VGND VPWR VPWR u_input_buffer.wr_ptr\[3\]
+ sky130_fd_sc_hd__dfrtp_1
X_7295_ u_input_buffer.fifo_mem\[39\]\[12\] _3049_ _3051_ u_input_buffer.fifo_mem\[40\]\[12\]
+ VGND VGND VPWR VPWR _3535_ sky130_fd_sc_hd__a22o_1
Xhold788 u_input_buffer.fifo_mem\[47\]\[14\] VGND VGND VPWR VPWR net1000 sky130_fd_sc_hd__dlygate4sd3_1
Xhold799 u_input_buffer.fifo_mem\[46\]\[13\] VGND VGND VPWR VPWR net1011 sky130_fd_sc_hd__dlygate4sd3_1
X_6246_ net1189 _2528_ _2661_ VGND VGND VPWR VPWR _2678_ sky130_fd_sc_hd__mux2_1
X_6177_ net1170 _2528_ _2624_ VGND VGND VPWR VPWR _2641_ sky130_fd_sc_hd__mux2_1
X_5128_ _1409_ net1226 _2060_ VGND VGND VPWR VPWR _2066_ sky130_fd_sc_hd__mux2_1
X_5059_ _2029_ VGND VGND VPWR VPWR _0407_ sky130_fd_sc_hd__clkbuf_1
X_8818_ clknet_leaf_16_clk _0907_ VGND VGND VPWR VPWR u_input_buffer.fifo_mem\[12\]\[8\]
+ sky130_fd_sc_hd__dfxtp_1
XFILLER_0_39_228 VGND VGND VPWR VPWR sky130_fd_sc_hd__fill_2
X_8749_ clknet_leaf_18_clk _0838_ VGND VGND VPWR VPWR u_input_buffer.fifo_mem\[16\]\[3\]
+ sky130_fd_sc_hd__dfxtp_1
XFILLER_0_7_391 VGND VGND VPWR VPWR sky130_fd_sc_hd__fill_1
XFILLER_0_105_366 VGND VGND VPWR VPWR sky130_fd_sc_hd__decap_4
XFILLER_0_15_180 VGND VGND VPWR VPWR sky130_fd_sc_hd__fill_2
Xhold82 u_input_buffer.fifo_mem\[15\]\[6\] VGND VGND VPWR VPWR net294 sky130_fd_sc_hd__dlygate4sd3_1
Xhold60 u_input_buffer.fifo_mem\[18\]\[14\] VGND VGND VPWR VPWR net272 sky130_fd_sc_hd__dlygate4sd3_1
Xhold71 u_input_buffer.fifo_mem\[36\]\[15\] VGND VGND VPWR VPWR net283 sky130_fd_sc_hd__dlygate4sd3_1
Xhold93 u_input_buffer.fifo_mem\[43\]\[6\] VGND VGND VPWR VPWR net305 sky130_fd_sc_hd__dlygate4sd3_1
XFILLER_0_58_559 VGND VGND VPWR VPWR sky130_fd_sc_hd__fill_2
XFILLER_0_26_489 VGND VGND VPWR VPWR sky130_fd_sc_hd__fill_1
X_4430_ _1669_ VGND VGND VPWR VPWR _0138_ sky130_fd_sc_hd__clkbuf_1
XANTENNA_2 _1724_ VGND VGND VPWR VPWR sky130_fd_sc_hd__diode_2
XFILLER_0_6_47 VGND VGND VPWR VPWR sky130_fd_sc_hd__decap_4
X_4361_ _1627_ VGND VGND VPWR VPWR _0111_ sky130_fd_sc_hd__clkbuf_1
X_6100_ _2599_ VGND VGND VPWR VPWR _0878_ sky130_fd_sc_hd__clkbuf_1
XFILLER_0_67_44 VGND VGND VPWR VPWR sky130_fd_sc_hd__fill_2
X_4292_ _1570_ u_analytics_engine.data_in\[3\] u_analytics_engine.data_in\[2\] _1571_
+ VGND VGND VPWR VPWR _1572_ sky130_fd_sc_hd__a22o_1
XTAP_323 VGND VPWR sky130_fd_sc_hd__tapvpwrvgnd_1
XFILLER_0_6_69 VGND VGND VPWR VPWR sky130_fd_sc_hd__fill_2
XTAP_312 VGND VPWR sky130_fd_sc_hd__tapvpwrvgnd_1
XTAP_301 VGND VPWR sky130_fd_sc_hd__tapvpwrvgnd_1
X_7080_ u_input_buffer.fifo_mem\[1\]\[7\] _2932_ _3322_ _3324_ VGND VGND VPWR VPWR
+ _3325_ sky130_fd_sc_hd__a211o_1
XTAP_367 VGND VPWR sky130_fd_sc_hd__tapvpwrvgnd_1
XTAP_356 VGND VPWR sky130_fd_sc_hd__tapvpwrvgnd_1
XTAP_345 VGND VPWR sky130_fd_sc_hd__tapvpwrvgnd_1
XTAP_334 VGND VPWR sky130_fd_sc_hd__tapvpwrvgnd_1
X_6031_ net339 _2522_ _2548_ VGND VGND VPWR VPWR _2562_ sky130_fd_sc_hd__mux2_1
XTAP_389 VGND VPWR sky130_fd_sc_hd__tapvpwrvgnd_1
XTAP_378 VGND VPWR sky130_fd_sc_hd__tapvpwrvgnd_1
X_7982_ clknet_leaf_57_clk _0071_ net198 VGND VGND VPWR VPWR u_sample_counter.sample_count\[5\]
+ sky130_fd_sc_hd__dfrtp_1
X_6933_ _3175_ _3177_ _3179_ _3181_ VGND VGND VPWR VPWR _3182_ sky130_fd_sc_hd__or4_1
XPHY_18 VGND VGND VPWR VPWR sky130_fd_sc_hd__decap_3
XPHY_29 VGND VGND VPWR VPWR sky130_fd_sc_hd__decap_3
X_6864_ u_input_buffer.fifo_mem\[6\]\[1\] _3035_ _3037_ u_input_buffer.fifo_mem\[28\]\[1\]
+ _3114_ VGND VGND VPWR VPWR _3115_ sky130_fd_sc_hd__a221o_1
X_5815_ net266 _2272_ _2424_ VGND VGND VPWR VPWR _2440_ sky130_fd_sc_hd__mux2_1
X_8603_ clknet_leaf_5_clk _0692_ VGND VGND VPWR VPWR u_input_buffer.fifo_mem\[25\]\[1\]
+ sky130_fd_sc_hd__dfxtp_1
XFILLER_0_91_337 VGND VGND VPWR VPWR sky130_fd_sc_hd__decap_8
X_6795_ _2906_ _2949_ VGND VGND VPWR VPWR _3047_ sky130_fd_sc_hd__nor2_4
X_8534_ clknet_leaf_85_clk _0623_ VGND VGND VPWR VPWR u_input_buffer.fifo_mem\[30\]\[12\]
+ sky130_fd_sc_hd__dfxtp_1
X_5746_ net429 _2272_ _2387_ VGND VGND VPWR VPWR _2403_ sky130_fd_sc_hd__mux2_1
X_8465_ clknet_leaf_17_clk _0554_ VGND VGND VPWR VPWR u_input_buffer.fifo_mem\[34\]\[7\]
+ sky130_fd_sc_hd__dfxtp_1
X_5677_ _2366_ VGND VGND VPWR VPWR _0688_ sky130_fd_sc_hd__clkbuf_1
XFILLER_0_44_253 VGND VGND VPWR VPWR sky130_fd_sc_hd__decap_3
XFILLER_0_114_141 VPWR VGND VPWR VGND sky130_ef_sc_hd__decap_12
X_4628_ net701 _1720_ _1778_ VGND VGND VPWR VPWR _1787_ sky130_fd_sc_hd__mux2_1
X_7416_ u_input_buffer.fifo_mem\[3\]\[15\] _3069_ _3071_ u_input_buffer.fifo_mem\[60\]\[15\]
+ VGND VGND VPWR VPWR _3653_ sky130_fd_sc_hd__a22o_1
X_8396_ clknet_leaf_46_clk _0485_ VGND VGND VPWR VPWR u_input_buffer.fifo_mem\[38\]\[2\]
+ sky130_fd_sc_hd__dfxtp_1
Xhold530 u_input_buffer.fifo_mem\[19\]\[10\] VGND VGND VPWR VPWR net742 sky130_fd_sc_hd__dlygate4sd3_1
Xhold541 u_input_buffer.fifo_mem\[39\]\[7\] VGND VGND VPWR VPWR net753 sky130_fd_sc_hd__dlygate4sd3_1
Xhold552 u_input_buffer.fifo_mem\[50\]\[0\] VGND VGND VPWR VPWR net764 sky130_fd_sc_hd__dlygate4sd3_1
XFILLER_0_12_150 VGND VGND VPWR VPWR sky130_fd_sc_hd__fill_1
XFILLER_0_13_673 VPWR VGND VPWR VGND sky130_ef_sc_hd__decap_12
X_7347_ u_input_buffer.fifo_mem\[33\]\[14\] _2897_ _2903_ u_input_buffer.fifo_mem\[61\]\[14\]
+ _3584_ VGND VGND VPWR VPWR _3585_ sky130_fd_sc_hd__a221o_1
X_4559_ _1748_ VGND VGND VPWR VPWR _0188_ sky130_fd_sc_hd__clkbuf_1
Xhold563 u_input_buffer.fifo_mem\[0\]\[10\] VGND VGND VPWR VPWR net775 sky130_fd_sc_hd__dlygate4sd3_1
Xhold596 u_input_buffer.fifo_mem\[39\]\[0\] VGND VGND VPWR VPWR net808 sky130_fd_sc_hd__dlygate4sd3_1
Xhold585 u_input_buffer.fifo_mem\[2\]\[1\] VGND VGND VPWR VPWR net797 sky130_fd_sc_hd__dlygate4sd3_1
X_7278_ u_input_buffer.fifo_mem\[16\]\[12\] _2970_ _2972_ u_input_buffer.fifo_mem\[49\]\[12\]
+ _2974_ VGND VGND VPWR VPWR _3518_ sky130_fd_sc_hd__a221o_1
Xhold574 u_input_buffer.fifo_mem\[35\]\[12\] VGND VGND VPWR VPWR net786 sky130_fd_sc_hd__dlygate4sd3_1
X_6229_ _2669_ VGND VGND VPWR VPWR _0937_ sky130_fd_sc_hd__clkbuf_1
X_9017_ clknet_leaf_94_clk _1106_ VGND VGND VPWR VPWR u_input_buffer.fifo_mem\[0\]\[15\]
+ sky130_fd_sc_hd__dfxtp_1
XTAP_890 VGND VPWR sky130_fd_sc_hd__tapvpwrvgnd_1
XFILLER_0_48_581 VGND VGND VPWR VPWR sky130_fd_sc_hd__fill_1
XFILLER_0_94_197 VGND VGND VPWR VPWR sky130_fd_sc_hd__decap_4
XFILLER_0_106_642 VGND VGND VPWR VPWR sky130_fd_sc_hd__fill_2
XFILLER_0_2_309 VGND VGND VPWR VPWR sky130_fd_sc_hd__decap_4
XFILLER_0_53_57 VGND VGND VPWR VPWR sky130_fd_sc_hd__decap_3
XFILLER_0_18_209 VGND VGND VPWR VPWR sky130_fd_sc_hd__fill_1
X_5600_ _2325_ VGND VGND VPWR VPWR _0652_ sky130_fd_sc_hd__clkbuf_1
X_6580_ _2855_ VGND VGND VPWR VPWR _1102_ sky130_fd_sc_hd__clkbuf_1
XFILLER_0_14_404 VGND VGND VPWR VPWR sky130_fd_sc_hd__fill_1
XFILLER_0_6_637 VGND VGND VPWR VPWR sky130_fd_sc_hd__decap_6
X_5531_ net919 _2264_ _2276_ VGND VGND VPWR VPWR _2288_ sky130_fd_sc_hd__mux2_1
X_8250_ clknet_leaf_59_clk _0339_ VGND VGND VPWR VPWR u_input_buffer.fifo_mem\[47\]\[0\]
+ sky130_fd_sc_hd__dfxtp_1
XFILLER_0_81_370 VGND VGND VPWR VPWR sky130_fd_sc_hd__decap_4
XFILLER_0_5_158 VGND VGND VPWR VPWR sky130_fd_sc_hd__fill_2
XFILLER_0_111_111 VGND VGND VPWR VPWR sky130_fd_sc_hd__fill_1
X_5462_ net639 _2240_ _2244_ VGND VGND VPWR VPWR _2245_ sky130_fd_sc_hd__mux2_1
XFILLER_0_78_21 VGND VGND VPWR VPWR sky130_fd_sc_hd__decap_6
XFILLER_0_14_459 VPWR VGND VPWR VGND sky130_ef_sc_hd__decap_12
X_7201_ u_input_buffer.fifo_mem\[34\]\[10\] _2965_ _2968_ u_input_buffer.fifo_mem\[48\]\[10\]
+ _3442_ VGND VGND VPWR VPWR _3443_ sky130_fd_sc_hd__a221o_1
XFILLER_0_112_645 VPWR VGND VPWR VGND sky130_ef_sc_hd__decap_12
XFILLER_0_41_278 VGND VGND VPWR VPWR sky130_fd_sc_hd__fill_2
X_8181_ clknet_leaf_75_clk _0270_ VGND VGND VPWR VPWR u_input_buffer.fifo_mem\[52\]\[11\]
+ sky130_fd_sc_hd__dfxtp_1
X_4413_ _1592_ _1659_ VGND VGND VPWR VPWR _1660_ sky130_fd_sc_hd__nor2_4
X_5393_ _1385_ net1178 _2205_ VGND VGND VPWR VPWR _2207_ sky130_fd_sc_hd__mux2_1
X_4344_ u_input_buffer.data_in\[7\] VGND VGND VPWR VPWR _1616_ sky130_fd_sc_hd__clkbuf_4
X_7132_ u_input_buffer.fifo_mem\[31\]\[8\] _3017_ _3020_ u_input_buffer.fifo_mem\[38\]\[8\]
+ VGND VGND VPWR VPWR _3376_ sky130_fd_sc_hd__a22o_1
XFILLER_0_10_643 VGND VGND VPWR VPWR sky130_fd_sc_hd__fill_1
XFILLER_0_1_353 VGND VGND VPWR VPWR sky130_fd_sc_hd__fill_1
X_7063_ u_input_buffer.fifo_mem\[15\]\[6\] _3060_ _3062_ u_input_buffer.fifo_mem\[43\]\[6\]
+ VGND VGND VPWR VPWR _3309_ sky130_fd_sc_hd__a22o_1
XFILLER_0_94_53 VPWR VGND VPWR VGND sky130_ef_sc_hd__decap_12
X_6014_ _2553_ VGND VGND VPWR VPWR _0838_ sky130_fd_sc_hd__clkbuf_1
X_4275_ _1548_ VGND VGND VPWR VPWR _1555_ sky130_fd_sc_hd__inv_2
XFILLER_0_96_418 VGND VGND VPWR VPWR sky130_fd_sc_hd__fill_2
XTAP_1319 VGND VPWR sky130_fd_sc_hd__tapvpwrvgnd_1
XTAP_1308 VGND VPWR sky130_fd_sc_hd__tapvpwrvgnd_1
X_7965_ clknet_leaf_23_clk _0055_ net193 VGND VGND VPWR VPWR u_input_buffer.data_in\[5\]
+ sky130_fd_sc_hd__dfrtp_1
X_6916_ u_analytics_engine.data_in\[2\] _2893_ _3164_ _3165_ VGND VGND VPWR VPWR _1128_
+ sky130_fd_sc_hd__a22o_1
X_7896_ clknet_leaf_82_clk net244 net187 VGND VGND VPWR VPWR u_register_bank.status_flags\[16\]
+ sky130_fd_sc_hd__dfrtp_1
X_6847_ u_input_buffer.fifo_mem\[14\]\[1\] _2958_ _2961_ u_input_buffer.fifo_mem\[42\]\[1\]
+ VGND VGND VPWR VPWR _3098_ sky130_fd_sc_hd__a22o_1
X_6778_ _2900_ _2959_ VGND VGND VPWR VPWR _3030_ sky130_fd_sc_hd__nor2_4
X_5729_ _2394_ VGND VGND VPWR VPWR _0712_ sky130_fd_sc_hd__clkbuf_1
X_8517_ clknet_leaf_91_clk _0606_ VGND VGND VPWR VPWR u_input_buffer.fifo_mem\[31\]\[11\]
+ sky130_fd_sc_hd__dfxtp_1
XFILLER_0_115_483 VGND VGND VPWR VPWR sky130_fd_sc_hd__decap_4
XFILLER_0_103_612 VGND VGND VPWR VPWR sky130_fd_sc_hd__decap_4
X_8448_ clknet_leaf_31_clk _0537_ VGND VGND VPWR VPWR u_input_buffer.fifo_mem\[35\]\[6\]
+ sky130_fd_sc_hd__dfxtp_1
Xclkbuf_leaf_111_clk clknet_3_0__leaf_clk VGND VGND VPWR VPWR clknet_leaf_111_clk
+ sky130_fd_sc_hd__clkbuf_16
XFILLER_0_32_245 VGND VGND VPWR VPWR sky130_fd_sc_hd__fill_1
X_8379_ clknet_leaf_50_clk _0468_ VGND VGND VPWR VPWR u_input_buffer.fifo_mem\[39\]\[1\]
+ sky130_fd_sc_hd__dfxtp_1
Xhold371 u_input_buffer.fifo_mem\[36\]\[6\] VGND VGND VPWR VPWR net583 sky130_fd_sc_hd__dlygate4sd3_1
Xhold360 u_input_buffer.fifo_mem\[47\]\[1\] VGND VGND VPWR VPWR net572 sky130_fd_sc_hd__dlygate4sd3_1
Xhold382 u_input_buffer.fifo_mem\[20\]\[9\] VGND VGND VPWR VPWR net594 sky130_fd_sc_hd__dlygate4sd3_1
Xhold393 u_input_buffer.fifo_mem\[6\]\[15\] VGND VGND VPWR VPWR net605 sky130_fd_sc_hd__dlygate4sd3_1
XFILLER_0_99_234 VGND VGND VPWR VPWR sky130_fd_sc_hd__decap_3
Xhold1060 u_input_buffer.fifo_mem\[1\]\[4\] VGND VGND VPWR VPWR net1272 sky130_fd_sc_hd__dlygate4sd3_1
XFILLER_0_99_256 VGND VGND VPWR VPWR sky130_fd_sc_hd__decap_3
Xhold1082 u_input_buffer.fifo_mem\[59\]\[7\] VGND VGND VPWR VPWR net1294 sky130_fd_sc_hd__dlygate4sd3_1
Xhold1093 u_input_buffer.fifo_mem\[49\]\[4\] VGND VGND VPWR VPWR net1305 sky130_fd_sc_hd__dlygate4sd3_1
Xhold1071 u_input_buffer.fifo_mem\[17\]\[4\] VGND VGND VPWR VPWR net1283 sky130_fd_sc_hd__dlygate4sd3_1
XFILLER_0_68_610 VGND VGND VPWR VPWR sky130_fd_sc_hd__fill_2
XFILLER_0_114_29 VPWR VGND VPWR VGND sky130_ef_sc_hd__decap_12
XFILLER_0_114_18 VGND VGND VPWR VPWR sky130_fd_sc_hd__decap_8
XFILLER_0_83_635 VGND VGND VPWR VPWR sky130_fd_sc_hd__decap_8
XFILLER_0_83_602 VPWR VGND VPWR VGND sky130_ef_sc_hd__decap_12
XFILLER_0_55_337 VGND VGND VPWR VPWR sky130_fd_sc_hd__fill_1
XFILLER_0_106_450 VGND VGND VPWR VPWR sky130_fd_sc_hd__decap_3
XFILLER_0_51_521 VGND VGND VPWR VPWR sky130_fd_sc_hd__fill_1
Xclkbuf_leaf_102_clk clknet_3_0__leaf_clk VGND VGND VPWR VPWR clknet_leaf_102_clk
+ sky130_fd_sc_hd__clkbuf_16
XFILLER_0_3_629 VPWR VGND VPWR VGND sky130_ef_sc_hd__decap_12
X_4060_ _1386_ u_sensor_interface.sensor_array\[2\]\[1\] _1379_ VGND VGND VPWR VPWR
+ _1387_ sky130_fd_sc_hd__mux2_1
XFILLER_0_3_15 VPWR VGND VPWR VGND sky130_ef_sc_hd__decap_12
X_4962_ u_input_buffer.wr_ptr\[4\] _1590_ VGND VGND VPWR VPWR _1969_ sky130_fd_sc_hd__nor2_4
X_7750_ _3865_ VGND VGND VPWR VPWR _1262_ sky130_fd_sc_hd__clkbuf_1
X_7681_ _3811_ VGND VGND VPWR VPWR _1247_ sky130_fd_sc_hd__clkbuf_1
XFILLER_0_59_676 VGND VGND VPWR VPWR sky130_fd_sc_hd__decap_6
X_4893_ _1931_ VGND VGND VPWR VPWR _1932_ sky130_fd_sc_hd__buf_4
X_6701_ _2877_ _2876_ _2952_ VGND VGND VPWR VPWR _2953_ sky130_fd_sc_hd__or3_4
XFILLER_0_58_197 VGND VGND VPWR VPWR sky130_fd_sc_hd__decap_3
X_6632_ net255 _1637_ VGND VGND VPWR VPWR _1121_ sky130_fd_sc_hd__xor2_1
XFILLER_0_27_540 VGND VGND VPWR VPWR sky130_fd_sc_hd__fill_1
X_6563_ net452 _1396_ _2843_ VGND VGND VPWR VPWR _2847_ sky130_fd_sc_hd__mux2_1
X_5514_ _2279_ VGND VGND VPWR VPWR _0612_ sky130_fd_sc_hd__clkbuf_1
X_8302_ clknet_leaf_36_clk _0391_ VGND VGND VPWR VPWR u_input_buffer.fifo_mem\[44\]\[4\]
+ sky130_fd_sc_hd__dfxtp_1
X_6494_ _2810_ VGND VGND VPWR VPWR _1061_ sky130_fd_sc_hd__clkbuf_1
XFILLER_0_14_256 VGND VGND VPWR VPWR sky130_fd_sc_hd__fill_2
X_5445_ net679 _2010_ _2222_ VGND VGND VPWR VPWR _2234_ sky130_fd_sc_hd__mux2_1
X_8233_ clknet_leaf_99_clk _0322_ VGND VGND VPWR VPWR u_input_buffer.fifo_mem\[49\]\[15\]
+ sky130_fd_sc_hd__dfxtp_1
XFILLER_0_42_587 VGND VGND VPWR VPWR sky130_fd_sc_hd__fill_1
XFILLER_0_42_598 VGND VGND VPWR VPWR sky130_fd_sc_hd__fill_2
XFILLER_0_112_486 VGND VGND VPWR VPWR sky130_fd_sc_hd__fill_2
X_8164_ clknet_leaf_105_clk _0253_ VGND VGND VPWR VPWR u_input_buffer.fifo_mem\[53\]\[10\]
+ sky130_fd_sc_hd__dfxtp_1
X_5376_ _2197_ VGND VGND VPWR VPWR _0556_ sky130_fd_sc_hd__clkbuf_1
X_7115_ u_input_buffer.fifo_mem\[41\]\[8\] _2919_ _2921_ u_input_buffer.fifo_mem\[45\]\[8\]
+ _3358_ VGND VGND VPWR VPWR _3359_ sky130_fd_sc_hd__a221o_1
X_4327_ net488 _1604_ _1602_ VGND VGND VPWR VPWR _1605_ sky130_fd_sc_hd__mux2_1
X_8095_ clknet_leaf_4_clk _0184_ VGND VGND VPWR VPWR u_input_buffer.fifo_mem\[57\]\[5\]
+ sky130_fd_sc_hd__dfxtp_1
X_7046_ u_input_buffer.fifo_mem\[2\]\[6\] _2984_ _2986_ u_input_buffer.fifo_mem\[32\]\[6\]
+ VGND VGND VPWR VPWR _3292_ sky130_fd_sc_hd__a22o_1
Xfanout169 net171 VGND VGND VPWR VPWR net169 sky130_fd_sc_hd__clkbuf_2
X_4258_ u_analytics_engine.threshold\[13\] _1536_ _1537_ VGND VGND VPWR VPWR _1538_
+ sky130_fd_sc_hd__a21oi_1
X_4189_ _1490_ _1491_ VGND VGND VPWR VPWR _1492_ sky130_fd_sc_hd__and2_1
XTAP_1105 VGND VPWR sky130_fd_sc_hd__tapvpwrvgnd_1
X_8997_ clknet_leaf_108_clk _1086_ VGND VGND VPWR VPWR u_input_buffer.fifo_mem\[1\]\[11\]
+ sky130_fd_sc_hd__dfxtp_1
X_7948_ clknet_leaf_50_clk _0038_ VGND VGND VPWR VPWR u_sensor_interface.sensor_array\[0\]\[4\]
+ sky130_fd_sc_hd__dfxtp_1
XTAP_1138 VGND VPWR sky130_fd_sc_hd__tapvpwrvgnd_1
XTAP_1116 VGND VPWR sky130_fd_sc_hd__tapvpwrvgnd_1
XTAP_1127 VGND VPWR sky130_fd_sc_hd__tapvpwrvgnd_1
XTAP_1149 VGND VPWR sky130_fd_sc_hd__tapvpwrvgnd_1
XFILLER_0_65_657 VGND VGND VPWR VPWR sky130_fd_sc_hd__decap_4
XFILLER_0_9_261 VGND VGND VPWR VPWR sky130_fd_sc_hd__decap_4
XFILLER_0_37_337 VGND VGND VPWR VPWR sky130_fd_sc_hd__fill_2
X_7879_ _3939_ VGND VGND VPWR VPWR _1317_ sky130_fd_sc_hd__clkbuf_1
XFILLER_0_49_186 VGND VGND VPWR VPWR sky130_fd_sc_hd__fill_2
XFILLER_0_107_247 VGND VGND VPWR VPWR sky130_fd_sc_hd__decap_4
XFILLER_0_60_340 VGND VGND VPWR VPWR sky130_fd_sc_hd__fill_2
XFILLER_0_60_362 VGND VGND VPWR VPWR sky130_fd_sc_hd__fill_2
Xhold190 u_input_buffer.fifo_mem\[46\]\[7\] VGND VGND VPWR VPWR net402 sky130_fd_sc_hd__dlygate4sd3_1
XFILLER_0_18_27 VGND VGND VPWR VPWR sky130_fd_sc_hd__fill_1
XFILLER_0_34_59 VGND VGND VPWR VPWR sky130_fd_sc_hd__decap_4
XFILLER_0_55_167 VGND VGND VPWR VPWR sky130_fd_sc_hd__fill_1
XFILLER_0_83_498 VGND VGND VPWR VPWR sky130_fd_sc_hd__decap_6
XFILLER_0_3_404 VGND VGND VPWR VPWR sky130_fd_sc_hd__fill_1
X_5230_ _2120_ VGND VGND VPWR VPWR _0487_ sky130_fd_sc_hd__clkbuf_1
X_5161_ _2083_ VGND VGND VPWR VPWR _0455_ sky130_fd_sc_hd__clkbuf_1
X_5092_ net284 _1998_ _2042_ VGND VGND VPWR VPWR _2047_ sky130_fd_sc_hd__mux2_1
X_4112_ _1431_ VGND VGND VPWR VPWR _0058_ sky130_fd_sc_hd__clkbuf_1
XFILLER_0_75_66 VGND VGND VPWR VPWR sky130_fd_sc_hd__decap_8
X_4043_ _1373_ VGND VGND VPWR VPWR _0047_ sky130_fd_sc_hd__clkbuf_1
X_8920_ clknet_leaf_75_clk _1009_ VGND VGND VPWR VPWR u_input_buffer.fifo_mem\[6\]\[14\]
+ sky130_fd_sc_hd__dfxtp_1
XFILLER_0_75_99 VPWR VGND VPWR VGND sky130_ef_sc_hd__decap_12
X_8851_ clknet_leaf_39_clk _0940_ VGND VGND VPWR VPWR u_input_buffer.fifo_mem\[10\]\[9\]
+ sky130_fd_sc_hd__dfxtp_1
X_8782_ clknet_leaf_29_clk _0871_ VGND VGND VPWR VPWR u_input_buffer.fifo_mem\[14\]\[4\]
+ sky130_fd_sc_hd__dfxtp_1
X_7802_ net150 u_analytics_engine.data_in\[11\] _3893_ VGND VGND VPWR VPWR _3899_
+ sky130_fd_sc_hd__mux2_1
XFILLER_0_91_54 VGND VGND VPWR VPWR sky130_fd_sc_hd__fill_2
X_5994_ _2542_ VGND VGND VPWR VPWR _0829_ sky130_fd_sc_hd__clkbuf_1
X_7733_ _3851_ net126 _3852_ VGND VGND VPWR VPWR _3853_ sky130_fd_sc_hd__mux2_1
X_4945_ _1960_ VGND VGND VPWR VPWR _0362_ sky130_fd_sc_hd__clkbuf_1
XFILLER_0_91_98 VGND VGND VPWR VPWR sky130_fd_sc_hd__decap_3
XFILLER_0_115_83 VGND VGND VPWR VPWR sky130_fd_sc_hd__fill_1
XFILLER_0_46_112 VGND VGND VPWR VPWR sky130_fd_sc_hd__fill_2
X_7664_ _3798_ VGND VGND VPWR VPWR _1243_ sky130_fd_sc_hd__clkbuf_1
X_4876_ net986 _1722_ _1912_ VGND VGND VPWR VPWR _1922_ sky130_fd_sc_hd__mux2_1
XFILLER_0_47_668 VGND VGND VPWR VPWR sky130_fd_sc_hd__fill_1
XFILLER_0_6_253 VGND VGND VPWR VPWR sky130_fd_sc_hd__fill_2
XFILLER_0_6_220 VGND VGND VPWR VPWR sky130_fd_sc_hd__fill_1
X_7595_ net17 u_analytics_engine.threshold\[14\] _3748_ VGND VGND VPWR VPWR _3753_
+ sky130_fd_sc_hd__mux2_1
X_6615_ _2876_ _2874_ VGND VGND VPWR VPWR _1116_ sky130_fd_sc_hd__xor2_1
X_6546_ _2837_ VGND VGND VPWR VPWR _1086_ sky130_fd_sc_hd__clkbuf_1
XFILLER_0_15_532 VGND VGND VPWR VPWR sky130_fd_sc_hd__decap_4
XFILLER_0_104_239 VGND VGND VPWR VPWR sky130_fd_sc_hd__fill_2
XFILLER_0_30_513 VGND VGND VPWR VPWR sky130_fd_sc_hd__decap_8
XFILLER_0_42_362 VGND VGND VPWR VPWR sky130_fd_sc_hd__fill_2
X_6477_ net412 _1444_ _2788_ VGND VGND VPWR VPWR _2801_ sky130_fd_sc_hd__mux2_1
X_5428_ _2225_ VGND VGND VPWR VPWR _0580_ sky130_fd_sc_hd__clkbuf_1
X_8216_ clknet_leaf_98_clk _0305_ VGND VGND VPWR VPWR u_input_buffer.fifo_mem\[50\]\[14\]
+ sky130_fd_sc_hd__dfxtp_1
X_9196_ clknet_leaf_79_clk _1284_ net191 VGND VGND VPWR VPWR net153 sky130_fd_sc_hd__dfrtp_1
XFILLER_0_100_445 VGND VGND VPWR VPWR sky130_fd_sc_hd__fill_1
X_5359_ net307 _1992_ _2187_ VGND VGND VPWR VPWR _2189_ sky130_fd_sc_hd__mux2_1
X_8147_ clknet_leaf_42_clk _0236_ VGND VGND VPWR VPWR u_input_buffer.fifo_mem\[54\]\[9\]
+ sky130_fd_sc_hd__dfxtp_1
X_8078_ clknet_leaf_59_clk _0167_ VGND VGND VPWR VPWR u_input_buffer.fifo_mem\[58\]\[4\]
+ sky130_fd_sc_hd__dfxtp_1
X_7029_ u_input_buffer.fifo_mem\[63\]\[5\] _2887_ _3076_ u_input_buffer.fifo_mem\[55\]\[5\]
+ _3275_ VGND VGND VPWR VPWR _3276_ sky130_fd_sc_hd__a221o_1
XFILLER_0_92_251 VGND VGND VPWR VPWR sky130_fd_sc_hd__fill_1
XFILLER_0_38_668 VGND VGND VPWR VPWR sky130_fd_sc_hd__decap_6
XFILLER_0_53_605 VGND VGND VPWR VPWR sky130_fd_sc_hd__decap_6
XFILLER_0_108_589 VPWR VGND VPWR VGND sky130_ef_sc_hd__decap_12
XFILLER_0_20_17 VGND VGND VPWR VPWR sky130_fd_sc_hd__fill_2
XTAP_708 VGND VPWR sky130_fd_sc_hd__tapvpwrvgnd_1
XTAP_719 VGND VPWR sky130_fd_sc_hd__tapvpwrvgnd_1
XFILLER_0_88_513 VGND VGND VPWR VPWR sky130_fd_sc_hd__fill_1
XFILLER_0_0_16 VGND VGND VPWR VPWR sky130_fd_sc_hd__fill_1
XFILLER_0_56_410 VGND VGND VPWR VPWR sky130_fd_sc_hd__fill_1
X_4730_ net741 _1716_ _1836_ VGND VGND VPWR VPWR _1843_ sky130_fd_sc_hd__mux2_1
XTAP_1491 VGND VPWR sky130_fd_sc_hd__tapvpwrvgnd_1
XTAP_1480 VGND VPWR sky130_fd_sc_hd__tapvpwrvgnd_1
XFILLER_0_8_529 VGND VGND VPWR VPWR sky130_fd_sc_hd__decap_3
XFILLER_0_29_679 VGND VGND VPWR VPWR sky130_fd_sc_hd__fill_1
X_4661_ _1805_ VGND VGND VPWR VPWR _0233_ sky130_fd_sc_hd__clkbuf_1
XFILLER_0_114_526 VGND VGND VPWR VPWR sky130_fd_sc_hd__decap_6
X_7380_ u_input_buffer.fifo_mem\[63\]\[14\] _2886_ _3075_ u_input_buffer.fifo_mem\[55\]\[14\]
+ _3617_ VGND VGND VPWR VPWR _3618_ sky130_fd_sc_hd__a221o_1
X_6400_ _2760_ VGND VGND VPWR VPWR _1017_ sky130_fd_sc_hd__clkbuf_1
X_6331_ net570 _2510_ _2717_ VGND VGND VPWR VPWR _2724_ sky130_fd_sc_hd__mux2_1
X_4592_ _1766_ VGND VGND VPWR VPWR _0203_ sky130_fd_sc_hd__clkbuf_1
XFILLER_0_24_373 VGND VGND VPWR VPWR sky130_fd_sc_hd__decap_4
Xhold904 u_input_buffer.fifo_mem\[19\]\[14\] VGND VGND VPWR VPWR net1116 sky130_fd_sc_hd__dlygate4sd3_1
Xhold937 u_input_buffer.fifo_mem\[35\]\[10\] VGND VGND VPWR VPWR net1149 sky130_fd_sc_hd__dlygate4sd3_1
Xhold926 u_input_buffer.fifo_mem\[46\]\[11\] VGND VGND VPWR VPWR net1138 sky130_fd_sc_hd__dlygate4sd3_1
Xhold915 u_input_buffer.fifo_mem\[13\]\[3\] VGND VGND VPWR VPWR net1127 sky130_fd_sc_hd__dlygate4sd3_1
X_6262_ _1614_ net1128 _2680_ VGND VGND VPWR VPWR _2687_ sky130_fd_sc_hd__mux2_1
XFILLER_0_12_557 VPWR VGND VPWR VGND sky130_ef_sc_hd__decap_12
Xhold948 u_input_buffer.fifo_mem\[49\]\[14\] VGND VGND VPWR VPWR net1160 sky130_fd_sc_hd__dlygate4sd3_1
Xhold959 u_input_buffer.fifo_mem\[38\]\[15\] VGND VGND VPWR VPWR net1171 sky130_fd_sc_hd__dlygate4sd3_1
X_9050_ clknet_leaf_72_clk _1139_ VGND VGND VPWR VPWR u_analytics_engine.data_in\[13\]
+ sky130_fd_sc_hd__dfxtp_2
X_6193_ _2650_ VGND VGND VPWR VPWR _0920_ sky130_fd_sc_hd__clkbuf_1
XFILLER_0_86_65 VPWR VGND VPWR VGND sky130_ef_sc_hd__decap_12
X_8001_ clknet_leaf_78_clk _0090_ net190 VGND VGND VPWR VPWR u_sample_counter.sample_count\[24\]
+ sky130_fd_sc_hd__dfrtp_1
X_5213_ net849 _2016_ _2096_ VGND VGND VPWR VPWR _2111_ sky130_fd_sc_hd__mux2_1
X_5144_ _1457_ net1066 _2059_ VGND VGND VPWR VPWR _2074_ sky130_fd_sc_hd__mux2_1
X_5075_ _2037_ VGND VGND VPWR VPWR _0415_ sky130_fd_sc_hd__clkbuf_1
XFILLER_0_79_502 VGND VGND VPWR VPWR sky130_fd_sc_hd__fill_2
X_4026_ _1364_ VGND VGND VPWR VPWR _0039_ sky130_fd_sc_hd__clkbuf_1
X_8903_ clknet_leaf_85_clk _0992_ VGND VGND VPWR VPWR u_input_buffer.fifo_mem\[7\]\[13\]
+ sky130_fd_sc_hd__dfxtp_1
X_8834_ clknet_leaf_16_clk _0923_ VGND VGND VPWR VPWR u_input_buffer.fifo_mem\[11\]\[8\]
+ sky130_fd_sc_hd__dfxtp_1
XFILLER_0_94_505 VGND VGND VPWR VPWR sky130_fd_sc_hd__fill_1
Xclkbuf_leaf_91_clk clknet_3_2__leaf_clk VGND VGND VPWR VPWR clknet_leaf_91_clk sky130_fd_sc_hd__clkbuf_16
X_8765_ clknet_leaf_40_clk _0854_ VGND VGND VPWR VPWR u_input_buffer.fifo_mem\[15\]\[3\]
+ sky130_fd_sc_hd__dfxtp_1
XFILLER_0_59_281 VGND VGND VPWR VPWR sky130_fd_sc_hd__fill_2
X_5977_ _1606_ net1195 _2531_ VGND VGND VPWR VPWR _2534_ sky130_fd_sc_hd__mux2_1
X_7716_ _3838_ net122 _3817_ VGND VGND VPWR VPWR _3839_ sky130_fd_sc_hd__mux2_1
X_8696_ clknet_leaf_89_clk _0785_ VGND VGND VPWR VPWR u_input_buffer.fifo_mem\[20\]\[14\]
+ sky130_fd_sc_hd__dfxtp_1
X_4928_ _1600_ _1930_ VGND VGND VPWR VPWR _1951_ sky130_fd_sc_hd__nor2_4
X_7647_ _3785_ net125 _3782_ VGND VGND VPWR VPWR _3786_ sky130_fd_sc_hd__mux2_1
X_4859_ _1913_ VGND VGND VPWR VPWR _0323_ sky130_fd_sc_hd__clkbuf_1
XFILLER_0_74_295 VGND VGND VPWR VPWR sky130_fd_sc_hd__fill_2
XFILLER_0_34_159 VGND VGND VPWR VPWR sky130_fd_sc_hd__fill_1
X_7578_ net40 u_analytics_engine.threshold\[6\] _3737_ VGND VGND VPWR VPWR _3744_
+ sky130_fd_sc_hd__mux2_1
Xclkbuf_3_0__f_clk clknet_0_clk VGND VGND VPWR VPWR clknet_3_0__leaf_clk sky130_fd_sc_hd__clkbuf_16
X_6529_ _1608_ net1022 _2825_ VGND VGND VPWR VPWR _2829_ sky130_fd_sc_hd__mux2_1
X_9179_ net181 _1267_ VGND VGND VPWR VPWR net135 sky130_fd_sc_hd__dfxtp_2
XFILLER_0_100_253 VGND VGND VPWR VPWR sky130_fd_sc_hd__decap_4
XFILLER_0_15_39 VPWR VGND VPWR VGND sky130_ef_sc_hd__decap_12
XFILLER_0_97_387 VGND VGND VPWR VPWR sky130_fd_sc_hd__fill_2
XFILLER_0_85_516 VGND VGND VPWR VPWR sky130_fd_sc_hd__decap_4
XFILLER_0_85_505 VGND VGND VPWR VPWR sky130_fd_sc_hd__fill_2
Xclkbuf_leaf_82_clk clknet_3_2__leaf_clk VGND VGND VPWR VPWR clknet_leaf_82_clk sky130_fd_sc_hd__clkbuf_16
XFILLER_0_38_454 VGND VGND VPWR VPWR sky130_fd_sc_hd__fill_2
XFILLER_0_110_9 VPWR VGND VPWR VGND sky130_ef_sc_hd__decap_12
XFILLER_0_41_608 VGND VGND VPWR VPWR sky130_fd_sc_hd__fill_2
Xwire164 net165 VGND VGND VPWR VPWR net164 sky130_fd_sc_hd__buf_1
XFILLER_0_104_581 VGND VGND VPWR VPWR sky130_fd_sc_hd__fill_2
XTAP_505 VGND VPWR sky130_fd_sc_hd__tapvpwrvgnd_1
XTAP_516 VGND VPWR sky130_fd_sc_hd__tapvpwrvgnd_1
XTAP_527 VGND VPWR sky130_fd_sc_hd__tapvpwrvgnd_1
XTAP_538 VGND VPWR sky130_fd_sc_hd__tapvpwrvgnd_1
XTAP_549 VGND VPWR sky130_fd_sc_hd__tapvpwrvgnd_1
XFILLER_0_56_57 VGND VGND VPWR VPWR sky130_fd_sc_hd__decap_4
X_5900_ _2485_ VGND VGND VPWR VPWR _0792_ sky130_fd_sc_hd__clkbuf_1
X_6880_ u_input_buffer.fifo_mem\[37\]\[2\] _2923_ _2926_ u_input_buffer.fifo_mem\[9\]\[2\]
+ VGND VGND VPWR VPWR _3130_ sky130_fd_sc_hd__a22o_1
Xclkbuf_leaf_73_clk clknet_3_3__leaf_clk VGND VGND VPWR VPWR clknet_leaf_73_clk sky130_fd_sc_hd__clkbuf_16
X_5831_ _1612_ net1250 _2443_ VGND VGND VPWR VPWR _2449_ sky130_fd_sc_hd__mux2_1
X_5762_ _2412_ VGND VGND VPWR VPWR _0727_ sky130_fd_sc_hd__clkbuf_1
XFILLER_0_8_337 VGND VGND VPWR VPWR sky130_fd_sc_hd__decap_3
X_8550_ clknet_leaf_109_clk _0639_ VGND VGND VPWR VPWR u_input_buffer.fifo_mem\[29\]\[12\]
+ sky130_fd_sc_hd__dfxtp_1
X_7501_ net34 u_register_bank.window_cfg\[2\] _3700_ VGND VGND VPWR VPWR _3703_ sky130_fd_sc_hd__mux2_1
XFILLER_0_56_251 VGND VGND VPWR VPWR sky130_fd_sc_hd__fill_1
X_4713_ _1469_ net626 _1816_ VGND VGND VPWR VPWR _1833_ sky130_fd_sc_hd__mux2_1
XFILLER_0_17_649 VGND VGND VPWR VPWR sky130_fd_sc_hd__fill_2
X_5693_ _2375_ VGND VGND VPWR VPWR _0695_ sky130_fd_sc_hd__clkbuf_1
X_8481_ clknet_leaf_7_clk _0570_ VGND VGND VPWR VPWR u_input_buffer.fifo_mem\[33\]\[7\]
+ sky130_fd_sc_hd__dfxtp_1
X_7432_ _3664_ VGND VGND VPWR VPWR _1145_ sky130_fd_sc_hd__clkbuf_1
XFILLER_0_25_671 VGND VGND VPWR VPWR sky130_fd_sc_hd__fill_1
X_4644_ _1597_ _1598_ VGND VGND VPWR VPWR _1795_ sky130_fd_sc_hd__and2b_2
X_4575_ net981 _1700_ _1757_ VGND VGND VPWR VPWR _1758_ sky130_fd_sc_hd__mux2_1
XFILLER_0_102_518 VGND VGND VPWR VPWR sky130_fd_sc_hd__decap_3
X_7363_ _3585_ _3587_ _3591_ _3600_ VGND VGND VPWR VPWR _3601_ sky130_fd_sc_hd__or4_1
Xhold712 u_input_buffer.fifo_mem\[31\]\[12\] VGND VGND VPWR VPWR net924 sky130_fd_sc_hd__dlygate4sd3_1
XFILLER_0_40_630 VGND VGND VPWR VPWR sky130_fd_sc_hd__decap_8
Xhold701 u_input_buffer.fifo_mem\[4\]\[13\] VGND VGND VPWR VPWR net913 sky130_fd_sc_hd__dlygate4sd3_1
Xhold745 u_input_buffer.fifo_mem\[44\]\[5\] VGND VGND VPWR VPWR net957 sky130_fd_sc_hd__dlygate4sd3_1
Xhold723 u_input_buffer.fifo_mem\[35\]\[3\] VGND VGND VPWR VPWR net935 sky130_fd_sc_hd__dlygate4sd3_1
XFILLER_0_97_53 VGND VGND VPWR VPWR sky130_fd_sc_hd__decap_3
XFILLER_0_4_587 VGND VGND VPWR VPWR sky130_fd_sc_hd__fill_1
Xhold734 u_input_buffer.fifo_mem\[9\]\[14\] VGND VGND VPWR VPWR net946 sky130_fd_sc_hd__dlygate4sd3_1
X_9102_ net169 _1190_ net201 VGND VGND VPWR VPWR u_register_bank.window_cfg\[16\]
+ sky130_fd_sc_hd__dfrtp_1
X_7294_ _3527_ _3529_ _3531_ _3533_ VGND VGND VPWR VPWR _3534_ sky130_fd_sc_hd__or4_1
X_6314_ net1039 _2528_ _2697_ VGND VGND VPWR VPWR _2714_ sky130_fd_sc_hd__mux2_1
Xhold767 u_input_buffer.fifo_mem\[26\]\[6\] VGND VGND VPWR VPWR net979 sky130_fd_sc_hd__dlygate4sd3_1
Xhold778 u_input_buffer.fifo_mem\[21\]\[10\] VGND VGND VPWR VPWR net990 sky130_fd_sc_hd__dlygate4sd3_1
XFILLER_0_12_365 VGND VGND VPWR VPWR sky130_fd_sc_hd__decap_6
X_9033_ clknet_leaf_100_clk _1122_ net186 VGND VGND VPWR VPWR u_input_buffer.wr_ptr\[2\]
+ sky130_fd_sc_hd__dfrtp_1
Xhold756 u_input_buffer.fifo_mem\[13\]\[4\] VGND VGND VPWR VPWR net968 sky130_fd_sc_hd__dlygate4sd3_1
X_6245_ _2677_ VGND VGND VPWR VPWR _0945_ sky130_fd_sc_hd__clkbuf_1
Xhold789 u_sensor_interface.sensor_array\[3\]\[11\] VGND VGND VPWR VPWR net1001 sky130_fd_sc_hd__dlygate4sd3_1
X_6176_ _2640_ VGND VGND VPWR VPWR _0913_ sky130_fd_sc_hd__clkbuf_1
X_5127_ _2065_ VGND VGND VPWR VPWR _0439_ sky130_fd_sc_hd__clkbuf_1
X_5058_ net478 _1998_ _2024_ VGND VGND VPWR VPWR _2029_ sky130_fd_sc_hd__mux2_1
X_4009_ _1355_ VGND VGND VPWR VPWR _0031_ sky130_fd_sc_hd__clkbuf_1
Xclkbuf_leaf_64_clk clknet_3_6__leaf_clk VGND VGND VPWR VPWR clknet_leaf_64_clk sky130_fd_sc_hd__clkbuf_16
X_8817_ clknet_leaf_38_clk _0906_ VGND VGND VPWR VPWR u_input_buffer.fifo_mem\[12\]\[7\]
+ sky130_fd_sc_hd__dfxtp_1
X_8748_ clknet_leaf_24_clk _0837_ VGND VGND VPWR VPWR u_input_buffer.fifo_mem\[16\]\[2\]
+ sky130_fd_sc_hd__dfxtp_1
XFILLER_0_75_571 VGND VGND VPWR VPWR sky130_fd_sc_hd__decap_3
XFILLER_0_35_402 VGND VGND VPWR VPWR sky130_fd_sc_hd__decap_3
XFILLER_0_90_541 VGND VGND VPWR VPWR sky130_fd_sc_hd__fill_1
XFILLER_0_90_530 VGND VGND VPWR VPWR sky130_fd_sc_hd__fill_2
X_8679_ clknet_leaf_0_clk _0768_ VGND VGND VPWR VPWR u_input_buffer.fifo_mem\[21\]\[13\]
+ sky130_fd_sc_hd__dfxtp_1
XFILLER_0_47_284 VGND VGND VPWR VPWR sky130_fd_sc_hd__decap_3
XFILLER_0_50_438 VGND VGND VPWR VPWR sky130_fd_sc_hd__decap_4
Xhold50 u_input_buffer.fifo_mem\[0\]\[2\] VGND VGND VPWR VPWR net262 sky130_fd_sc_hd__dlygate4sd3_1
Xhold72 u_input_buffer.fifo_mem\[42\]\[4\] VGND VGND VPWR VPWR net284 sky130_fd_sc_hd__dlygate4sd3_1
Xhold83 u_input_buffer.fifo_mem\[22\]\[6\] VGND VGND VPWR VPWR net295 sky130_fd_sc_hd__dlygate4sd3_1
XFILLER_0_89_118 VGND VGND VPWR VPWR sky130_fd_sc_hd__fill_2
Xhold61 u_input_buffer.fifo_mem\[43\]\[10\] VGND VGND VPWR VPWR net273 sky130_fd_sc_hd__dlygate4sd3_1
Xhold94 u_input_buffer.fifo_mem\[15\]\[12\] VGND VGND VPWR VPWR net306 sky130_fd_sc_hd__dlygate4sd3_1
Xclkbuf_leaf_55_clk clknet_3_7__leaf_clk VGND VGND VPWR VPWR clknet_leaf_55_clk sky130_fd_sc_hd__clkbuf_16
XFILLER_0_42_59 VGND VGND VPWR VPWR sky130_fd_sc_hd__fill_1
XFILLER_0_38_251 VGND VGND VPWR VPWR sky130_fd_sc_hd__fill_1
XFILLER_0_38_262 VGND VGND VPWR VPWR sky130_fd_sc_hd__fill_2
XFILLER_0_38_273 VGND VGND VPWR VPWR sky130_fd_sc_hd__fill_1
XFILLER_0_115_109 VGND VGND VPWR VPWR sky130_fd_sc_hd__decap_3
XFILLER_0_109_673 VGND VGND VPWR VPWR sky130_fd_sc_hd__decap_8
XFILLER_0_53_221 VGND VGND VPWR VPWR sky130_fd_sc_hd__decap_3
XFILLER_0_14_619 VPWR VGND VPWR VGND sky130_ef_sc_hd__decap_12
XANTENNA_3 _2912_ VGND VGND VPWR VPWR sky130_fd_sc_hd__diode_2
XFILLER_0_6_15 VPWR VGND VPWR VGND sky130_ef_sc_hd__decap_12
X_4360_ net1183 _1626_ _1601_ VGND VGND VPWR VPWR _1627_ sky130_fd_sc_hd__mux2_1
XFILLER_0_6_37 VGND VGND VPWR VPWR sky130_fd_sc_hd__fill_1
XFILLER_0_21_140 VGND VGND VPWR VPWR sky130_fd_sc_hd__fill_1
X_4291_ u_analytics_engine.threshold\[2\] VGND VGND VPWR VPWR _1571_ sky130_fd_sc_hd__inv_2
XTAP_324 VGND VPWR sky130_fd_sc_hd__tapvpwrvgnd_1
XTAP_313 VGND VPWR sky130_fd_sc_hd__tapvpwrvgnd_1
XTAP_302 VGND VPWR sky130_fd_sc_hd__tapvpwrvgnd_1
XTAP_357 VGND VPWR sky130_fd_sc_hd__tapvpwrvgnd_1
XTAP_346 VGND VPWR sky130_fd_sc_hd__tapvpwrvgnd_1
XTAP_335 VGND VPWR sky130_fd_sc_hd__tapvpwrvgnd_1
X_6030_ _2561_ VGND VGND VPWR VPWR _0846_ sky130_fd_sc_hd__clkbuf_1
XTAP_379 VGND VPWR sky130_fd_sc_hd__tapvpwrvgnd_1
XTAP_368 VGND VPWR sky130_fd_sc_hd__tapvpwrvgnd_1
X_7981_ clknet_leaf_57_clk _0070_ net198 VGND VGND VPWR VPWR u_sample_counter.sample_count\[4\]
+ sky130_fd_sc_hd__dfrtp_1
XFILLER_0_107_51 VGND VGND VPWR VPWR sky130_fd_sc_hd__decap_4
XFILLER_0_83_77 VGND VGND VPWR VPWR sky130_fd_sc_hd__decap_4
Xclkbuf_leaf_46_clk clknet_3_7__leaf_clk VGND VGND VPWR VPWR clknet_leaf_46_clk sky130_fd_sc_hd__clkbuf_16
X_6932_ u_input_buffer.fifo_mem\[51\]\[3\] _2990_ _2993_ u_input_buffer.fifo_mem\[11\]\[3\]
+ _3180_ VGND VGND VPWR VPWR _3181_ sky130_fd_sc_hd__a221o_1
XPHY_19 VGND VGND VPWR VPWR sky130_fd_sc_hd__decap_3
X_6863_ u_input_buffer.fifo_mem\[52\]\[1\] _3039_ _3041_ u_input_buffer.fifo_mem\[56\]\[1\]
+ VGND VGND VPWR VPWR _3114_ sky130_fd_sc_hd__a22o_1
XFILLER_0_76_302 VGND VGND VPWR VPWR sky130_fd_sc_hd__decap_3
XFILLER_0_8_112 VGND VGND VPWR VPWR sky130_fd_sc_hd__fill_1
X_5814_ _2439_ VGND VGND VPWR VPWR _0752_ sky130_fd_sc_hd__clkbuf_1
X_8602_ clknet_leaf_4_clk _0691_ VGND VGND VPWR VPWR u_input_buffer.fifo_mem\[25\]\[0\]
+ sky130_fd_sc_hd__dfxtp_1
X_6794_ _3045_ VGND VGND VPWR VPWR _3046_ sky130_fd_sc_hd__clkbuf_4
XFILLER_0_57_582 VPWR VGND VPWR VGND sky130_ef_sc_hd__decap_12
XFILLER_0_17_402 VGND VGND VPWR VPWR sky130_fd_sc_hd__fill_1
X_8533_ clknet_leaf_81_clk _0622_ VGND VGND VPWR VPWR u_input_buffer.fifo_mem\[30\]\[11\]
+ sky130_fd_sc_hd__dfxtp_1
X_5745_ _2402_ VGND VGND VPWR VPWR _0720_ sky130_fd_sc_hd__clkbuf_1
XFILLER_0_115_643 VGND VGND VPWR VPWR sky130_fd_sc_hd__fill_1
XFILLER_0_115_610 VGND VGND VPWR VPWR sky130_fd_sc_hd__fill_2
XFILLER_0_96_3 VPWR VGND VPWR VGND sky130_ef_sc_hd__decap_12
X_8464_ clknet_leaf_38_clk _0553_ VGND VGND VPWR VPWR u_input_buffer.fifo_mem\[34\]\[6\]
+ sky130_fd_sc_hd__dfxtp_1
X_5676_ net910 _2270_ _2351_ VGND VGND VPWR VPWR _2366_ sky130_fd_sc_hd__mux2_1
XFILLER_0_114_153 VPWR VGND VPWR VGND sky130_ef_sc_hd__decap_12
X_4627_ _1786_ VGND VGND VPWR VPWR _0218_ sky130_fd_sc_hd__clkbuf_1
X_7415_ u_input_buffer.fifo_mem\[10\]\[15\] _3055_ _3057_ u_input_buffer.fifo_mem\[44\]\[15\]
+ _3651_ VGND VGND VPWR VPWR _3652_ sky130_fd_sc_hd__a221o_1
Xhold520 u_input_buffer.fifo_mem\[14\]\[5\] VGND VGND VPWR VPWR net732 sky130_fd_sc_hd__dlygate4sd3_1
X_8395_ clknet_leaf_45_clk _0484_ VGND VGND VPWR VPWR u_input_buffer.fifo_mem\[38\]\[1\]
+ sky130_fd_sc_hd__dfxtp_1
XFILLER_0_114_197 VPWR VGND VPWR VGND sky130_ef_sc_hd__decap_12
XFILLER_0_102_348 VGND VGND VPWR VPWR sky130_fd_sc_hd__decap_4
Xhold553 u_input_buffer.fifo_mem\[60\]\[7\] VGND VGND VPWR VPWR net765 sky130_fd_sc_hd__dlygate4sd3_1
X_7346_ u_input_buffer.fifo_mem\[21\]\[14\] _2908_ _2912_ u_input_buffer.fifo_mem\[25\]\[14\]
+ VGND VGND VPWR VPWR _3584_ sky130_fd_sc_hd__a22o_1
XFILLER_0_13_685 VGND VGND VPWR VPWR sky130_fd_sc_hd__fill_1
Xhold542 u_input_buffer.fifo_mem\[63\]\[15\] VGND VGND VPWR VPWR net754 sky130_fd_sc_hd__dlygate4sd3_1
Xhold531 u_input_buffer.fifo_mem\[46\]\[10\] VGND VGND VPWR VPWR net743 sky130_fd_sc_hd__dlygate4sd3_1
X_4558_ _1433_ net1107 _1738_ VGND VGND VPWR VPWR _1748_ sky130_fd_sc_hd__mux2_1
Xhold564 u_input_buffer.fifo_mem\[56\]\[7\] VGND VGND VPWR VPWR net776 sky130_fd_sc_hd__dlygate4sd3_1
Xhold586 u_input_buffer.fifo_mem\[30\]\[4\] VGND VGND VPWR VPWR net798 sky130_fd_sc_hd__dlygate4sd3_1
Xhold597 u_sensor_interface.sensor_array\[3\]\[14\] VGND VGND VPWR VPWR net809 sky130_fd_sc_hd__dlygate4sd3_1
Xhold575 u_input_buffer.fifo_mem\[11\]\[11\] VGND VGND VPWR VPWR net787 sky130_fd_sc_hd__dlygate4sd3_1
XFILLER_0_40_493 VGND VGND VPWR VPWR sky130_fd_sc_hd__fill_1
X_4489_ _1703_ VGND VGND VPWR VPWR _1704_ sky130_fd_sc_hd__buf_4
X_7277_ u_input_buffer.fifo_mem\[36\]\[12\] _2950_ _2954_ u_input_buffer.fifo_mem\[35\]\[12\]
+ _3516_ VGND VGND VPWR VPWR _3517_ sky130_fd_sc_hd__a221o_1
X_6228_ net833 _2510_ _2662_ VGND VGND VPWR VPWR _2669_ sky130_fd_sc_hd__mux2_1
X_9016_ clknet_leaf_72_clk _1105_ VGND VGND VPWR VPWR u_input_buffer.fifo_mem\[0\]\[14\]
+ sky130_fd_sc_hd__dfxtp_1
X_6159_ net867 _2510_ _2625_ VGND VGND VPWR VPWR _2632_ sky130_fd_sc_hd__mux2_1
XTAP_880 VGND VPWR sky130_fd_sc_hd__tapvpwrvgnd_1
XTAP_891 VGND VPWR sky130_fd_sc_hd__tapvpwrvgnd_1
Xclkbuf_leaf_37_clk clknet_3_5__leaf_clk VGND VGND VPWR VPWR clknet_leaf_37_clk sky130_fd_sc_hd__clkbuf_16
XFILLER_0_67_335 VGND VGND VPWR VPWR sky130_fd_sc_hd__fill_1
XFILLER_0_95_666 VGND VGND VPWR VPWR sky130_fd_sc_hd__decap_3
XFILLER_0_79_195 VGND VGND VPWR VPWR sky130_fd_sc_hd__fill_1
XFILLER_0_67_379 VGND VGND VPWR VPWR sky130_fd_sc_hd__fill_1
XFILLER_0_12_29 VPWR VGND VPWR VGND sky130_ef_sc_hd__decap_12
Xclkbuf_leaf_28_clk clknet_3_5__leaf_clk VGND VGND VPWR VPWR clknet_leaf_28_clk sky130_fd_sc_hd__clkbuf_16
XPHY_190 VGND VGND VPWR VPWR sky130_fd_sc_hd__decap_3
X_5530_ _2287_ VGND VGND VPWR VPWR _0620_ sky130_fd_sc_hd__clkbuf_1
XFILLER_0_81_393 VGND VGND VPWR VPWR sky130_fd_sc_hd__decap_4
X_5461_ _2243_ VGND VGND VPWR VPWR _2244_ sky130_fd_sc_hd__clkbuf_4
XFILLER_0_14_438 VGND VGND VPWR VPWR sky130_fd_sc_hd__fill_2
XFILLER_0_54_585 VGND VGND VPWR VPWR sky130_fd_sc_hd__decap_3
XFILLER_0_78_11 VGND VGND VPWR VPWR sky130_fd_sc_hd__fill_2
X_7200_ u_input_buffer.fifo_mem\[16\]\[10\] _2970_ _2972_ u_input_buffer.fifo_mem\[49\]\[10\]
+ _2974_ VGND VGND VPWR VPWR _3442_ sky130_fd_sc_hd__a221o_1
X_4412_ _1599_ _1658_ VGND VGND VPWR VPWR _1659_ sky130_fd_sc_hd__nand2_4
XFILLER_0_112_657 VPWR VGND VPWR VGND sky130_ef_sc_hd__decap_12
X_5392_ _2206_ VGND VGND VPWR VPWR _0563_ sky130_fd_sc_hd__clkbuf_1
X_8180_ clknet_leaf_72_clk _0269_ VGND VGND VPWR VPWR u_input_buffer.fifo_mem\[52\]\[10\]
+ sky130_fd_sc_hd__dfxtp_1
X_4343_ _1615_ VGND VGND VPWR VPWR _0105_ sky130_fd_sc_hd__clkbuf_1
X_7131_ u_input_buffer.fifo_mem\[8\]\[8\] _3004_ _3006_ u_input_buffer.fifo_mem\[19\]\[8\]
+ _3374_ VGND VGND VPWR VPWR _3375_ sky130_fd_sc_hd__a221o_1
X_7062_ u_input_buffer.fifo_mem\[23\]\[6\] _3046_ _3048_ u_input_buffer.fifo_mem\[20\]\[6\]
+ _3307_ VGND VGND VPWR VPWR _3308_ sky130_fd_sc_hd__a221o_1
X_4274_ _1539_ _1553_ VGND VGND VPWR VPWR _1554_ sky130_fd_sc_hd__or2_1
X_6013_ net421 _2504_ _2549_ VGND VGND VPWR VPWR _2553_ sky130_fd_sc_hd__mux2_1
XFILLER_0_94_65 VPWR VGND VPWR VGND sky130_ef_sc_hd__decap_12
XFILLER_0_27_81 VGND VGND VPWR VPWR sky130_fd_sc_hd__fill_2
XFILLER_0_96_408 VGND VGND VPWR VPWR sky130_fd_sc_hd__fill_1
X_7964_ clknet_leaf_22_clk _0054_ net193 VGND VGND VPWR VPWR u_input_buffer.data_in\[4\]
+ sky130_fd_sc_hd__dfrtp_1
Xclkbuf_leaf_19_clk clknet_3_4__leaf_clk VGND VGND VPWR VPWR clknet_leaf_19_clk sky130_fd_sc_hd__clkbuf_16
XTAP_1309 VGND VPWR sky130_fd_sc_hd__tapvpwrvgnd_1
X_6915_ net262 _3086_ _3088_ VGND VGND VPWR VPWR _3165_ sky130_fd_sc_hd__o21a_1
X_7895_ clknet_leaf_82_clk net223 net187 VGND VGND VPWR VPWR u_register_bank.status_flags\[15\]
+ sky130_fd_sc_hd__dfrtp_1
X_6846_ u_input_buffer.fifo_mem\[1\]\[1\] _2932_ _3094_ _3096_ VGND VGND VPWR VPWR
+ _3097_ sky130_fd_sc_hd__a211o_1
X_6777_ _3028_ VGND VGND VPWR VPWR _3029_ sky130_fd_sc_hd__clkbuf_4
X_5728_ net400 _2254_ _2388_ VGND VGND VPWR VPWR _2394_ sky130_fd_sc_hd__mux2_1
X_3989_ _1322_ VGND VGND VPWR VPWR _1345_ sky130_fd_sc_hd__buf_6
X_8516_ clknet_leaf_72_clk _0605_ VGND VGND VPWR VPWR u_input_buffer.fifo_mem\[31\]\[10\]
+ sky130_fd_sc_hd__dfxtp_1
X_8447_ clknet_leaf_32_clk _0536_ VGND VGND VPWR VPWR u_input_buffer.fifo_mem\[35\]\[5\]
+ sky130_fd_sc_hd__dfxtp_1
XFILLER_0_102_101 VGND VGND VPWR VPWR sky130_fd_sc_hd__fill_1
X_5659_ _2357_ VGND VGND VPWR VPWR _0679_ sky130_fd_sc_hd__clkbuf_1
XFILLER_0_60_566 VGND VGND VPWR VPWR sky130_fd_sc_hd__fill_1
XFILLER_0_5_671 VGND VGND VPWR VPWR sky130_fd_sc_hd__fill_1
X_8378_ clknet_leaf_50_clk _0467_ VGND VGND VPWR VPWR u_input_buffer.fifo_mem\[39\]\[0\]
+ sky130_fd_sc_hd__dfxtp_1
XFILLER_0_20_419 VGND VGND VPWR VPWR sky130_fd_sc_hd__fill_1
XFILLER_0_102_178 VGND VGND VPWR VPWR sky130_fd_sc_hd__fill_1
XFILLER_0_102_156 VGND VGND VPWR VPWR sky130_fd_sc_hd__decap_3
Xhold361 u_input_buffer.fifo_mem\[16\]\[5\] VGND VGND VPWR VPWR net573 sky130_fd_sc_hd__dlygate4sd3_1
X_7329_ u_input_buffer.fifo_mem\[30\]\[13\] _3028_ _3030_ u_input_buffer.fifo_mem\[58\]\[13\]
+ VGND VGND VPWR VPWR _3568_ sky130_fd_sc_hd__a22o_1
Xhold350 u_input_buffer.fifo_mem\[0\]\[12\] VGND VGND VPWR VPWR net562 sky130_fd_sc_hd__dlygate4sd3_1
Xhold383 u_input_buffer.fifo_mem\[20\]\[5\] VGND VGND VPWR VPWR net595 sky130_fd_sc_hd__dlygate4sd3_1
Xhold394 u_input_buffer.fifo_mem\[2\]\[5\] VGND VGND VPWR VPWR net606 sky130_fd_sc_hd__dlygate4sd3_1
Xhold372 u_input_buffer.fifo_mem\[19\]\[11\] VGND VGND VPWR VPWR net584 sky130_fd_sc_hd__dlygate4sd3_1
Xhold1050 u_input_buffer.fifo_mem\[61\]\[0\] VGND VGND VPWR VPWR net1262 sky130_fd_sc_hd__dlygate4sd3_1
Xhold1094 u_input_buffer.fifo_mem\[49\]\[2\] VGND VGND VPWR VPWR net1306 sky130_fd_sc_hd__dlygate4sd3_1
Xhold1061 u_input_buffer.fifo_mem\[37\]\[1\] VGND VGND VPWR VPWR net1273 sky130_fd_sc_hd__dlygate4sd3_1
Xhold1072 u_sensor_interface.sensor_array\[2\]\[5\] VGND VGND VPWR VPWR net1284 sky130_fd_sc_hd__dlygate4sd3_1
Xhold1083 u_input_buffer.fifo_mem\[4\]\[12\] VGND VGND VPWR VPWR net1295 sky130_fd_sc_hd__dlygate4sd3_1
XFILLER_0_67_110 VGND VGND VPWR VPWR sky130_fd_sc_hd__fill_2
XFILLER_0_83_614 VGND VGND VPWR VPWR sky130_fd_sc_hd__fill_2
XFILLER_0_36_596 VGND VGND VPWR VPWR sky130_fd_sc_hd__decap_4
XFILLER_0_106_473 VGND VGND VPWR VPWR sky130_fd_sc_hd__decap_3
XFILLER_0_63_393 VGND VGND VPWR VPWR sky130_fd_sc_hd__fill_1
XFILLER_0_3_27 VPWR VGND VPWR VGND sky130_ef_sc_hd__decap_12
XFILLER_0_58_121 VGND VGND VPWR VPWR sky130_fd_sc_hd__fill_1
X_4961_ _1968_ VGND VGND VPWR VPWR _0370_ sky130_fd_sc_hd__clkbuf_1
X_7680_ _3810_ net145 _3782_ VGND VGND VPWR VPWR _3811_ sky130_fd_sc_hd__mux2_1
XFILLER_0_58_165 VGND VGND VPWR VPWR sky130_fd_sc_hd__fill_1
X_4892_ _1635_ _1678_ VGND VGND VPWR VPWR _1931_ sky130_fd_sc_hd__or2_1
X_6700_ u_input_buffer.rd_ptr\[0\] u_input_buffer.rd_ptr\[1\] VGND VGND VPWR VPWR
+ _2952_ sky130_fd_sc_hd__nand2_1
XFILLER_0_104_41 VPWR VGND VPWR VGND sky130_ef_sc_hd__decap_12
X_6631_ _1637_ _2888_ VGND VGND VPWR VPWR _1120_ sky130_fd_sc_hd__nor2_1
XFILLER_0_104_85 VPWR VGND VPWR VGND sky130_ef_sc_hd__decap_12
X_6562_ _2846_ VGND VGND VPWR VPWR _1093_ sky130_fd_sc_hd__clkbuf_1
X_8301_ clknet_leaf_40_clk _0390_ VGND VGND VPWR VPWR u_input_buffer.fifo_mem\[44\]\[3\]
+ sky130_fd_sc_hd__dfxtp_1
X_5513_ net458 _2246_ _2277_ VGND VGND VPWR VPWR _2279_ sky130_fd_sc_hd__mux2_1
X_6493_ net436 _1390_ _2807_ VGND VGND VPWR VPWR _2810_ sky130_fd_sc_hd__mux2_1
X_5444_ _2233_ VGND VGND VPWR VPWR _0588_ sky130_fd_sc_hd__clkbuf_1
X_8232_ clknet_leaf_100_clk _0321_ VGND VGND VPWR VPWR u_input_buffer.fifo_mem\[49\]\[14\]
+ sky130_fd_sc_hd__dfxtp_1
Xclkbuf_leaf_8_clk clknet_3_1__leaf_clk VGND VGND VPWR VPWR clknet_leaf_8_clk sky130_fd_sc_hd__clkbuf_16
XFILLER_0_2_685 VGND VGND VPWR VPWR sky130_fd_sc_hd__fill_1
X_8163_ clknet_leaf_8_clk _0252_ VGND VGND VPWR VPWR u_input_buffer.fifo_mem\[53\]\[9\]
+ sky130_fd_sc_hd__dfxtp_1
X_7114_ u_input_buffer.fifo_mem\[37\]\[8\] _2923_ _2926_ u_input_buffer.fifo_mem\[9\]\[8\]
+ VGND VGND VPWR VPWR _3358_ sky130_fd_sc_hd__a22o_1
X_5375_ net450 _2008_ _2187_ VGND VGND VPWR VPWR _2197_ sky130_fd_sc_hd__mux2_1
XFILLER_0_59_3 VGND VGND VPWR VPWR sky130_fd_sc_hd__fill_2
XFILLER_0_10_452 VGND VGND VPWR VPWR sky130_fd_sc_hd__decap_8
X_4326_ u_input_buffer.data_in\[1\] VGND VGND VPWR VPWR _1604_ sky130_fd_sc_hd__buf_4
XFILLER_0_10_485 VPWR VGND VPWR VGND sky130_ef_sc_hd__decap_12
X_8094_ clknet_leaf_4_clk _0183_ VGND VGND VPWR VPWR u_input_buffer.fifo_mem\[57\]\[4\]
+ sky130_fd_sc_hd__dfxtp_1
X_7045_ u_input_buffer.fifo_mem\[34\]\[6\] _2966_ _2969_ u_input_buffer.fifo_mem\[48\]\[6\]
+ _3290_ VGND VGND VPWR VPWR _3291_ sky130_fd_sc_hd__a221o_1
X_4257_ u_analytics_engine.threshold\[15\] _1534_ VGND VGND VPWR VPWR _1537_ sky130_fd_sc_hd__and2_1
X_4188_ u_sample_counter.sample_count\[9\] _1487_ VGND VGND VPWR VPWR _1491_ sky130_fd_sc_hd__or2_1
X_8996_ clknet_leaf_105_clk _1085_ VGND VGND VPWR VPWR u_input_buffer.fifo_mem\[1\]\[10\]
+ sky130_fd_sc_hd__dfxtp_1
X_7947_ clknet_leaf_60_clk _0037_ VGND VGND VPWR VPWR u_sensor_interface.sensor_array\[0\]\[3\]
+ sky130_fd_sc_hd__dfxtp_2
XTAP_1117 VGND VPWR sky130_fd_sc_hd__tapvpwrvgnd_1
XTAP_1128 VGND VPWR sky130_fd_sc_hd__tapvpwrvgnd_1
XTAP_1106 VGND VPWR sky130_fd_sc_hd__tapvpwrvgnd_1
XTAP_1139 VGND VPWR sky130_fd_sc_hd__tapvpwrvgnd_1
X_7878_ net36 u_register_bank.sensor_enable\[31\] _3904_ VGND VGND VPWR VPWR _3939_
+ sky130_fd_sc_hd__mux2_1
X_6829_ u_input_buffer.fifo_mem\[54\]\[0\] _3078_ _3080_ u_input_buffer.fifo_mem\[46\]\[0\]
+ VGND VGND VPWR VPWR _3081_ sky130_fd_sc_hd__a22o_1
XFILLER_0_64_157 VGND VGND VPWR VPWR sky130_fd_sc_hd__decap_6
XFILLER_0_80_639 VGND VGND VPWR VPWR sky130_fd_sc_hd__fill_2
XFILLER_0_33_544 VGND VGND VPWR VPWR sky130_fd_sc_hd__decap_4
XFILLER_0_103_410 VGND VGND VPWR VPWR sky130_fd_sc_hd__decap_3
XFILLER_0_103_465 VGND VGND VPWR VPWR sky130_fd_sc_hd__decap_8
Xhold180 u_input_buffer.fifo_mem\[58\]\[15\] VGND VGND VPWR VPWR net392 sky130_fd_sc_hd__dlygate4sd3_1
Xhold191 u_input_buffer.fifo_mem\[16\]\[14\] VGND VGND VPWR VPWR net403 sky130_fd_sc_hd__dlygate4sd3_1
XTAP_1640 VGND VPWR sky130_fd_sc_hd__tapvpwrvgnd_1
XFILLER_0_55_124 VGND VGND VPWR VPWR sky130_fd_sc_hd__fill_1
XFILLER_0_71_617 VGND VGND VPWR VPWR sky130_fd_sc_hd__decap_6
XFILLER_0_43_308 VGND VGND VPWR VPWR sky130_fd_sc_hd__decap_3
XFILLER_0_106_292 VGND VGND VPWR VPWR sky130_fd_sc_hd__fill_1
XFILLER_0_3_449 VPWR VGND VPWR VGND sky130_ef_sc_hd__decap_12
XFILLER_0_59_57 VGND VGND VPWR VPWR sky130_fd_sc_hd__decap_4
X_5160_ net875 _1998_ _2078_ VGND VGND VPWR VPWR _2083_ sky130_fd_sc_hd__mux2_1
X_5091_ _2046_ VGND VGND VPWR VPWR _0422_ sky130_fd_sc_hd__clkbuf_1
X_4111_ _1427_ _1430_ _0000_ VGND VGND VPWR VPWR _1431_ sky130_fd_sc_hd__mux2_1
X_4042_ net259 net50 _1367_ VGND VGND VPWR VPWR _1373_ sky130_fd_sc_hd__mux2_1
XFILLER_0_78_216 VGND VGND VPWR VPWR sky130_fd_sc_hd__fill_2
X_8850_ clknet_leaf_41_clk _0939_ VGND VGND VPWR VPWR u_input_buffer.fifo_mem\[10\]\[8\]
+ sky130_fd_sc_hd__dfxtp_1
X_8781_ clknet_leaf_26_clk _0870_ VGND VGND VPWR VPWR u_input_buffer.fifo_mem\[14\]\[3\]
+ sky130_fd_sc_hd__dfxtp_1
X_5993_ _1622_ net877 _2530_ VGND VGND VPWR VPWR _2542_ sky130_fd_sc_hd__mux2_1
X_7801_ _3898_ VGND VGND VPWR VPWR _1280_ sky130_fd_sc_hd__clkbuf_1
X_4944_ net402 _1718_ _1952_ VGND VGND VPWR VPWR _1960_ sky130_fd_sc_hd__mux2_1
XFILLER_0_59_452 VGND VGND VPWR VPWR sky130_fd_sc_hd__fill_1
X_7732_ _3781_ VGND VGND VPWR VPWR _3852_ sky130_fd_sc_hd__buf_4
X_7663_ _3797_ net141 _3782_ VGND VGND VPWR VPWR _3798_ sky130_fd_sc_hd__mux2_1
X_4875_ _1921_ VGND VGND VPWR VPWR _0331_ sky130_fd_sc_hd__clkbuf_1
XFILLER_0_74_488 VGND VGND VPWR VPWR sky130_fd_sc_hd__decap_4
XFILLER_0_61_116 VGND VGND VPWR VPWR sky130_fd_sc_hd__decap_3
X_7594_ _3752_ VGND VGND VPWR VPWR _1219_ sky130_fd_sc_hd__clkbuf_1
X_6614_ u_input_buffer.rd_ptr\[2\] VGND VGND VPWR VPWR _2876_ sky130_fd_sc_hd__buf_2
XFILLER_0_46_179 VGND VGND VPWR VPWR sky130_fd_sc_hd__fill_1
X_6545_ _1624_ net982 _2824_ VGND VGND VPWR VPWR _2837_ sky130_fd_sc_hd__mux2_1
XFILLER_0_27_393 VGND VGND VPWR VPWR sky130_fd_sc_hd__decap_6
XFILLER_0_42_352 VGND VGND VPWR VPWR sky130_fd_sc_hd__fill_1
XFILLER_0_42_374 VGND VGND VPWR VPWR sky130_fd_sc_hd__fill_1
X_6476_ _2800_ VGND VGND VPWR VPWR _1053_ sky130_fd_sc_hd__clkbuf_1
X_8215_ clknet_leaf_8_clk _0304_ VGND VGND VPWR VPWR u_input_buffer.fifo_mem\[50\]\[13\]
+ sky130_fd_sc_hd__dfxtp_1
X_9195_ clknet_leaf_50_clk _1283_ net199 VGND VGND VPWR VPWR net152 sky130_fd_sc_hd__dfrtp_1
XFILLER_0_112_284 VGND VGND VPWR VPWR sky130_fd_sc_hd__decap_8
XFILLER_0_112_262 VGND VGND VPWR VPWR sky130_fd_sc_hd__fill_2
X_5427_ net454 _1992_ _2223_ VGND VGND VPWR VPWR _2225_ sky130_fd_sc_hd__mux2_1
XFILLER_0_30_558 VGND VGND VPWR VPWR sky130_fd_sc_hd__decap_6
XFILLER_0_112_295 VGND VGND VPWR VPWR sky130_fd_sc_hd__fill_1
X_5358_ _2188_ VGND VGND VPWR VPWR _0547_ sky130_fd_sc_hd__clkbuf_1
X_8146_ clknet_leaf_41_clk _0235_ VGND VGND VPWR VPWR u_input_buffer.fifo_mem\[54\]\[8\]
+ sky130_fd_sc_hd__dfxtp_1
X_4309_ u_input_buffer.data_in\[0\] VGND VGND VPWR VPWR _1588_ sky130_fd_sc_hd__buf_4
X_8077_ clknet_leaf_66_clk _0166_ VGND VGND VPWR VPWR u_input_buffer.fifo_mem\[58\]\[3\]
+ sky130_fd_sc_hd__dfxtp_1
X_5289_ net380 _1988_ _2151_ VGND VGND VPWR VPWR _2152_ sky130_fd_sc_hd__mux2_1
X_7028_ u_input_buffer.fifo_mem\[54\]\[5\] _3078_ _3080_ u_input_buffer.fifo_mem\[46\]\[5\]
+ VGND VGND VPWR VPWR _3275_ sky130_fd_sc_hd__a22o_1
XFILLER_0_97_569 VGND VGND VPWR VPWR sky130_fd_sc_hd__fill_1
X_8979_ clknet_leaf_19_clk _1068_ VGND VGND VPWR VPWR u_input_buffer.fifo_mem\[2\]\[9\]
+ sky130_fd_sc_hd__dfxtp_1
XFILLER_0_37_113 VGND VGND VPWR VPWR sky130_fd_sc_hd__fill_2
XFILLER_0_53_639 VGND VGND VPWR VPWR sky130_fd_sc_hd__fill_1
XFILLER_0_52_149 VGND VGND VPWR VPWR sky130_fd_sc_hd__decap_3
XFILLER_0_21_503 VGND VGND VPWR VPWR sky130_fd_sc_hd__fill_1
XTAP_709 VGND VPWR sky130_fd_sc_hd__tapvpwrvgnd_1
XFILLER_0_61_36 VGND VGND VPWR VPWR sky130_fd_sc_hd__fill_1
XFILLER_0_56_400 VGND VGND VPWR VPWR sky130_fd_sc_hd__fill_2
XFILLER_0_29_625 VGND VGND VPWR VPWR sky130_fd_sc_hd__decap_8
XTAP_1492 VGND VPWR sky130_fd_sc_hd__tapvpwrvgnd_1
XTAP_1481 VGND VPWR sky130_fd_sc_hd__tapvpwrvgnd_1
XTAP_1470 VGND VPWR sky130_fd_sc_hd__tapvpwrvgnd_1
X_4660_ net362 _1716_ _1798_ VGND VGND VPWR VPWR _1805_ sky130_fd_sc_hd__mux2_1
XFILLER_0_56_477 VGND VGND VPWR VPWR sky130_fd_sc_hd__decap_4
XFILLER_0_9_15 VPWR VGND VPWR VGND sky130_ef_sc_hd__decap_12
XFILLER_0_71_447 VGND VGND VPWR VPWR sky130_fd_sc_hd__fill_1
XFILLER_0_43_127 VGND VGND VPWR VPWR sky130_fd_sc_hd__fill_2
X_6330_ _2723_ VGND VGND VPWR VPWR _0984_ sky130_fd_sc_hd__clkbuf_1
X_4591_ net681 _1720_ _1757_ VGND VGND VPWR VPWR _1766_ sky130_fd_sc_hd__mux2_1
XFILLER_0_24_352 VGND VGND VPWR VPWR sky130_fd_sc_hd__fill_1
Xhold916 u_input_buffer.fifo_mem\[9\]\[6\] VGND VGND VPWR VPWR net1128 sky130_fd_sc_hd__dlygate4sd3_1
Xhold927 u_input_buffer.fifo_mem\[33\]\[5\] VGND VGND VPWR VPWR net1139 sky130_fd_sc_hd__dlygate4sd3_1
XFILLER_0_3_268 VGND VGND VPWR VPWR sky130_fd_sc_hd__decap_4
Xhold905 u_input_buffer.fifo_mem\[25\]\[13\] VGND VGND VPWR VPWR net1117 sky130_fd_sc_hd__dlygate4sd3_1
Xhold938 u_input_buffer.fifo_mem\[20\]\[1\] VGND VGND VPWR VPWR net1150 sky130_fd_sc_hd__dlygate4sd3_1
X_6261_ _2686_ VGND VGND VPWR VPWR _0952_ sky130_fd_sc_hd__clkbuf_1
XFILLER_0_12_569 VPWR VGND VPWR VGND sky130_ef_sc_hd__decap_12
Xhold949 u_input_buffer.fifo_mem\[5\]\[9\] VGND VGND VPWR VPWR net1161 sky130_fd_sc_hd__dlygate4sd3_1
X_6192_ net951 _2508_ _2644_ VGND VGND VPWR VPWR _2650_ sky130_fd_sc_hd__mux2_1
X_8000_ clknet_leaf_63_clk _0089_ net195 VGND VGND VPWR VPWR u_sample_counter.sample_count\[23\]
+ sky130_fd_sc_hd__dfrtp_1
X_5212_ _2110_ VGND VGND VPWR VPWR _0479_ sky130_fd_sc_hd__clkbuf_1
X_5143_ _2073_ VGND VGND VPWR VPWR _0447_ sky130_fd_sc_hd__clkbuf_1
X_5074_ net1073 _2014_ _2023_ VGND VGND VPWR VPWR _2037_ sky130_fd_sc_hd__mux2_1
X_4025_ u_sensor_interface.sensor_array\[0\]\[5\] net101 _1356_ VGND VGND VPWR VPWR
+ _1364_ sky130_fd_sc_hd__mux2_1
X_8902_ clknet_leaf_85_clk _0991_ VGND VGND VPWR VPWR u_input_buffer.fifo_mem\[7\]\[12\]
+ sky130_fd_sc_hd__dfxtp_1
X_8833_ clknet_leaf_38_clk _0922_ VGND VGND VPWR VPWR u_input_buffer.fifo_mem\[11\]\[7\]
+ sky130_fd_sc_hd__dfxtp_1
XFILLER_0_35_92 VGND VGND VPWR VPWR sky130_fd_sc_hd__fill_2
X_8764_ clknet_leaf_34_clk _0853_ VGND VGND VPWR VPWR u_input_buffer.fifo_mem\[15\]\[2\]
+ sky130_fd_sc_hd__dfxtp_1
XFILLER_0_59_271 VGND VGND VPWR VPWR sky130_fd_sc_hd__fill_1
XFILLER_0_19_113 VGND VGND VPWR VPWR sky130_fd_sc_hd__decap_3
X_5976_ _2533_ VGND VGND VPWR VPWR _0820_ sky130_fd_sc_hd__clkbuf_1
X_8695_ clknet_leaf_90_clk _0784_ VGND VGND VPWR VPWR u_input_buffer.fifo_mem\[20\]\[13\]
+ sky130_fd_sc_hd__dfxtp_1
X_7715_ u_register_bank.window_cfg\[17\] _3812_ _3813_ u_register_bank.threshold_cfg\[17\]
+ _3837_ VGND VGND VPWR VPWR _3838_ sky130_fd_sc_hd__a221o_1
X_4927_ _1950_ VGND VGND VPWR VPWR _0354_ sky130_fd_sc_hd__clkbuf_1
XFILLER_0_47_444 VGND VGND VPWR VPWR sky130_fd_sc_hd__decap_4
X_4858_ net590 _1700_ _1912_ VGND VGND VPWR VPWR _1913_ sky130_fd_sc_hd__mux2_1
X_7646_ u_register_bank.window_cfg\[1\] _3772_ _3773_ u_analytics_engine.threshold\[1\]
+ _3784_ VGND VGND VPWR VPWR _3785_ sky130_fd_sc_hd__a221o_1
XFILLER_0_7_541 VPWR VGND VPWR VGND sky130_ef_sc_hd__decap_12
XFILLER_0_35_617 VGND VGND VPWR VPWR sky130_fd_sc_hd__fill_1
XFILLER_0_15_330 VGND VGND VPWR VPWR sky130_fd_sc_hd__decap_6
XFILLER_0_34_127 VGND VGND VPWR VPWR sky130_fd_sc_hd__fill_2
X_7577_ _3743_ VGND VGND VPWR VPWR _1211_ sky130_fd_sc_hd__clkbuf_1
X_4789_ _1875_ VGND VGND VPWR VPWR _0291_ sky130_fd_sc_hd__clkbuf_1
X_6528_ _2828_ VGND VGND VPWR VPWR _1077_ sky130_fd_sc_hd__clkbuf_1
X_6459_ net281 _1390_ _2789_ VGND VGND VPWR VPWR _2792_ sky130_fd_sc_hd__mux2_1
X_9178_ net177 _1266_ VGND VGND VPWR VPWR net134 sky130_fd_sc_hd__dfxtp_2
XFILLER_0_30_399 VGND VGND VPWR VPWR sky130_fd_sc_hd__decap_3
X_8129_ clknet_leaf_34_clk _0218_ VGND VGND VPWR VPWR u_input_buffer.fifo_mem\[55\]\[7\]
+ sky130_fd_sc_hd__dfxtp_1
XFILLER_0_38_433 VGND VGND VPWR VPWR sky130_fd_sc_hd__fill_1
XFILLER_0_38_466 VGND VGND VPWR VPWR sky130_fd_sc_hd__fill_1
XFILLER_0_108_354 VGND VGND VPWR VPWR sky130_fd_sc_hd__fill_2
XFILLER_0_19_680 VGND VGND VPWR VPWR sky130_fd_sc_hd__fill_2
Xwire165 _1528_ VGND VGND VPWR VPWR net165 sky130_fd_sc_hd__buf_1
XFILLER_0_104_571 VGND VGND VPWR VPWR sky130_fd_sc_hd__fill_2
XFILLER_0_0_205 VGND VGND VPWR VPWR sky130_fd_sc_hd__decap_4
XTAP_506 VGND VPWR sky130_fd_sc_hd__tapvpwrvgnd_1
XTAP_517 VGND VPWR sky130_fd_sc_hd__tapvpwrvgnd_1
XTAP_528 VGND VPWR sky130_fd_sc_hd__tapvpwrvgnd_1
XTAP_539 VGND VPWR sky130_fd_sc_hd__tapvpwrvgnd_1
X_5830_ _2448_ VGND VGND VPWR VPWR _0759_ sky130_fd_sc_hd__clkbuf_1
X_5761_ net511 _2252_ _2407_ VGND VGND VPWR VPWR _2412_ sky130_fd_sc_hd__mux2_1
XFILLER_0_8_316 VGND VGND VPWR VPWR sky130_fd_sc_hd__fill_2
X_7500_ _3702_ VGND VGND VPWR VPWR _1175_ sky130_fd_sc_hd__clkbuf_1
X_4712_ _1832_ VGND VGND VPWR VPWR _0257_ sky130_fd_sc_hd__clkbuf_1
X_8480_ clknet_leaf_7_clk _0569_ VGND VGND VPWR VPWR u_input_buffer.fifo_mem\[33\]\[6\]
+ sky130_fd_sc_hd__dfxtp_1
XFILLER_0_112_41 VPWR VGND VPWR VGND sky130_ef_sc_hd__decap_12
X_7431_ net265 net92 _3662_ VGND VGND VPWR VPWR _3664_ sky130_fd_sc_hd__mux2_1
XFILLER_0_16_127 VGND VGND VPWR VPWR sky130_fd_sc_hd__decap_3
XFILLER_0_29_499 VGND VGND VPWR VPWR sky130_fd_sc_hd__fill_2
X_5692_ _1610_ net1155 _2370_ VGND VGND VPWR VPWR _2375_ sky130_fd_sc_hd__mux2_1
XFILLER_0_112_85 VPWR VGND VPWR VGND sky130_ef_sc_hd__decap_12
XFILLER_0_4_533 VPWR VGND VPWR VGND sky130_ef_sc_hd__decap_12
X_4643_ _1794_ VGND VGND VPWR VPWR _0226_ sky130_fd_sc_hd__clkbuf_1
XFILLER_0_97_21 VPWR VGND VPWR VGND sky130_ef_sc_hd__decap_12
XFILLER_0_21_83 VGND VGND VPWR VPWR sky130_fd_sc_hd__fill_1
X_7362_ _3593_ _3595_ _3597_ _3599_ VGND VGND VPWR VPWR _3600_ sky130_fd_sc_hd__or4_1
Xhold702 u_input_buffer.fifo_mem\[18\]\[11\] VGND VGND VPWR VPWR net914 sky130_fd_sc_hd__dlygate4sd3_1
X_4574_ _1756_ VGND VGND VPWR VPWR _1757_ sky130_fd_sc_hd__buf_4
Xhold724 u_input_buffer.fifo_mem\[42\]\[7\] VGND VGND VPWR VPWR net936 sky130_fd_sc_hd__dlygate4sd3_1
Xhold713 u_input_buffer.fifo_mem\[56\]\[4\] VGND VGND VPWR VPWR net925 sky130_fd_sc_hd__dlygate4sd3_1
Xhold735 u_input_buffer.fifo_mem\[60\]\[1\] VGND VGND VPWR VPWR net947 sky130_fd_sc_hd__dlygate4sd3_1
Xhold746 u_input_buffer.fifo_mem\[60\]\[13\] VGND VGND VPWR VPWR net958 sky130_fd_sc_hd__dlygate4sd3_1
X_9101_ net168 _1189_ net201 VGND VGND VPWR VPWR u_register_bank.window_cfg\[15\]
+ sky130_fd_sc_hd__dfrtp_1
X_7293_ u_input_buffer.fifo_mem\[6\]\[12\] _3034_ _3036_ u_input_buffer.fifo_mem\[28\]\[12\]
+ _3532_ VGND VGND VPWR VPWR _3533_ sky130_fd_sc_hd__a221o_1
X_6313_ _2713_ VGND VGND VPWR VPWR _0977_ sky130_fd_sc_hd__clkbuf_1
Xhold779 u_input_buffer.fifo_mem\[55\]\[2\] VGND VGND VPWR VPWR net991 sky130_fd_sc_hd__dlygate4sd3_1
Xhold768 u_input_buffer.fifo_mem\[33\]\[11\] VGND VGND VPWR VPWR net980 sky130_fd_sc_hd__dlygate4sd3_1
XFILLER_0_12_388 VGND VGND VPWR VPWR sky130_fd_sc_hd__fill_2
Xhold757 u_input_buffer.fifo_mem\[5\]\[15\] VGND VGND VPWR VPWR net969 sky130_fd_sc_hd__dlygate4sd3_1
X_9032_ clknet_leaf_101_clk _1121_ net184 VGND VGND VPWR VPWR u_input_buffer.wr_ptr\[1\]
+ sky130_fd_sc_hd__dfrtp_2
X_6244_ net582 _2526_ _2661_ VGND VGND VPWR VPWR _2677_ sky130_fd_sc_hd__mux2_1
XFILLER_0_12_399 VGND VGND VPWR VPWR sky130_fd_sc_hd__fill_1
X_6175_ net632 _2526_ _2624_ VGND VGND VPWR VPWR _2640_ sky130_fd_sc_hd__mux2_1
X_5126_ _1403_ net1052 _2060_ VGND VGND VPWR VPWR _2065_ sky130_fd_sc_hd__mux2_1
X_5057_ _2028_ VGND VGND VPWR VPWR _0406_ sky130_fd_sc_hd__clkbuf_1
X_4008_ u_sensor_interface.sensor_array\[1\]\[13\] net67 _1345_ VGND VGND VPWR VPWR
+ _1355_ sky130_fd_sc_hd__mux2_1
X_8816_ clknet_leaf_30_clk _0905_ VGND VGND VPWR VPWR u_input_buffer.fifo_mem\[12\]\[6\]
+ sky130_fd_sc_hd__dfxtp_1
XFILLER_0_109_129 VGND VGND VPWR VPWR sky130_fd_sc_hd__fill_2
XFILLER_0_109_107 VGND VGND VPWR VPWR sky130_fd_sc_hd__decap_4
X_8747_ clknet_leaf_24_clk _0836_ VGND VGND VPWR VPWR u_input_buffer.fifo_mem\[16\]\[1\]
+ sky130_fd_sc_hd__dfxtp_1
X_5959_ _1450_ VGND VGND VPWR VPWR _2522_ sky130_fd_sc_hd__buf_4
XFILLER_0_75_561 VGND VGND VPWR VPWR sky130_fd_sc_hd__fill_1
XFILLER_0_90_520 VGND VGND VPWR VPWR sky130_fd_sc_hd__fill_1
XFILLER_0_62_233 VGND VGND VPWR VPWR sky130_fd_sc_hd__decap_3
X_8678_ clknet_leaf_105_clk _0767_ VGND VGND VPWR VPWR u_input_buffer.fifo_mem\[21\]\[12\]
+ sky130_fd_sc_hd__dfxtp_1
XFILLER_0_35_447 VGND VGND VPWR VPWR sky130_fd_sc_hd__fill_1
XFILLER_0_47_296 VGND VGND VPWR VPWR sky130_fd_sc_hd__decap_4
XFILLER_0_7_393 VGND VGND VPWR VPWR sky130_fd_sc_hd__fill_2
XFILLER_0_23_609 VGND VGND VPWR VPWR sky130_fd_sc_hd__decap_6
XFILLER_0_35_458 VGND VGND VPWR VPWR sky130_fd_sc_hd__decap_6
X_7629_ _3770_ VGND VGND VPWR VPWR _1236_ sky130_fd_sc_hd__clkbuf_1
Xhold40 u_sample_counter.sample_count\[26\] VGND VGND VPWR VPWR net252 sky130_fd_sc_hd__dlygate4sd3_1
Xhold51 u_input_buffer.fifo_mem\[0\]\[6\] VGND VGND VPWR VPWR net263 sky130_fd_sc_hd__dlygate4sd3_1
Xhold62 u_sensor_interface.sensor_array\[0\]\[12\] VGND VGND VPWR VPWR net274 sky130_fd_sc_hd__dlygate4sd3_1
Xhold73 u_input_buffer.fifo_mem\[6\]\[13\] VGND VGND VPWR VPWR net285 sky130_fd_sc_hd__dlygate4sd3_1
Xhold95 u_input_buffer.fifo_mem\[34\]\[1\] VGND VGND VPWR VPWR net307 sky130_fd_sc_hd__dlygate4sd3_1
Xhold84 u_input_buffer.fifo_mem\[50\]\[10\] VGND VGND VPWR VPWR net296 sky130_fd_sc_hd__dlygate4sd3_1
XFILLER_0_85_303 VGND VGND VPWR VPWR sky130_fd_sc_hd__fill_1
XFILLER_0_93_391 VGND VGND VPWR VPWR sky130_fd_sc_hd__fill_1
XFILLER_0_108_195 VGND VGND VPWR VPWR sky130_fd_sc_hd__fill_1
XFILLER_0_13_108 VGND VGND VPWR VPWR sky130_fd_sc_hd__decap_4
XANTENNA_4 _3107_ VGND VGND VPWR VPWR sky130_fd_sc_hd__diode_2
XFILLER_0_1_503 VGND VGND VPWR VPWR sky130_fd_sc_hd__fill_1
XFILLER_0_6_27 VGND VGND VPWR VPWR sky130_fd_sc_hd__fill_1
XFILLER_0_21_163 VGND VGND VPWR VPWR sky130_fd_sc_hd__decap_4
XFILLER_0_67_57 VGND VGND VPWR VPWR sky130_fd_sc_hd__decap_4
X_4290_ u_analytics_engine.threshold\[3\] VGND VGND VPWR VPWR _1570_ sky130_fd_sc_hd__inv_2
XTAP_314 VGND VPWR sky130_fd_sc_hd__tapvpwrvgnd_1
XTAP_303 VGND VPWR sky130_fd_sc_hd__tapvpwrvgnd_1
XTAP_358 VGND VPWR sky130_fd_sc_hd__tapvpwrvgnd_1
XTAP_347 VGND VPWR sky130_fd_sc_hd__tapvpwrvgnd_1
XTAP_325 VGND VPWR sky130_fd_sc_hd__tapvpwrvgnd_1
XTAP_336 VGND VPWR sky130_fd_sc_hd__tapvpwrvgnd_1
XTAP_369 VGND VPWR sky130_fd_sc_hd__tapvpwrvgnd_1
X_7980_ clknet_leaf_57_clk _0069_ net198 VGND VGND VPWR VPWR u_sample_counter.sample_count\[3\]
+ sky130_fd_sc_hd__dfrtp_1
XFILLER_0_88_152 VGND VGND VPWR VPWR sky130_fd_sc_hd__fill_1
XFILLER_0_88_141 VGND VGND VPWR VPWR sky130_fd_sc_hd__fill_2
X_6931_ u_input_buffer.fifo_mem\[50\]\[3\] _2995_ _2997_ u_input_buffer.fifo_mem\[4\]\[3\]
+ VGND VGND VPWR VPWR _3180_ sky130_fd_sc_hd__a22o_1
X_6862_ u_input_buffer.fifo_mem\[7\]\[1\] _3025_ _3027_ u_input_buffer.fifo_mem\[22\]\[1\]
+ _3112_ VGND VGND VPWR VPWR _3113_ sky130_fd_sc_hd__a221o_1
XFILLER_0_16_83 VGND VGND VPWR VPWR sky130_fd_sc_hd__fill_1
XFILLER_0_76_358 VGND VGND VPWR VPWR sky130_fd_sc_hd__decap_6
X_8601_ clknet_leaf_87_clk _0690_ VGND VGND VPWR VPWR u_input_buffer.fifo_mem\[26\]\[15\]
+ sky130_fd_sc_hd__dfxtp_1
X_5813_ net1180 _2270_ _2424_ VGND VGND VPWR VPWR _2439_ sky130_fd_sc_hd__mux2_1
X_8532_ clknet_leaf_86_clk _0621_ VGND VGND VPWR VPWR u_input_buffer.fifo_mem\[30\]\[10\]
+ sky130_fd_sc_hd__dfxtp_1
X_6793_ _2910_ _3023_ VGND VGND VPWR VPWR _3045_ sky130_fd_sc_hd__and2_4
XFILLER_0_72_531 VGND VGND VPWR VPWR sky130_fd_sc_hd__fill_1
XFILLER_0_57_594 VGND VGND VPWR VPWR sky130_fd_sc_hd__fill_2
XFILLER_0_17_436 VGND VGND VPWR VPWR sky130_fd_sc_hd__fill_1
XFILLER_0_32_82 VGND VGND VPWR VPWR sky130_fd_sc_hd__fill_2
X_5744_ net552 _2270_ _2387_ VGND VGND VPWR VPWR _2402_ sky130_fd_sc_hd__mux2_1
X_8463_ clknet_leaf_30_clk _0552_ VGND VGND VPWR VPWR u_input_buffer.fifo_mem\[34\]\[5\]
+ sky130_fd_sc_hd__dfxtp_1
X_5675_ _2365_ VGND VGND VPWR VPWR _0687_ sky130_fd_sc_hd__clkbuf_1
X_4626_ net939 _1718_ _1778_ VGND VGND VPWR VPWR _1786_ sky130_fd_sc_hd__mux2_1
X_8394_ clknet_leaf_46_clk _0483_ VGND VGND VPWR VPWR u_input_buffer.fifo_mem\[38\]\[0\]
+ sky130_fd_sc_hd__dfxtp_1
XFILLER_0_89_3 VPWR VGND VPWR VGND sky130_ef_sc_hd__decap_12
XFILLER_0_4_341 VGND VGND VPWR VPWR sky130_fd_sc_hd__fill_1
X_7414_ u_input_buffer.fifo_mem\[15\]\[15\] _3059_ _3061_ u_input_buffer.fifo_mem\[43\]\[15\]
+ VGND VGND VPWR VPWR _3651_ sky130_fd_sc_hd__a22o_1
XFILLER_0_114_165 VPWR VGND VPWR VGND sky130_ef_sc_hd__decap_12
XFILLER_0_4_363 VGND VGND VPWR VPWR sky130_fd_sc_hd__fill_1
Xhold510 u_input_buffer.fifo_mem\[53\]\[2\] VGND VGND VPWR VPWR net722 sky130_fd_sc_hd__dlygate4sd3_1
X_7345_ net1132 _2892_ _3582_ _3583_ VGND VGND VPWR VPWR _1139_ sky130_fd_sc_hd__a22o_1
Xhold554 u_input_buffer.fifo_mem\[44\]\[0\] VGND VGND VPWR VPWR net766 sky130_fd_sc_hd__dlygate4sd3_1
Xhold543 u_input_buffer.fifo_mem\[32\]\[9\] VGND VGND VPWR VPWR net755 sky130_fd_sc_hd__dlygate4sd3_1
Xhold521 u_input_buffer.fifo_mem\[33\]\[9\] VGND VGND VPWR VPWR net733 sky130_fd_sc_hd__dlygate4sd3_1
Xhold532 u_input_buffer.fifo_mem\[62\]\[11\] VGND VGND VPWR VPWR net744 sky130_fd_sc_hd__dlygate4sd3_1
X_4557_ _1747_ VGND VGND VPWR VPWR _0187_ sky130_fd_sc_hd__clkbuf_1
Xhold565 u_input_buffer.fifo_mem\[16\]\[2\] VGND VGND VPWR VPWR net777 sky130_fd_sc_hd__dlygate4sd3_1
Xhold587 u_input_buffer.fifo_mem\[9\]\[0\] VGND VGND VPWR VPWR net799 sky130_fd_sc_hd__dlygate4sd3_1
Xhold576 u_input_buffer.fifo_mem\[55\]\[9\] VGND VGND VPWR VPWR net788 sky130_fd_sc_hd__dlygate4sd3_1
X_4488_ _1592_ _1702_ VGND VGND VPWR VPWR _1703_ sky130_fd_sc_hd__nor2_4
X_7276_ u_input_buffer.fifo_mem\[14\]\[12\] _2957_ _2960_ u_input_buffer.fifo_mem\[42\]\[12\]
+ VGND VGND VPWR VPWR _3516_ sky130_fd_sc_hd__a22o_1
X_6227_ _2668_ VGND VGND VPWR VPWR _0936_ sky130_fd_sc_hd__clkbuf_1
Xhold598 u_input_buffer.fifo_mem\[20\]\[6\] VGND VGND VPWR VPWR net810 sky130_fd_sc_hd__dlygate4sd3_1
XFILLER_0_0_580 VGND VGND VPWR VPWR sky130_fd_sc_hd__fill_2
X_9015_ clknet_leaf_71_clk _1104_ VGND VGND VPWR VPWR u_input_buffer.fifo_mem\[0\]\[13\]
+ sky130_fd_sc_hd__dfxtp_1
X_6158_ _2631_ VGND VGND VPWR VPWR _0904_ sky130_fd_sc_hd__clkbuf_1
XTAP_870 VGND VPWR sky130_fd_sc_hd__tapvpwrvgnd_1
X_5109_ _2055_ VGND VGND VPWR VPWR _0431_ sky130_fd_sc_hd__clkbuf_1
XTAP_881 VGND VPWR sky130_fd_sc_hd__tapvpwrvgnd_1
XTAP_892 VGND VPWR sky130_fd_sc_hd__tapvpwrvgnd_1
X_6089_ net629 _2510_ _2587_ VGND VGND VPWR VPWR _2594_ sky130_fd_sc_hd__mux2_1
XFILLER_0_39_561 VGND VGND VPWR VPWR sky130_fd_sc_hd__fill_1
XFILLER_0_54_520 VGND VGND VPWR VPWR sky130_fd_sc_hd__fill_2
XFILLER_0_54_531 VGND VGND VPWR VPWR sky130_fd_sc_hd__fill_1
XPHY_191 VGND VGND VPWR VPWR sky130_fd_sc_hd__decap_3
XPHY_180 VGND VGND VPWR VPWR sky130_fd_sc_hd__decap_3
XFILLER_0_14_417 VGND VGND VPWR VPWR sky130_fd_sc_hd__decap_3
X_5460_ _1932_ _2242_ VGND VGND VPWR VPWR _2243_ sky130_fd_sc_hd__nor2_4
X_4411_ u_input_buffer.wr_ptr\[0\] u_input_buffer.wr_ptr\[1\] _1594_ u_analytics_engine.data_valid
+ VGND VGND VPWR VPWR _1658_ sky130_fd_sc_hd__and4bb_4
XFILLER_0_111_113 VGND VGND VPWR VPWR sky130_fd_sc_hd__decap_6
XFILLER_0_10_601 VPWR VGND VPWR VGND sky130_ef_sc_hd__decap_12
XFILLER_0_1_311 VGND VGND VPWR VPWR sky130_fd_sc_hd__decap_8
X_5391_ _1377_ net847 _2205_ VGND VGND VPWR VPWR _2206_ sky130_fd_sc_hd__mux2_1
XFILLER_0_112_669 VPWR VGND VPWR VGND sky130_ef_sc_hd__decap_12
X_4342_ net956 _1614_ _1602_ VGND VGND VPWR VPWR _1615_ sky130_fd_sc_hd__mux2_1
X_7130_ u_input_buffer.fifo_mem\[47\]\[8\] _2879_ _3007_ _3009_ u_input_buffer.fifo_mem\[24\]\[8\]
+ VGND VGND VPWR VPWR _3374_ sky130_fd_sc_hd__a32o_1
XFILLER_0_10_645 VPWR VGND VPWR VGND sky130_ef_sc_hd__decap_12
X_7061_ u_input_buffer.fifo_mem\[39\]\[6\] _3050_ _3052_ u_input_buffer.fifo_mem\[40\]\[6\]
+ VGND VGND VPWR VPWR _3307_ sky130_fd_sc_hd__a22o_1
X_4273_ _1541_ _1551_ _1552_ VGND VGND VPWR VPWR _1553_ sky130_fd_sc_hd__a21oi_1
X_6012_ _2552_ VGND VGND VPWR VPWR _0837_ sky130_fd_sc_hd__clkbuf_1
.ends
